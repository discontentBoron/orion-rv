* Functional test stimulus file for 5ns period

* SS process corner
.include "/home/discontentBoron/OpenRAM/technology/freepdk45/models/tran_models/models_ss/PMOS_VTG.inc"
.include "/home/discontentBoron/OpenRAM/technology/freepdk45/models/tran_models/models_ss/NMOS_VTG.inc"
.include "/tmp/openram_discontentBoron_4757_temp/sram.sp"

* Global Power Supplies
Vvdd vdd 0 0.95

*Nodes gnd and 0 are the same global ground node in ngspice/hspice/xa. Otherwise, this source may be needed.
Vgnd gnd 0 0.0

* Instantiation of the SRAM
Xdcache_data_sram_1rw0r0w_32_512_freepdk45 din0_0 din0_1 din0_2 din0_3 din0_4 din0_5 din0_6 din0_7 din0_8 din0_9 din0_10 din0_11 din0_12 din0_13 din0_14 din0_15 din0_16 din0_17 din0_18 din0_19 din0_20 din0_21 din0_22 din0_23 din0_24 din0_25 din0_26 din0_27 din0_28 din0_29 din0_30 din0_31 a0_0 a0_1 a0_2 a0_3 a0_4 a0_5 a0_6 a0_7 a0_8 CSB0 WEB0 clk0 WMASK0_0 WMASK0_1 WMASK0_2 WMASK0_3 dout0_0 dout0_1 dout0_2 dout0_3 dout0_4 dout0_5 dout0_6 dout0_7 dout0_8 dout0_9 dout0_10 dout0_11 dout0_12 dout0_13 dout0_14 dout0_15 dout0_16 dout0_17 dout0_18 dout0_19 dout0_20 dout0_21 dout0_22 dout0_23 dout0_24 dout0_25 dout0_26 dout0_27 dout0_28 dout0_29 dout0_30 dout0_31 vdd gnd dcache_data_sram_1rw0r0w_32_512_freepdk45

* SRAM output loads
CD00 dout0_0  0 0.8364f
CD01 dout0_1  0 0.8364f
CD02 dout0_2  0 0.8364f
CD03 dout0_3  0 0.8364f
CD04 dout0_4  0 0.8364f
CD05 dout0_5  0 0.8364f
CD06 dout0_6  0 0.8364f
CD07 dout0_7  0 0.8364f
CD08 dout0_8  0 0.8364f
CD09 dout0_9  0 0.8364f
CD010 dout0_10  0 0.8364f
CD011 dout0_11  0 0.8364f
CD012 dout0_12  0 0.8364f
CD013 dout0_13  0 0.8364f
CD014 dout0_14  0 0.8364f
CD015 dout0_15  0 0.8364f
CD016 dout0_16  0 0.8364f
CD017 dout0_17  0 0.8364f
CD018 dout0_18  0 0.8364f
CD019 dout0_19  0 0.8364f
CD020 dout0_20  0 0.8364f
CD021 dout0_21  0 0.8364f
CD022 dout0_22  0 0.8364f
CD023 dout0_23  0 0.8364f
CD024 dout0_24  0 0.8364f
CD025 dout0_25  0 0.8364f
CD026 dout0_26  0 0.8364f
CD027 dout0_27  0 0.8364f
CD028 dout0_28  0 0.8364f
CD029 dout0_29  0 0.8364f
CD030 dout0_30  0 0.8364f
CD031 dout0_31  0 0.8364f

* Important signals for debug
* bl:	xsram:xbank0:bl_0_0
* br:	xsram:xbank0:br_0_0
* s_en:	xsram:s_en
* q:	xsram:xbank0:xbitcell_array:xbitcell_array:xbit_r0_c0:Q
* qbar:	xsram:xbank0:xbitcell_array:xbitcell_array:xbit_r0_c0:Q_bar

* Sequence of operations
*	Idle during cycle 0 (0ns - 5ns)
*	Writing 01000100000011011010101100111001  to  address 111111101 (from port 0) during cycle 1 (5ns - 10ns)
*	Writing 01101000101101010101111100110000  to  address 000000000 (from port 0) during cycle 2 (10ns - 15ns)
*	Writing 01101000010011001111101110011010  to  address 111111110 (from port 0) during cycle 3 (15ns - 20ns)
*	Reading 01101000101101010101111100110000 from address 000000000 (from port 0) during cycle 4 (20ns - 25ns)
*	Writing 11111100110011101101111110001001  to  address 000000010 (from port 0) during cycle 5 (25ns - 30ns)
*	Writing (partial) 10111111011111101001111100101011  to  address 000000010 with mask bit 0001 (from port 0) during cycle 6 (30ns - 35ns)
*	Writing 11101101000001110111011001000100  to  address 000000011 (from port 0) during cycle 7 (35ns - 40ns)
*	Writing 10111000111010110110111001110100  to  address 000000001 (from port 0) during cycle 8 (40ns - 45ns)
*	Writing 01101010011101111001001111000110  to  address 000000001 (from port 0) during cycle 9 (45ns - 50ns)
*	Writing (partial) 01101011110110010101000010000001  to  address 111111110 with mask bit 0010 (from port 0) during cycle 10 (50ns - 55ns)
*	Reading 11111100110011101101111100101011 from address 000000010 (from port 0) during cycle 11 (55ns - 60ns)
*	Writing (partial) 10110010101000001100001111010101  to  address 111111110 with mask bit 1010 (from port 0) during cycle 12 (60ns - 65ns)
*	Writing 01100111100000010110110101010100  to  address 000000001 (from port 0) during cycle 13 (65ns - 70ns)
*	Reading 01100111100000010110110101010100 from address 000000001 (from port 0) during cycle 14 (70ns - 75ns)
*	Writing 00111100100101101110110001000010  to  address 111111110 (from port 0) during cycle 15 (75ns - 80ns)
*	Writing 00111111101011111011111001011000  to  address 111111011 (from port 0) during cycle 16 (80ns - 85ns)
*	Writing 01010001110100100101010110001110  to  address 000000011 (from port 0) during cycle 17 (85ns - 90ns)
*	Reading 11111100110011101101111100101011 from address 000000010 (from port 0) during cycle 18 (90ns - 95ns)
*	Writing (partial) 00101000110101011011010100000100  to  address 111111110 with mask bit 0110 (from port 0) during cycle 19 (95ns - 100ns)
*	Writing 10110101001101000011111000110111  to  address 000000001 (from port 0) during cycle 21 (105ns - 110ns)
*	Writing 11110001101101001111101011000101  to  address 000000001 (from port 0) during cycle 23 (115ns - 120ns)
*	Reading 00111100110101011011010101000010 from address 111111110 (from port 0) during cycle 24 (120ns - 125ns)
*	Writing 11111001001011110010001000101000  to  address 111111101 (from port 0) during cycle 25 (125ns - 130ns)
*	Writing 00111101100100001111000001010011  to  address 111111011 (from port 0) during cycle 26 (130ns - 135ns)
*	Reading 01010001110100100101010110001110 from address 000000011 (from port 0) during cycle 28 (140ns - 145ns)
*	Reading 00111101100100001111000001010011 from address 111111011 (from port 0) during cycle 29 (145ns - 150ns)
*	Reading 00111100110101011011010101000010 from address 111111110 (from port 0) during cycle 31 (155ns - 160ns)
*	Reading 01101000101101010101111100110000 from address 000000000 (from port 0) during cycle 32 (160ns - 165ns)
*	Writing 10111000100111011001100100001101  to  address 000000010 (from port 0) during cycle 33 (165ns - 170ns)
*	Reading 01101000101101010101111100110000 from address 000000000 (from port 0) during cycle 34 (170ns - 175ns)
*	Reading 00111100110101011011010101000010 from address 111111110 (from port 0) during cycle 35 (175ns - 180ns)
*	Writing 10110010111010100001011100000111  to  address 111111011 (from port 0) during cycle 36 (180ns - 185ns)
*	Writing 10100001100000011010010010011100  to  address 111111011 (from port 0) during cycle 37 (185ns - 190ns)
*	Reading 01010001110100100101010110001110 from address 000000011 (from port 0) during cycle 39 (195ns - 200ns)
*	Writing 00101010010011110011011000111010  to  address 111111100 (from port 0) during cycle 40 (200ns - 205ns)
*	Reading 11111001001011110010001000101000 from address 111111101 (from port 0) during cycle 44 (220ns - 225ns)
*	Writing 11100010111011001010100100011100  to  address 111111101 (from port 0) during cycle 46 (230ns - 235ns)
*	Reading 01010001110100100101010110001110 from address 000000011 (from port 0) during cycle 47 (235ns - 240ns)
*	Writing (partial) 10011011110001000101100010010100  to  address 000000011 with mask bit 1011 (from port 0) during cycle 49 (245ns - 250ns)
*	Reading 10111000100111011001100100001101 from address 000000010 (from port 0) during cycle 51 (255ns - 260ns)
*	Reading 00111100110101011011010101000010 from address 111111110 (from port 0) during cycle 52 (260ns - 265ns)
*	Writing (partial) 10000111100001000100001110100111  to  address 111111110 with mask bit 1101 (from port 0) during cycle 53 (265ns - 270ns)
*	Writing 00101101111101000000101010111100  to  address 000000010 (from port 0) during cycle 54 (270ns - 275ns)
*	Reading 10011011110100100101100010010100 from address 000000011 (from port 0) during cycle 56 (280ns - 285ns)
*	Writing 10010001010101110101011110001101  to  address 000000001 (from port 0) during cycle 57 (285ns - 290ns)
*	Reading 10100001100000011010010010011100 from address 111111011 (from port 0) during cycle 59 (295ns - 300ns)
*	Writing 10101110110101011111011101011110  to  address 111111100 (from port 0) during cycle 60 (300ns - 305ns)
*	Reading 10101110110101011111011101011110 from address 111111100 (from port 0) during cycle 62 (310ns - 315ns)
*	Writing (partial) 01100000110100000000100001110001  to  address 000000010 with mask bit 0001 (from port 0) during cycle 63 (315ns - 320ns)
*	Reading 11100010111011001010100100011100 from address 111111101 (from port 0) during cycle 66 (330ns - 335ns)
*	Reading 00101101111101000000101001110001 from address 000000010 (from port 0) during cycle 67 (335ns - 340ns)
*	Reading 01101000101101010101111100110000 from address 000000000 (from port 0) during cycle 68 (340ns - 345ns)
*	Writing (partial) 01111111011011000001110101101000  to  address 111111100 with mask bit 1000 (from port 0) during cycle 69 (345ns - 350ns)
*	Reading 11100010111011001010100100011100 from address 111111101 (from port 0) during cycle 70 (350ns - 355ns)
*	Reading 10011011110100100101100010010100 from address 000000011 (from port 0) during cycle 71 (355ns - 360ns)
*	Writing 10111010011101111100001110110100  to  address 111111110 (from port 0) during cycle 72 (360ns - 365ns)
*	Writing (partial) 00100011111101010001110101000010  to  address 000000011 with mask bit 0100 (from port 0) during cycle 73 (365ns - 370ns)
*	Reading 11100010111011001010100100011100 from address 111111101 (from port 0) during cycle 74 (370ns - 375ns)
*	Reading 01111111110101011111011101011110 from address 111111100 (from port 0) during cycle 75 (375ns - 380ns)
*	Reading 01101000101101010101111100110000 from address 000000000 (from port 0) during cycle 76 (380ns - 385ns)
*	Reading 00101101111101000000101001110001 from address 000000010 (from port 0) during cycle 77 (385ns - 390ns)
*	Writing 10110010110110110111100100101111  to  address 000000011 (from port 0) during cycle 78 (390ns - 395ns)
*	Reading 10100001100000011010010010011100 from address 111111011 (from port 0) during cycle 79 (395ns - 400ns)
*	Reading 10010001010101110101011110001101 from address 000000001 (from port 0) during cycle 80 (400ns - 405ns)
*	Reading 10010001010101110101011110001101 from address 000000001 (from port 0) during cycle 81 (405ns - 410ns)
*	Writing (partial) 00101011000011110011110101010001  to  address 111111101 with mask bit 1110 (from port 0) during cycle 82 (410ns - 415ns)
*	Reading 00101011000011110011110100011100 from address 111111101 (from port 0) during cycle 84 (420ns - 425ns)
*	Writing 11001011100110000101110111111110  to  address 000000001 (from port 0) during cycle 85 (425ns - 430ns)
*	Reading 00101101111101000000101001110001 from address 000000010 (from port 0) during cycle 86 (430ns - 435ns)
*	Writing (partial) 10100000101110011101100111110110  to  address 000000001 with mask bit 0110 (from port 0) during cycle 87 (435ns - 440ns)
*	Writing (partial) 01110011011000100000111100010011  to  address 000000001 with mask bit 1110 (from port 0) during cycle 88 (440ns - 445ns)
*	Writing (partial) 11100000010001010111010000011100  to  address 111111110 with mask bit 0011 (from port 0) during cycle 89 (445ns - 450ns)
*	Reading 00101011000011110011110100011100 from address 111111101 (from port 0) during cycle 91 (455ns - 460ns)
*	Writing 01001110001010101001100101010000  to  address 000000011 (from port 0) during cycle 92 (460ns - 465ns)
*	Writing (partial) 00111000110100100111001100010111  to  address 000000011 with mask bit 1110 (from port 0) during cycle 93 (465ns - 470ns)
*	Reading 10111010011101110111010000011100 from address 111111110 (from port 0) during cycle 94 (470ns - 475ns)
*	Writing (partial) 10100001010110101100011110111000  to  address 000000001 with mask bit 0101 (from port 0) during cycle 95 (475ns - 480ns)
*	Writing (partial) 00001010001000101101010111100100  to  address 111111100 with mask bit 1010 (from port 0) during cycle 96 (480ns - 485ns)
*	Writing (partial) 00111100110110111110100100110000  to  address 000000010 with mask bit 0011 (from port 0) during cycle 97 (485ns - 490ns)
*	Writing (partial) 00001111000001110101111010001010  to  address 000000010 with mask bit 1101 (from port 0) during cycle 98 (490ns - 495ns)
*	Reading 00101011000011110011110100011100 from address 111111101 (from port 0) during cycle 99 (495ns - 500ns)
*	Writing 11101110011100111001101111000100  to  address 111111110 (from port 0) during cycle 100 (500ns - 505ns)
*	Reading 01101000101101010101111100110000 from address 000000000 (from port 0) during cycle 101 (505ns - 510ns)
*	Reading 00111000110100100111001101010000 from address 000000011 (from port 0) during cycle 103 (515ns - 520ns)
*	Writing 00110011001011111100101001010111  to  address 111111011 (from port 0) during cycle 104 (520ns - 525ns)
*	Reading 11101110011100111001101111000100 from address 111111110 (from port 0) during cycle 105 (525ns - 530ns)
*	Writing (partial) 10001101111000111111101011111101  to  address 000000001 with mask bit 0111 (from port 0) during cycle 106 (530ns - 535ns)
*	Writing (partial) 01111010110100000000011010011000  to  address 000000010 with mask bit 0110 (from port 0) during cycle 107 (535ns - 540ns)
*	Writing 11001001011111100010011001010100  to  address 111111011 (from port 0) during cycle 108 (540ns - 545ns)
*	Reading 00111000110100100111001101010000 from address 000000011 (from port 0) during cycle 109 (545ns - 550ns)
*	Writing (partial) 10111110010001101000100110010100  to  address 111111100 with mask bit 0010 (from port 0) during cycle 111 (555ns - 560ns)
*	Writing 11110001111001100010000000100000  to  address 111111101 (from port 0) during cycle 112 (560ns - 565ns)
*	Reading 11101110011100111001101111000100 from address 111111110 (from port 0) during cycle 113 (565ns - 570ns)
*	Reading 00111000110100100111001101010000 from address 000000011 (from port 0) during cycle 116 (580ns - 585ns)
*	Reading 11001001011111100010011001010100 from address 111111011 (from port 0) during cycle 118 (590ns - 595ns)
*	Writing 01100000000000000111011101010000  to  address 000000010 (from port 0) during cycle 119 (595ns - 600ns)
*	Reading 00111000110100100111001101010000 from address 000000011 (from port 0) during cycle 121 (605ns - 610ns)
*	Reading 01110011111000111111101011111101 from address 000000001 (from port 0) during cycle 122 (610ns - 615ns)
*	Reading 11001001011111100010011001010100 from address 111111011 (from port 0) during cycle 123 (615ns - 620ns)
*	Reading 11001001011111100010011001010100 from address 111111011 (from port 0) during cycle 124 (620ns - 625ns)
*	Reading 00111000110100100111001101010000 from address 000000011 (from port 0) during cycle 125 (625ns - 630ns)
*	Reading 01110011111000111111101011111101 from address 000000001 (from port 0) during cycle 126 (630ns - 635ns)
*	Writing (partial) 11100001101000010011111001000100  to  address 000000010 with mask bit 0101 (from port 0) during cycle 128 (640ns - 645ns)
*	Writing (partial) 11001110000100111101011011011110  to  address 000000010 with mask bit 0001 (from port 0) during cycle 129 (645ns - 650ns)
*	Reading 11110001111001100010000000100000 from address 111111101 (from port 0) during cycle 130 (650ns - 655ns)
*	Reading 01110011111000111111101011111101 from address 000000001 (from port 0) during cycle 132 (660ns - 665ns)
*	Writing 01100101101011110010100101100100  to  address 111111011 (from port 0) during cycle 134 (670ns - 675ns)
*	Writing 01100001100001011010111101011100  to  address 000000000 (from port 0) during cycle 135 (675ns - 680ns)
*	Reading 01100000101000010111011111011110 from address 000000010 (from port 0) during cycle 136 (680ns - 685ns)
*	Writing 01101010101110010001010011011101  to  address 000000010 (from port 0) during cycle 137 (685ns - 690ns)
*	Reading 01100101101011110010100101100100 from address 111111011 (from port 0) during cycle 139 (695ns - 700ns)
*	Reading 01110011111000111111101011111101 from address 000000001 (from port 0) during cycle 142 (710ns - 715ns)
*	Reading 00111000110100100111001101010000 from address 000000011 (from port 0) during cycle 143 (715ns - 720ns)
*	Writing (partial) 01101000100000011011110001001100  to  address 000000000 with mask bit 0010 (from port 0) during cycle 144 (720ns - 725ns)
*	Reading 01100101101011110010100101100100 from address 111111011 (from port 0) during cycle 145 (725ns - 730ns)
*	Writing 11010011011111001010100011101111  to  address 000000010 (from port 0) during cycle 146 (730ns - 735ns)
*	Writing (partial) 01010111010111010000101111100110  to  address 000000000 with mask bit 0111 (from port 0) during cycle 147 (735ns - 740ns)
*	Reading 11010011011111001010100011101111 from address 000000010 (from port 0) during cycle 148 (740ns - 745ns)
*	Writing (partial) 10110010101101110111100011001001  to  address 000000010 with mask bit 1101 (from port 0) during cycle 149 (745ns - 750ns)
*	Reading 10110010101101111010100011001001 from address 000000010 (from port 0) during cycle 150 (750ns - 755ns)
*	Reading 00111000110100100111001101010000 from address 000000011 (from port 0) during cycle 151 (755ns - 760ns)
*	Reading 00111000110100100111001101010000 from address 000000011 (from port 0) during cycle 152 (760ns - 765ns)
*	Writing 01010101011100001011001000110000  to  address 000000011 (from port 0) during cycle 153 (765ns - 770ns)
*	Reading 01100001010111010000101111100110 from address 000000000 (from port 0) during cycle 154 (770ns - 775ns)
*	Reading 01010101011100001011001000110000 from address 000000011 (from port 0) during cycle 155 (775ns - 780ns)
*	Reading 01100001010111010000101111100110 from address 000000000 (from port 0) during cycle 156 (780ns - 785ns)
*	Reading 01010101011100001011001000110000 from address 000000011 (from port 0) during cycle 157 (785ns - 790ns)
*	Reading 11110001111001100010000000100000 from address 111111101 (from port 0) during cycle 158 (790ns - 795ns)
*	Writing 01010101011001100001011010100010  to  address 000000011 (from port 0) during cycle 160 (800ns - 805ns)
*	Reading 11110001111001100010000000100000 from address 111111101 (from port 0) during cycle 161 (805ns - 810ns)
*	Reading 01100101101011110010100101100100 from address 111111011 (from port 0) during cycle 162 (810ns - 815ns)
*	Reading 01100001010111010000101111100110 from address 000000000 (from port 0) during cycle 164 (820ns - 825ns)
*	Reading 10110010101101111010100011001001 from address 000000010 (from port 0) during cycle 165 (825ns - 830ns)
*	Reading 10110010101101111010100011001001 from address 000000010 (from port 0) during cycle 167 (835ns - 840ns)
*	Writing (partial) 10101000001110011011010000001010  to  address 000000010 with mask bit 0010 (from port 0) during cycle 168 (840ns - 845ns)
*	Writing (partial) 00000011001011110001001000011000  to  address 000000001 with mask bit 1110 (from port 0) during cycle 169 (845ns - 850ns)
*	Writing (partial) 01000010111101111001001101011000  to  address 111111110 with mask bit 1000 (from port 0) during cycle 170 (850ns - 855ns)
*	Writing 10011111101011100110010100110011  to  address 111111100 (from port 0) during cycle 171 (855ns - 860ns)
*	Reading 11110001111001100010000000100000 from address 111111101 (from port 0) during cycle 172 (860ns - 865ns)
*	Writing 10011011110010011010000101011011  to  address 000000000 (from port 0) during cycle 173 (865ns - 870ns)
*	Writing 01010000001111110001001110010100  to  address 111111011 (from port 0) during cycle 174 (870ns - 875ns)
*	Reading 10011011110010011010000101011011 from address 000000000 (from port 0) during cycle 175 (875ns - 880ns)
*	Reading 01000010011100111001101111000100 from address 111111110 (from port 0) during cycle 176 (880ns - 885ns)
*	Writing (partial) 01101100100001111000011110010111  to  address 111111011 with mask bit 1110 (from port 0) during cycle 177 (885ns - 890ns)
*	Writing (partial) 10001100110010101001010100111100  to  address 111111100 with mask bit 1011 (from port 0) during cycle 178 (890ns - 895ns)
*	Reading 10001100101011101001010100111100 from address 111111100 (from port 0) during cycle 179 (895ns - 900ns)
*	Writing 00000001100000101000100010010100  to  address 111111011 (from port 0) during cycle 181 (905ns - 910ns)
*	Writing 11110010110011010101000110110101  to  address 000000001 (from port 0) during cycle 182 (910ns - 915ns)
*	Reading 10001100101011101001010100111100 from address 111111100 (from port 0) during cycle 183 (915ns - 920ns)
*	Writing (partial) 00111100000000110010010100001001  to  address 000000000 with mask bit 0010 (from port 0) during cycle 184 (920ns - 925ns)
*	Writing (partial) 11001000010111000010110110000101  to  address 000000011 with mask bit 0100 (from port 0) during cycle 185 (925ns - 930ns)
*	Reading 11110001111001100010000000100000 from address 111111101 (from port 0) during cycle 186 (930ns - 935ns)
*	Writing 11101111101010011111101000010010  to  address 000000011 (from port 0) during cycle 187 (935ns - 940ns)
*	Reading 11110010110011010101000110110101 from address 000000001 (from port 0) during cycle 188 (940ns - 945ns)
*	Writing (partial) 10000010000101000000100001111011  to  address 000000001 with mask bit 0100 (from port 0) during cycle 190 (950ns - 955ns)
*	Writing (partial) 01011101111110101101100010101011  to  address 111111100 with mask bit 1000 (from port 0) during cycle 191 (955ns - 960ns)
*	Reading 00000001100000101000100010010100 from address 111111011 (from port 0) during cycle 192 (960ns - 965ns)
*	Reading 11101111101010011111101000010010 from address 000000011 (from port 0) during cycle 193 (965ns - 970ns)
*	Writing (partial) 00000100100100110101000001010000  to  address 000000000 with mask bit 0110 (from port 0) during cycle 194 (970ns - 975ns)
*	Reading 01011101101011101001010100111100 from address 111111100 (from port 0) during cycle 195 (975ns - 980ns)
*	Writing 10100001001000000000011111100101  to  address 111111100 (from port 0) during cycle 196 (980ns - 985ns)
*	Writing 11000101110111000001100011110001  to  address 000000000 (from port 0) during cycle 197 (985ns - 990ns)
*	Writing 11011001101110000110011001011111  to  address 111111110 (from port 0) during cycle 198 (990ns - 995ns)
*	Reading 11110001111001100010000000100000 from address 111111101 (from port 0) during cycle 199 (995ns - 1000ns)
*	Writing (partial) 11101101110010110111110001000101  to  address 000000010 with mask bit 0111 (from port 0) during cycle 201 (1005ns - 1010ns)
*	Idle during cycle 205 (1025ns - 1030ns)

* Generation of data and address signals
* (time, data): [(0, 0), (5, 1), (10, 0), (15, 0), (20, 0), (25, 1), (30, 1), (35, 0), (40, 0), (45, 0), (50, 1), (55, 1), (60, 1), (65, 0), (70, 0), (75, 0), (80, 0), (85, 0), (90, 0), (95, 0), (100, 0), (105, 1), (110, 1), (115, 1), (120, 1), (125, 0), (130, 1), (135, 1), (140, 1), (145, 1), (150, 1), (155, 1), (160, 1), (165, 1), (170, 1), (175, 1), (180, 1), (185, 0), (190, 0), (195, 0), (200, 0), (205, 0), (210, 0), (215, 0), (220, 0), (225, 0), (230, 0), (235, 0), (240, 0), (245, 0), (250, 0), (255, 0), (260, 0), (265, 1), (270, 0), (275, 0), (280, 0), (285, 1), (290, 1), (295, 1), (300, 0), (305, 0), (310, 0), (315, 1), (320, 1), (325, 1), (330, 1), (335, 1), (340, 1), (345, 0), (350, 0), (355, 0), (360, 0), (365, 0), (370, 0), (375, 0), (380, 0), (385, 0), (390, 1), (395, 1), (400, 1), (405, 1), (410, 1), (415, 1), (420, 1), (425, 0), (430, 0), (435, 0), (440, 1), (445, 0), (450, 0), (455, 0), (460, 0), (465, 1), (470, 1), (475, 0), (480, 0), (485, 0), (490, 0), (495, 0), (500, 0), (505, 0), (510, 0), (515, 0), (520, 1), (525, 1), (530, 1), (535, 0), (540, 0), (545, 0), (550, 0), (555, 0), (560, 0), (565, 0), (570, 0), (575, 0), (580, 0), (585, 0), (590, 0), (595, 0), (600, 0), (605, 0), (610, 0), (615, 0), (620, 0), (625, 0), (630, 0), (635, 0), (640, 0), (645, 0), (650, 0), (655, 0), (660, 0), (665, 0), (670, 0), (675, 0), (680, 0), (685, 1), (690, 1), (695, 1), (700, 1), (705, 1), (710, 1), (715, 1), (720, 0), (725, 0), (730, 1), (735, 0), (740, 0), (745, 1), (750, 1), (755, 1), (760, 1), (765, 0), (770, 0), (775, 0), (780, 0), (785, 0), (790, 0), (795, 0), (800, 0), (805, 0), (810, 0), (815, 0), (820, 0), (825, 0), (830, 0), (835, 0), (840, 0), (845, 0), (850, 0), (855, 1), (860, 1), (865, 1), (870, 0), (875, 0), (880, 0), (885, 1), (890, 0), (895, 0), (900, 0), (905, 0), (910, 1), (915, 1), (920, 1), (925, 1), (930, 1), (935, 0), (940, 0), (945, 0), (950, 1), (955, 1), (960, 1), (965, 1), (970, 0), (975, 0), (980, 1), (985, 1), (990, 1), (995, 1), (1000, 1), (1005, 1), (1010, 1), (1015, 1), (1020, 1), (1025, 1)]
Vdin0_0  din0_0  0 PWL (0n 0.0v 4.745n 0.0v 4.755n 0.95v 9.745n 0.95v 9.755n 0.0v 14.745n 0.0v 14.755n 0.0v 19.745n 0.0v 19.755n 0.0v 24.745n 0.0v 24.755n 0.95v 29.745n 0.95v 29.755n 0.95v 34.745n 0.95v 34.755n 0.0v 39.745n 0.0v 39.755n 0.0v 44.745n 0.0v 44.755n 0.0v 49.745n 0.0v 49.755n 0.95v 54.745n 0.95v 54.755n 0.95v 59.745n 0.95v 59.755n 0.95v 64.745n 0.95v 64.755n 0.0v 69.745n 0.0v 69.755n 0.0v 74.745n 0.0v 74.755n 0.0v 79.745n 0.0v 79.755n 0.0v 84.745n 0.0v 84.755n 0.0v 89.745n 0.0v 89.755n 0.0v 94.745n 0.0v 94.755n 0.0v 99.745n 0.0v 99.755n 0.0v 104.745n 0.0v 104.755n 0.95v 109.745n 0.95v 109.755n 0.95v 114.745n 0.95v 114.755n 0.95v 119.745n 0.95v 119.755n 0.95v 124.745n 0.95v 124.755n 0.0v 129.745n 0.0v 129.755n 0.95v 134.745n 0.95v 134.755n 0.95v 139.745n 0.95v 139.755n 0.95v 144.745n 0.95v 144.755n 0.95v 149.745n 0.95v 149.755n 0.95v 154.745n 0.95v 154.755n 0.95v 159.745n 0.95v 159.755n 0.95v 164.745n 0.95v 164.755n 0.95v 169.745n 0.95v 169.755n 0.95v 174.745n 0.95v 174.755n 0.95v 179.745n 0.95v 179.755n 0.95v 184.745n 0.95v 184.755n 0.0v 189.745n 0.0v 189.755n 0.0v 194.745n 0.0v 194.755n 0.0v 199.745n 0.0v 199.755n 0.0v 204.745n 0.0v 204.755n 0.0v 209.745n 0.0v 209.755n 0.0v 214.745n 0.0v 214.755n 0.0v 219.745n 0.0v 219.755n 0.0v 224.745n 0.0v 224.755n 0.0v 229.745n 0.0v 229.755n 0.0v 234.745n 0.0v 234.755n 0.0v 239.745n 0.0v 239.755n 0.0v 244.745n 0.0v 244.755n 0.0v 249.745n 0.0v 249.755n 0.0v 254.745n 0.0v 254.755n 0.0v 259.745n 0.0v 259.755n 0.0v 264.745n 0.0v 264.755n 0.95v 269.745n 0.95v 269.755n 0.0v 274.745n 0.0v 274.755n 0.0v 279.745n 0.0v 279.755n 0.0v 284.745n 0.0v 284.755n 0.95v 289.745n 0.95v 289.755n 0.95v 294.745n 0.95v 294.755n 0.95v 299.745n 0.95v 299.755n 0.0v 304.745n 0.0v 304.755n 0.0v 309.745n 0.0v 309.755n 0.0v 314.745n 0.0v 314.755n 0.95v 319.745n 0.95v 319.755n 0.95v 324.745n 0.95v 324.755n 0.95v 329.745n 0.95v 329.755n 0.95v 334.745n 0.95v 334.755n 0.95v 339.745n 0.95v 339.755n 0.95v 344.745n 0.95v 344.755n 0.0v 349.745n 0.0v 349.755n 0.0v 354.745n 0.0v 354.755n 0.0v 359.745n 0.0v 359.755n 0.0v 364.745n 0.0v 364.755n 0.0v 369.745n 0.0v 369.755n 0.0v 374.745n 0.0v 374.755n 0.0v 379.745n 0.0v 379.755n 0.0v 384.745n 0.0v 384.755n 0.0v 389.745n 0.0v 389.755n 0.95v 394.745n 0.95v 394.755n 0.95v 399.745n 0.95v 399.755n 0.95v 404.745n 0.95v 404.755n 0.95v 409.745n 0.95v 409.755n 0.95v 414.745n 0.95v 414.755n 0.95v 419.745n 0.95v 419.755n 0.95v 424.745n 0.95v 424.755n 0.0v 429.745n 0.0v 429.755n 0.0v 434.745n 0.0v 434.755n 0.0v 439.745n 0.0v 439.755n 0.95v 444.745n 0.95v 444.755n 0.0v 449.745n 0.0v 449.755n 0.0v 454.745n 0.0v 454.755n 0.0v 459.745n 0.0v 459.755n 0.0v 464.745n 0.0v 464.755n 0.95v 469.745n 0.95v 469.755n 0.95v 474.745n 0.95v 474.755n 0.0v 479.745n 0.0v 479.755n 0.0v 484.745n 0.0v 484.755n 0.0v 489.745n 0.0v 489.755n 0.0v 494.745n 0.0v 494.755n 0.0v 499.745n 0.0v 499.755n 0.0v 504.745n 0.0v 504.755n 0.0v 509.745n 0.0v 509.755n 0.0v 514.745n 0.0v 514.755n 0.0v 519.745n 0.0v 519.755n 0.95v 524.745n 0.95v 524.755n 0.95v 529.745n 0.95v 529.755n 0.95v 534.745n 0.95v 534.755n 0.0v 539.745n 0.0v 539.755n 0.0v 544.745n 0.0v 544.755n 0.0v 549.745n 0.0v 549.755n 0.0v 554.745n 0.0v 554.755n 0.0v 559.745n 0.0v 559.755n 0.0v 564.745n 0.0v 564.755n 0.0v 569.745n 0.0v 569.755n 0.0v 574.745n 0.0v 574.755n 0.0v 579.745n 0.0v 579.755n 0.0v 584.745n 0.0v 584.755n 0.0v 589.745n 0.0v 589.755n 0.0v 594.745n 0.0v 594.755n 0.0v 599.745n 0.0v 599.755n 0.0v 604.745n 0.0v 604.755n 0.0v 609.745n 0.0v 609.755n 0.0v 614.745n 0.0v 614.755n 0.0v 619.745n 0.0v 619.755n 0.0v 624.745n 0.0v 624.755n 0.0v 629.745n 0.0v 629.755n 0.0v 634.745n 0.0v 634.755n 0.0v 639.745n 0.0v 639.755n 0.0v 644.745n 0.0v 644.755n 0.0v 649.745n 0.0v 649.755n 0.0v 654.745n 0.0v 654.755n 0.0v 659.745n 0.0v 659.755n 0.0v 664.745n 0.0v 664.755n 0.0v 669.745n 0.0v 669.755n 0.0v 674.745n 0.0v 674.755n 0.0v 679.745n 0.0v 679.755n 0.0v 684.745n 0.0v 684.755n 0.95v 689.745n 0.95v 689.755n 0.95v 694.745n 0.95v 694.755n 0.95v 699.745n 0.95v 699.755n 0.95v 704.745n 0.95v 704.755n 0.95v 709.745n 0.95v 709.755n 0.95v 714.745n 0.95v 714.755n 0.95v 719.745n 0.95v 719.755n 0.0v 724.745n 0.0v 724.755n 0.0v 729.745n 0.0v 729.755n 0.95v 734.745n 0.95v 734.755n 0.0v 739.745n 0.0v 739.755n 0.0v 744.745n 0.0v 744.755n 0.95v 749.745n 0.95v 749.755n 0.95v 754.745n 0.95v 754.755n 0.95v 759.745n 0.95v 759.755n 0.95v 764.745n 0.95v 764.755n 0.0v 769.745n 0.0v 769.755n 0.0v 774.745n 0.0v 774.755n 0.0v 779.745n 0.0v 779.755n 0.0v 784.745n 0.0v 784.755n 0.0v 789.745n 0.0v 789.755n 0.0v 794.745n 0.0v 794.755n 0.0v 799.745n 0.0v 799.755n 0.0v 804.745n 0.0v 804.755n 0.0v 809.745n 0.0v 809.755n 0.0v 814.745n 0.0v 814.755n 0.0v 819.745n 0.0v 819.755n 0.0v 824.745n 0.0v 824.755n 0.0v 829.745n 0.0v 829.755n 0.0v 834.745n 0.0v 834.755n 0.0v 839.745n 0.0v 839.755n 0.0v 844.745n 0.0v 844.755n 0.0v 849.745n 0.0v 849.755n 0.0v 854.745n 0.0v 854.755n 0.95v 859.745n 0.95v 859.755n 0.95v 864.745n 0.95v 864.755n 0.95v 869.745n 0.95v 869.755n 0.0v 874.745n 0.0v 874.755n 0.0v 879.745n 0.0v 879.755n 0.0v 884.745n 0.0v 884.755n 0.95v 889.745n 0.95v 889.755n 0.0v 894.745n 0.0v 894.755n 0.0v 899.745n 0.0v 899.755n 0.0v 904.745n 0.0v 904.755n 0.0v 909.745n 0.0v 909.755n 0.95v 914.745n 0.95v 914.755n 0.95v 919.745n 0.95v 919.755n 0.95v 924.745n 0.95v 924.755n 0.95v 929.745n 0.95v 929.755n 0.95v 934.745n 0.95v 934.755n 0.0v 939.745n 0.0v 939.755n 0.0v 944.745n 0.0v 944.755n 0.0v 949.745n 0.0v 949.755n 0.95v 954.745n 0.95v 954.755n 0.95v 959.745n 0.95v 959.755n 0.95v 964.745n 0.95v 964.755n 0.95v 969.745n 0.95v 969.755n 0.0v 974.745n 0.0v 974.755n 0.0v 979.745n 0.0v 979.755n 0.95v 984.745n 0.95v 984.755n 0.95v 989.745n 0.95v 989.755n 0.95v 994.745n 0.95v 994.755n 0.95v 999.745n 0.95v 999.755n 0.95v 1004.745n 0.95v 1004.755n 0.95v 1009.745n 0.95v 1009.755n 0.95v 1014.745n 0.95v 1014.755n 0.95v 1019.745n 0.95v 1019.755n 0.95v 1024.745n 0.95v 1024.755n 0.95v )
* (time, data): [(0, 0), (5, 0), (10, 0), (15, 1), (20, 1), (25, 0), (30, 1), (35, 0), (40, 0), (45, 1), (50, 0), (55, 0), (60, 0), (65, 0), (70, 0), (75, 1), (80, 0), (85, 1), (90, 1), (95, 0), (100, 0), (105, 1), (110, 1), (115, 0), (120, 0), (125, 0), (130, 1), (135, 1), (140, 1), (145, 1), (150, 1), (155, 1), (160, 1), (165, 0), (170, 0), (175, 0), (180, 1), (185, 0), (190, 0), (195, 0), (200, 1), (205, 1), (210, 1), (215, 1), (220, 1), (225, 1), (230, 0), (235, 0), (240, 0), (245, 0), (250, 0), (255, 0), (260, 0), (265, 1), (270, 0), (275, 0), (280, 0), (285, 0), (290, 0), (295, 0), (300, 1), (305, 1), (310, 1), (315, 0), (320, 0), (325, 0), (330, 0), (335, 0), (340, 0), (345, 0), (350, 0), (355, 0), (360, 0), (365, 1), (370, 1), (375, 1), (380, 1), (385, 1), (390, 1), (395, 1), (400, 1), (405, 1), (410, 0), (415, 0), (420, 0), (425, 1), (430, 1), (435, 1), (440, 1), (445, 0), (450, 0), (455, 0), (460, 0), (465, 1), (470, 1), (475, 0), (480, 0), (485, 0), (490, 1), (495, 1), (500, 0), (505, 0), (510, 0), (515, 0), (520, 1), (525, 1), (530, 0), (535, 0), (540, 0), (545, 0), (550, 0), (555, 0), (560, 0), (565, 0), (570, 0), (575, 0), (580, 0), (585, 0), (590, 0), (595, 0), (600, 0), (605, 0), (610, 0), (615, 0), (620, 0), (625, 0), (630, 0), (635, 0), (640, 0), (645, 1), (650, 1), (655, 1), (660, 1), (665, 1), (670, 0), (675, 0), (680, 0), (685, 0), (690, 0), (695, 0), (700, 0), (705, 0), (710, 0), (715, 0), (720, 0), (725, 0), (730, 1), (735, 1), (740, 1), (745, 0), (750, 0), (755, 0), (760, 0), (765, 0), (770, 0), (775, 0), (780, 0), (785, 0), (790, 0), (795, 0), (800, 1), (805, 1), (810, 1), (815, 1), (820, 1), (825, 1), (830, 1), (835, 1), (840, 1), (845, 0), (850, 0), (855, 1), (860, 1), (865, 1), (870, 0), (875, 0), (880, 0), (885, 1), (890, 0), (895, 0), (900, 0), (905, 0), (910, 0), (915, 0), (920, 0), (925, 0), (930, 0), (935, 1), (940, 1), (945, 1), (950, 1), (955, 1), (960, 1), (965, 1), (970, 0), (975, 0), (980, 0), (985, 0), (990, 1), (995, 1), (1000, 1), (1005, 0), (1010, 0), (1015, 0), (1020, 0), (1025, 0)]
Vdin0_1  din0_1  0 PWL (0n 0.0v 4.745n 0.0v 4.755n 0.0v 9.745n 0.0v 9.755n 0.0v 14.745n 0.0v 14.755n 0.95v 19.745n 0.95v 19.755n 0.95v 24.745n 0.95v 24.755n 0.0v 29.745n 0.0v 29.755n 0.95v 34.745n 0.95v 34.755n 0.0v 39.745n 0.0v 39.755n 0.0v 44.745n 0.0v 44.755n 0.95v 49.745n 0.95v 49.755n 0.0v 54.745n 0.0v 54.755n 0.0v 59.745n 0.0v 59.755n 0.0v 64.745n 0.0v 64.755n 0.0v 69.745n 0.0v 69.755n 0.0v 74.745n 0.0v 74.755n 0.95v 79.745n 0.95v 79.755n 0.0v 84.745n 0.0v 84.755n 0.95v 89.745n 0.95v 89.755n 0.95v 94.745n 0.95v 94.755n 0.0v 99.745n 0.0v 99.755n 0.0v 104.745n 0.0v 104.755n 0.95v 109.745n 0.95v 109.755n 0.95v 114.745n 0.95v 114.755n 0.0v 119.745n 0.0v 119.755n 0.0v 124.745n 0.0v 124.755n 0.0v 129.745n 0.0v 129.755n 0.95v 134.745n 0.95v 134.755n 0.95v 139.745n 0.95v 139.755n 0.95v 144.745n 0.95v 144.755n 0.95v 149.745n 0.95v 149.755n 0.95v 154.745n 0.95v 154.755n 0.95v 159.745n 0.95v 159.755n 0.95v 164.745n 0.95v 164.755n 0.0v 169.745n 0.0v 169.755n 0.0v 174.745n 0.0v 174.755n 0.0v 179.745n 0.0v 179.755n 0.95v 184.745n 0.95v 184.755n 0.0v 189.745n 0.0v 189.755n 0.0v 194.745n 0.0v 194.755n 0.0v 199.745n 0.0v 199.755n 0.95v 204.745n 0.95v 204.755n 0.95v 209.745n 0.95v 209.755n 0.95v 214.745n 0.95v 214.755n 0.95v 219.745n 0.95v 219.755n 0.95v 224.745n 0.95v 224.755n 0.95v 229.745n 0.95v 229.755n 0.0v 234.745n 0.0v 234.755n 0.0v 239.745n 0.0v 239.755n 0.0v 244.745n 0.0v 244.755n 0.0v 249.745n 0.0v 249.755n 0.0v 254.745n 0.0v 254.755n 0.0v 259.745n 0.0v 259.755n 0.0v 264.745n 0.0v 264.755n 0.95v 269.745n 0.95v 269.755n 0.0v 274.745n 0.0v 274.755n 0.0v 279.745n 0.0v 279.755n 0.0v 284.745n 0.0v 284.755n 0.0v 289.745n 0.0v 289.755n 0.0v 294.745n 0.0v 294.755n 0.0v 299.745n 0.0v 299.755n 0.95v 304.745n 0.95v 304.755n 0.95v 309.745n 0.95v 309.755n 0.95v 314.745n 0.95v 314.755n 0.0v 319.745n 0.0v 319.755n 0.0v 324.745n 0.0v 324.755n 0.0v 329.745n 0.0v 329.755n 0.0v 334.745n 0.0v 334.755n 0.0v 339.745n 0.0v 339.755n 0.0v 344.745n 0.0v 344.755n 0.0v 349.745n 0.0v 349.755n 0.0v 354.745n 0.0v 354.755n 0.0v 359.745n 0.0v 359.755n 0.0v 364.745n 0.0v 364.755n 0.95v 369.745n 0.95v 369.755n 0.95v 374.745n 0.95v 374.755n 0.95v 379.745n 0.95v 379.755n 0.95v 384.745n 0.95v 384.755n 0.95v 389.745n 0.95v 389.755n 0.95v 394.745n 0.95v 394.755n 0.95v 399.745n 0.95v 399.755n 0.95v 404.745n 0.95v 404.755n 0.95v 409.745n 0.95v 409.755n 0.0v 414.745n 0.0v 414.755n 0.0v 419.745n 0.0v 419.755n 0.0v 424.745n 0.0v 424.755n 0.95v 429.745n 0.95v 429.755n 0.95v 434.745n 0.95v 434.755n 0.95v 439.745n 0.95v 439.755n 0.95v 444.745n 0.95v 444.755n 0.0v 449.745n 0.0v 449.755n 0.0v 454.745n 0.0v 454.755n 0.0v 459.745n 0.0v 459.755n 0.0v 464.745n 0.0v 464.755n 0.95v 469.745n 0.95v 469.755n 0.95v 474.745n 0.95v 474.755n 0.0v 479.745n 0.0v 479.755n 0.0v 484.745n 0.0v 484.755n 0.0v 489.745n 0.0v 489.755n 0.95v 494.745n 0.95v 494.755n 0.95v 499.745n 0.95v 499.755n 0.0v 504.745n 0.0v 504.755n 0.0v 509.745n 0.0v 509.755n 0.0v 514.745n 0.0v 514.755n 0.0v 519.745n 0.0v 519.755n 0.95v 524.745n 0.95v 524.755n 0.95v 529.745n 0.95v 529.755n 0.0v 534.745n 0.0v 534.755n 0.0v 539.745n 0.0v 539.755n 0.0v 544.745n 0.0v 544.755n 0.0v 549.745n 0.0v 549.755n 0.0v 554.745n 0.0v 554.755n 0.0v 559.745n 0.0v 559.755n 0.0v 564.745n 0.0v 564.755n 0.0v 569.745n 0.0v 569.755n 0.0v 574.745n 0.0v 574.755n 0.0v 579.745n 0.0v 579.755n 0.0v 584.745n 0.0v 584.755n 0.0v 589.745n 0.0v 589.755n 0.0v 594.745n 0.0v 594.755n 0.0v 599.745n 0.0v 599.755n 0.0v 604.745n 0.0v 604.755n 0.0v 609.745n 0.0v 609.755n 0.0v 614.745n 0.0v 614.755n 0.0v 619.745n 0.0v 619.755n 0.0v 624.745n 0.0v 624.755n 0.0v 629.745n 0.0v 629.755n 0.0v 634.745n 0.0v 634.755n 0.0v 639.745n 0.0v 639.755n 0.0v 644.745n 0.0v 644.755n 0.95v 649.745n 0.95v 649.755n 0.95v 654.745n 0.95v 654.755n 0.95v 659.745n 0.95v 659.755n 0.95v 664.745n 0.95v 664.755n 0.95v 669.745n 0.95v 669.755n 0.0v 674.745n 0.0v 674.755n 0.0v 679.745n 0.0v 679.755n 0.0v 684.745n 0.0v 684.755n 0.0v 689.745n 0.0v 689.755n 0.0v 694.745n 0.0v 694.755n 0.0v 699.745n 0.0v 699.755n 0.0v 704.745n 0.0v 704.755n 0.0v 709.745n 0.0v 709.755n 0.0v 714.745n 0.0v 714.755n 0.0v 719.745n 0.0v 719.755n 0.0v 724.745n 0.0v 724.755n 0.0v 729.745n 0.0v 729.755n 0.95v 734.745n 0.95v 734.755n 0.95v 739.745n 0.95v 739.755n 0.95v 744.745n 0.95v 744.755n 0.0v 749.745n 0.0v 749.755n 0.0v 754.745n 0.0v 754.755n 0.0v 759.745n 0.0v 759.755n 0.0v 764.745n 0.0v 764.755n 0.0v 769.745n 0.0v 769.755n 0.0v 774.745n 0.0v 774.755n 0.0v 779.745n 0.0v 779.755n 0.0v 784.745n 0.0v 784.755n 0.0v 789.745n 0.0v 789.755n 0.0v 794.745n 0.0v 794.755n 0.0v 799.745n 0.0v 799.755n 0.95v 804.745n 0.95v 804.755n 0.95v 809.745n 0.95v 809.755n 0.95v 814.745n 0.95v 814.755n 0.95v 819.745n 0.95v 819.755n 0.95v 824.745n 0.95v 824.755n 0.95v 829.745n 0.95v 829.755n 0.95v 834.745n 0.95v 834.755n 0.95v 839.745n 0.95v 839.755n 0.95v 844.745n 0.95v 844.755n 0.0v 849.745n 0.0v 849.755n 0.0v 854.745n 0.0v 854.755n 0.95v 859.745n 0.95v 859.755n 0.95v 864.745n 0.95v 864.755n 0.95v 869.745n 0.95v 869.755n 0.0v 874.745n 0.0v 874.755n 0.0v 879.745n 0.0v 879.755n 0.0v 884.745n 0.0v 884.755n 0.95v 889.745n 0.95v 889.755n 0.0v 894.745n 0.0v 894.755n 0.0v 899.745n 0.0v 899.755n 0.0v 904.745n 0.0v 904.755n 0.0v 909.745n 0.0v 909.755n 0.0v 914.745n 0.0v 914.755n 0.0v 919.745n 0.0v 919.755n 0.0v 924.745n 0.0v 924.755n 0.0v 929.745n 0.0v 929.755n 0.0v 934.745n 0.0v 934.755n 0.95v 939.745n 0.95v 939.755n 0.95v 944.745n 0.95v 944.755n 0.95v 949.745n 0.95v 949.755n 0.95v 954.745n 0.95v 954.755n 0.95v 959.745n 0.95v 959.755n 0.95v 964.745n 0.95v 964.755n 0.95v 969.745n 0.95v 969.755n 0.0v 974.745n 0.0v 974.755n 0.0v 979.745n 0.0v 979.755n 0.0v 984.745n 0.0v 984.755n 0.0v 989.745n 0.0v 989.755n 0.95v 994.745n 0.95v 994.755n 0.95v 999.745n 0.95v 999.755n 0.95v 1004.745n 0.95v 1004.755n 0.0v 1009.745n 0.0v 1009.755n 0.0v 1014.745n 0.0v 1014.755n 0.0v 1019.745n 0.0v 1019.755n 0.0v 1024.745n 0.0v 1024.755n 0.0v )
* (time, data): [(0, 0), (5, 0), (10, 0), (15, 0), (20, 0), (25, 0), (30, 0), (35, 1), (40, 1), (45, 1), (50, 0), (55, 0), (60, 1), (65, 1), (70, 1), (75, 0), (80, 0), (85, 1), (90, 1), (95, 1), (100, 1), (105, 1), (110, 1), (115, 1), (120, 1), (125, 0), (130, 0), (135, 0), (140, 0), (145, 0), (150, 0), (155, 0), (160, 0), (165, 1), (170, 1), (175, 1), (180, 1), (185, 1), (190, 1), (195, 1), (200, 0), (205, 0), (210, 0), (215, 0), (220, 0), (225, 0), (230, 1), (235, 1), (240, 1), (245, 1), (250, 1), (255, 1), (260, 1), (265, 1), (270, 1), (275, 1), (280, 1), (285, 1), (290, 1), (295, 1), (300, 1), (305, 1), (310, 1), (315, 0), (320, 0), (325, 0), (330, 0), (335, 0), (340, 0), (345, 0), (350, 0), (355, 0), (360, 1), (365, 0), (370, 0), (375, 0), (380, 0), (385, 0), (390, 1), (395, 1), (400, 1), (405, 1), (410, 0), (415, 0), (420, 0), (425, 1), (430, 1), (435, 1), (440, 0), (445, 1), (450, 1), (455, 1), (460, 0), (465, 1), (470, 1), (475, 0), (480, 1), (485, 0), (490, 0), (495, 0), (500, 1), (505, 1), (510, 1), (515, 1), (520, 1), (525, 1), (530, 1), (535, 0), (540, 1), (545, 1), (550, 1), (555, 1), (560, 0), (565, 0), (570, 0), (575, 0), (580, 0), (585, 0), (590, 0), (595, 0), (600, 0), (605, 0), (610, 0), (615, 0), (620, 0), (625, 0), (630, 0), (635, 0), (640, 1), (645, 1), (650, 1), (655, 1), (660, 1), (665, 1), (670, 1), (675, 1), (680, 1), (685, 1), (690, 1), (695, 1), (700, 1), (705, 1), (710, 1), (715, 1), (720, 1), (725, 1), (730, 1), (735, 1), (740, 1), (745, 0), (750, 0), (755, 0), (760, 0), (765, 0), (770, 0), (775, 0), (780, 0), (785, 0), (790, 0), (795, 0), (800, 0), (805, 0), (810, 0), (815, 0), (820, 0), (825, 0), (830, 0), (835, 0), (840, 0), (845, 0), (850, 0), (855, 0), (860, 0), (865, 0), (870, 1), (875, 1), (880, 1), (885, 1), (890, 1), (895, 1), (900, 1), (905, 1), (910, 1), (915, 1), (920, 0), (925, 1), (930, 1), (935, 0), (940, 0), (945, 0), (950, 0), (955, 0), (960, 0), (965, 0), (970, 0), (975, 0), (980, 1), (985, 0), (990, 1), (995, 1), (1000, 1), (1005, 1), (1010, 1), (1015, 1), (1020, 1), (1025, 1)]
Vdin0_2  din0_2  0 PWL (0n 0.0v 4.745n 0.0v 4.755n 0.0v 9.745n 0.0v 9.755n 0.0v 14.745n 0.0v 14.755n 0.0v 19.745n 0.0v 19.755n 0.0v 24.745n 0.0v 24.755n 0.0v 29.745n 0.0v 29.755n 0.0v 34.745n 0.0v 34.755n 0.95v 39.745n 0.95v 39.755n 0.95v 44.745n 0.95v 44.755n 0.95v 49.745n 0.95v 49.755n 0.0v 54.745n 0.0v 54.755n 0.0v 59.745n 0.0v 59.755n 0.95v 64.745n 0.95v 64.755n 0.95v 69.745n 0.95v 69.755n 0.95v 74.745n 0.95v 74.755n 0.0v 79.745n 0.0v 79.755n 0.0v 84.745n 0.0v 84.755n 0.95v 89.745n 0.95v 89.755n 0.95v 94.745n 0.95v 94.755n 0.95v 99.745n 0.95v 99.755n 0.95v 104.745n 0.95v 104.755n 0.95v 109.745n 0.95v 109.755n 0.95v 114.745n 0.95v 114.755n 0.95v 119.745n 0.95v 119.755n 0.95v 124.745n 0.95v 124.755n 0.0v 129.745n 0.0v 129.755n 0.0v 134.745n 0.0v 134.755n 0.0v 139.745n 0.0v 139.755n 0.0v 144.745n 0.0v 144.755n 0.0v 149.745n 0.0v 149.755n 0.0v 154.745n 0.0v 154.755n 0.0v 159.745n 0.0v 159.755n 0.0v 164.745n 0.0v 164.755n 0.95v 169.745n 0.95v 169.755n 0.95v 174.745n 0.95v 174.755n 0.95v 179.745n 0.95v 179.755n 0.95v 184.745n 0.95v 184.755n 0.95v 189.745n 0.95v 189.755n 0.95v 194.745n 0.95v 194.755n 0.95v 199.745n 0.95v 199.755n 0.0v 204.745n 0.0v 204.755n 0.0v 209.745n 0.0v 209.755n 0.0v 214.745n 0.0v 214.755n 0.0v 219.745n 0.0v 219.755n 0.0v 224.745n 0.0v 224.755n 0.0v 229.745n 0.0v 229.755n 0.95v 234.745n 0.95v 234.755n 0.95v 239.745n 0.95v 239.755n 0.95v 244.745n 0.95v 244.755n 0.95v 249.745n 0.95v 249.755n 0.95v 254.745n 0.95v 254.755n 0.95v 259.745n 0.95v 259.755n 0.95v 264.745n 0.95v 264.755n 0.95v 269.745n 0.95v 269.755n 0.95v 274.745n 0.95v 274.755n 0.95v 279.745n 0.95v 279.755n 0.95v 284.745n 0.95v 284.755n 0.95v 289.745n 0.95v 289.755n 0.95v 294.745n 0.95v 294.755n 0.95v 299.745n 0.95v 299.755n 0.95v 304.745n 0.95v 304.755n 0.95v 309.745n 0.95v 309.755n 0.95v 314.745n 0.95v 314.755n 0.0v 319.745n 0.0v 319.755n 0.0v 324.745n 0.0v 324.755n 0.0v 329.745n 0.0v 329.755n 0.0v 334.745n 0.0v 334.755n 0.0v 339.745n 0.0v 339.755n 0.0v 344.745n 0.0v 344.755n 0.0v 349.745n 0.0v 349.755n 0.0v 354.745n 0.0v 354.755n 0.0v 359.745n 0.0v 359.755n 0.95v 364.745n 0.95v 364.755n 0.0v 369.745n 0.0v 369.755n 0.0v 374.745n 0.0v 374.755n 0.0v 379.745n 0.0v 379.755n 0.0v 384.745n 0.0v 384.755n 0.0v 389.745n 0.0v 389.755n 0.95v 394.745n 0.95v 394.755n 0.95v 399.745n 0.95v 399.755n 0.95v 404.745n 0.95v 404.755n 0.95v 409.745n 0.95v 409.755n 0.0v 414.745n 0.0v 414.755n 0.0v 419.745n 0.0v 419.755n 0.0v 424.745n 0.0v 424.755n 0.95v 429.745n 0.95v 429.755n 0.95v 434.745n 0.95v 434.755n 0.95v 439.745n 0.95v 439.755n 0.0v 444.745n 0.0v 444.755n 0.95v 449.745n 0.95v 449.755n 0.95v 454.745n 0.95v 454.755n 0.95v 459.745n 0.95v 459.755n 0.0v 464.745n 0.0v 464.755n 0.95v 469.745n 0.95v 469.755n 0.95v 474.745n 0.95v 474.755n 0.0v 479.745n 0.0v 479.755n 0.95v 484.745n 0.95v 484.755n 0.0v 489.745n 0.0v 489.755n 0.0v 494.745n 0.0v 494.755n 0.0v 499.745n 0.0v 499.755n 0.95v 504.745n 0.95v 504.755n 0.95v 509.745n 0.95v 509.755n 0.95v 514.745n 0.95v 514.755n 0.95v 519.745n 0.95v 519.755n 0.95v 524.745n 0.95v 524.755n 0.95v 529.745n 0.95v 529.755n 0.95v 534.745n 0.95v 534.755n 0.0v 539.745n 0.0v 539.755n 0.95v 544.745n 0.95v 544.755n 0.95v 549.745n 0.95v 549.755n 0.95v 554.745n 0.95v 554.755n 0.95v 559.745n 0.95v 559.755n 0.0v 564.745n 0.0v 564.755n 0.0v 569.745n 0.0v 569.755n 0.0v 574.745n 0.0v 574.755n 0.0v 579.745n 0.0v 579.755n 0.0v 584.745n 0.0v 584.755n 0.0v 589.745n 0.0v 589.755n 0.0v 594.745n 0.0v 594.755n 0.0v 599.745n 0.0v 599.755n 0.0v 604.745n 0.0v 604.755n 0.0v 609.745n 0.0v 609.755n 0.0v 614.745n 0.0v 614.755n 0.0v 619.745n 0.0v 619.755n 0.0v 624.745n 0.0v 624.755n 0.0v 629.745n 0.0v 629.755n 0.0v 634.745n 0.0v 634.755n 0.0v 639.745n 0.0v 639.755n 0.95v 644.745n 0.95v 644.755n 0.95v 649.745n 0.95v 649.755n 0.95v 654.745n 0.95v 654.755n 0.95v 659.745n 0.95v 659.755n 0.95v 664.745n 0.95v 664.755n 0.95v 669.745n 0.95v 669.755n 0.95v 674.745n 0.95v 674.755n 0.95v 679.745n 0.95v 679.755n 0.95v 684.745n 0.95v 684.755n 0.95v 689.745n 0.95v 689.755n 0.95v 694.745n 0.95v 694.755n 0.95v 699.745n 0.95v 699.755n 0.95v 704.745n 0.95v 704.755n 0.95v 709.745n 0.95v 709.755n 0.95v 714.745n 0.95v 714.755n 0.95v 719.745n 0.95v 719.755n 0.95v 724.745n 0.95v 724.755n 0.95v 729.745n 0.95v 729.755n 0.95v 734.745n 0.95v 734.755n 0.95v 739.745n 0.95v 739.755n 0.95v 744.745n 0.95v 744.755n 0.0v 749.745n 0.0v 749.755n 0.0v 754.745n 0.0v 754.755n 0.0v 759.745n 0.0v 759.755n 0.0v 764.745n 0.0v 764.755n 0.0v 769.745n 0.0v 769.755n 0.0v 774.745n 0.0v 774.755n 0.0v 779.745n 0.0v 779.755n 0.0v 784.745n 0.0v 784.755n 0.0v 789.745n 0.0v 789.755n 0.0v 794.745n 0.0v 794.755n 0.0v 799.745n 0.0v 799.755n 0.0v 804.745n 0.0v 804.755n 0.0v 809.745n 0.0v 809.755n 0.0v 814.745n 0.0v 814.755n 0.0v 819.745n 0.0v 819.755n 0.0v 824.745n 0.0v 824.755n 0.0v 829.745n 0.0v 829.755n 0.0v 834.745n 0.0v 834.755n 0.0v 839.745n 0.0v 839.755n 0.0v 844.745n 0.0v 844.755n 0.0v 849.745n 0.0v 849.755n 0.0v 854.745n 0.0v 854.755n 0.0v 859.745n 0.0v 859.755n 0.0v 864.745n 0.0v 864.755n 0.0v 869.745n 0.0v 869.755n 0.95v 874.745n 0.95v 874.755n 0.95v 879.745n 0.95v 879.755n 0.95v 884.745n 0.95v 884.755n 0.95v 889.745n 0.95v 889.755n 0.95v 894.745n 0.95v 894.755n 0.95v 899.745n 0.95v 899.755n 0.95v 904.745n 0.95v 904.755n 0.95v 909.745n 0.95v 909.755n 0.95v 914.745n 0.95v 914.755n 0.95v 919.745n 0.95v 919.755n 0.0v 924.745n 0.0v 924.755n 0.95v 929.745n 0.95v 929.755n 0.95v 934.745n 0.95v 934.755n 0.0v 939.745n 0.0v 939.755n 0.0v 944.745n 0.0v 944.755n 0.0v 949.745n 0.0v 949.755n 0.0v 954.745n 0.0v 954.755n 0.0v 959.745n 0.0v 959.755n 0.0v 964.745n 0.0v 964.755n 0.0v 969.745n 0.0v 969.755n 0.0v 974.745n 0.0v 974.755n 0.0v 979.745n 0.0v 979.755n 0.95v 984.745n 0.95v 984.755n 0.0v 989.745n 0.0v 989.755n 0.95v 994.745n 0.95v 994.755n 0.95v 999.745n 0.95v 999.755n 0.95v 1004.745n 0.95v 1004.755n 0.95v 1009.745n 0.95v 1009.755n 0.95v 1014.745n 0.95v 1014.755n 0.95v 1019.745n 0.95v 1019.755n 0.95v 1024.745n 0.95v 1024.755n 0.95v )
* (time, data): [(0, 0), (5, 1), (10, 0), (15, 1), (20, 1), (25, 1), (30, 1), (35, 0), (40, 0), (45, 0), (50, 0), (55, 0), (60, 0), (65, 0), (70, 0), (75, 0), (80, 1), (85, 1), (90, 1), (95, 0), (100, 0), (105, 0), (110, 0), (115, 0), (120, 0), (125, 1), (130, 0), (135, 0), (140, 0), (145, 0), (150, 0), (155, 0), (160, 0), (165, 1), (170, 1), (175, 1), (180, 0), (185, 1), (190, 1), (195, 1), (200, 1), (205, 1), (210, 1), (215, 1), (220, 1), (225, 1), (230, 1), (235, 1), (240, 1), (245, 0), (250, 0), (255, 0), (260, 0), (265, 0), (270, 1), (275, 1), (280, 1), (285, 1), (290, 1), (295, 1), (300, 1), (305, 1), (310, 1), (315, 0), (320, 0), (325, 0), (330, 0), (335, 0), (340, 0), (345, 1), (350, 1), (355, 1), (360, 0), (365, 0), (370, 0), (375, 0), (380, 0), (385, 0), (390, 1), (395, 1), (400, 1), (405, 1), (410, 0), (415, 0), (420, 0), (425, 1), (430, 1), (435, 0), (440, 0), (445, 1), (450, 1), (455, 1), (460, 0), (465, 0), (470, 0), (475, 1), (480, 0), (485, 0), (490, 1), (495, 1), (500, 0), (505, 0), (510, 0), (515, 0), (520, 0), (525, 0), (530, 1), (535, 1), (540, 0), (545, 0), (550, 0), (555, 0), (560, 0), (565, 0), (570, 0), (575, 0), (580, 0), (585, 0), (590, 0), (595, 0), (600, 0), (605, 0), (610, 0), (615, 0), (620, 0), (625, 0), (630, 0), (635, 0), (640, 0), (645, 1), (650, 1), (655, 1), (660, 1), (665, 1), (670, 0), (675, 1), (680, 1), (685, 1), (690, 1), (695, 1), (700, 1), (705, 1), (710, 1), (715, 1), (720, 1), (725, 1), (730, 1), (735, 0), (740, 0), (745, 1), (750, 1), (755, 1), (760, 1), (765, 0), (770, 0), (775, 0), (780, 0), (785, 0), (790, 0), (795, 0), (800, 0), (805, 0), (810, 0), (815, 0), (820, 0), (825, 0), (830, 0), (835, 0), (840, 1), (845, 1), (850, 1), (855, 0), (860, 0), (865, 1), (870, 0), (875, 0), (880, 0), (885, 0), (890, 1), (895, 1), (900, 1), (905, 0), (910, 0), (915, 0), (920, 1), (925, 0), (930, 0), (935, 0), (940, 0), (945, 0), (950, 1), (955, 1), (960, 1), (965, 1), (970, 0), (975, 0), (980, 0), (985, 0), (990, 1), (995, 1), (1000, 1), (1005, 0), (1010, 0), (1015, 0), (1020, 0), (1025, 0)]
Vdin0_3  din0_3  0 PWL (0n 0.0v 4.745n 0.0v 4.755n 0.95v 9.745n 0.95v 9.755n 0.0v 14.745n 0.0v 14.755n 0.95v 19.745n 0.95v 19.755n 0.95v 24.745n 0.95v 24.755n 0.95v 29.745n 0.95v 29.755n 0.95v 34.745n 0.95v 34.755n 0.0v 39.745n 0.0v 39.755n 0.0v 44.745n 0.0v 44.755n 0.0v 49.745n 0.0v 49.755n 0.0v 54.745n 0.0v 54.755n 0.0v 59.745n 0.0v 59.755n 0.0v 64.745n 0.0v 64.755n 0.0v 69.745n 0.0v 69.755n 0.0v 74.745n 0.0v 74.755n 0.0v 79.745n 0.0v 79.755n 0.95v 84.745n 0.95v 84.755n 0.95v 89.745n 0.95v 89.755n 0.95v 94.745n 0.95v 94.755n 0.0v 99.745n 0.0v 99.755n 0.0v 104.745n 0.0v 104.755n 0.0v 109.745n 0.0v 109.755n 0.0v 114.745n 0.0v 114.755n 0.0v 119.745n 0.0v 119.755n 0.0v 124.745n 0.0v 124.755n 0.95v 129.745n 0.95v 129.755n 0.0v 134.745n 0.0v 134.755n 0.0v 139.745n 0.0v 139.755n 0.0v 144.745n 0.0v 144.755n 0.0v 149.745n 0.0v 149.755n 0.0v 154.745n 0.0v 154.755n 0.0v 159.745n 0.0v 159.755n 0.0v 164.745n 0.0v 164.755n 0.95v 169.745n 0.95v 169.755n 0.95v 174.745n 0.95v 174.755n 0.95v 179.745n 0.95v 179.755n 0.0v 184.745n 0.0v 184.755n 0.95v 189.745n 0.95v 189.755n 0.95v 194.745n 0.95v 194.755n 0.95v 199.745n 0.95v 199.755n 0.95v 204.745n 0.95v 204.755n 0.95v 209.745n 0.95v 209.755n 0.95v 214.745n 0.95v 214.755n 0.95v 219.745n 0.95v 219.755n 0.95v 224.745n 0.95v 224.755n 0.95v 229.745n 0.95v 229.755n 0.95v 234.745n 0.95v 234.755n 0.95v 239.745n 0.95v 239.755n 0.95v 244.745n 0.95v 244.755n 0.0v 249.745n 0.0v 249.755n 0.0v 254.745n 0.0v 254.755n 0.0v 259.745n 0.0v 259.755n 0.0v 264.745n 0.0v 264.755n 0.0v 269.745n 0.0v 269.755n 0.95v 274.745n 0.95v 274.755n 0.95v 279.745n 0.95v 279.755n 0.95v 284.745n 0.95v 284.755n 0.95v 289.745n 0.95v 289.755n 0.95v 294.745n 0.95v 294.755n 0.95v 299.745n 0.95v 299.755n 0.95v 304.745n 0.95v 304.755n 0.95v 309.745n 0.95v 309.755n 0.95v 314.745n 0.95v 314.755n 0.0v 319.745n 0.0v 319.755n 0.0v 324.745n 0.0v 324.755n 0.0v 329.745n 0.0v 329.755n 0.0v 334.745n 0.0v 334.755n 0.0v 339.745n 0.0v 339.755n 0.0v 344.745n 0.0v 344.755n 0.95v 349.745n 0.95v 349.755n 0.95v 354.745n 0.95v 354.755n 0.95v 359.745n 0.95v 359.755n 0.0v 364.745n 0.0v 364.755n 0.0v 369.745n 0.0v 369.755n 0.0v 374.745n 0.0v 374.755n 0.0v 379.745n 0.0v 379.755n 0.0v 384.745n 0.0v 384.755n 0.0v 389.745n 0.0v 389.755n 0.95v 394.745n 0.95v 394.755n 0.95v 399.745n 0.95v 399.755n 0.95v 404.745n 0.95v 404.755n 0.95v 409.745n 0.95v 409.755n 0.0v 414.745n 0.0v 414.755n 0.0v 419.745n 0.0v 419.755n 0.0v 424.745n 0.0v 424.755n 0.95v 429.745n 0.95v 429.755n 0.95v 434.745n 0.95v 434.755n 0.0v 439.745n 0.0v 439.755n 0.0v 444.745n 0.0v 444.755n 0.95v 449.745n 0.95v 449.755n 0.95v 454.745n 0.95v 454.755n 0.95v 459.745n 0.95v 459.755n 0.0v 464.745n 0.0v 464.755n 0.0v 469.745n 0.0v 469.755n 0.0v 474.745n 0.0v 474.755n 0.95v 479.745n 0.95v 479.755n 0.0v 484.745n 0.0v 484.755n 0.0v 489.745n 0.0v 489.755n 0.95v 494.745n 0.95v 494.755n 0.95v 499.745n 0.95v 499.755n 0.0v 504.745n 0.0v 504.755n 0.0v 509.745n 0.0v 509.755n 0.0v 514.745n 0.0v 514.755n 0.0v 519.745n 0.0v 519.755n 0.0v 524.745n 0.0v 524.755n 0.0v 529.745n 0.0v 529.755n 0.95v 534.745n 0.95v 534.755n 0.95v 539.745n 0.95v 539.755n 0.0v 544.745n 0.0v 544.755n 0.0v 549.745n 0.0v 549.755n 0.0v 554.745n 0.0v 554.755n 0.0v 559.745n 0.0v 559.755n 0.0v 564.745n 0.0v 564.755n 0.0v 569.745n 0.0v 569.755n 0.0v 574.745n 0.0v 574.755n 0.0v 579.745n 0.0v 579.755n 0.0v 584.745n 0.0v 584.755n 0.0v 589.745n 0.0v 589.755n 0.0v 594.745n 0.0v 594.755n 0.0v 599.745n 0.0v 599.755n 0.0v 604.745n 0.0v 604.755n 0.0v 609.745n 0.0v 609.755n 0.0v 614.745n 0.0v 614.755n 0.0v 619.745n 0.0v 619.755n 0.0v 624.745n 0.0v 624.755n 0.0v 629.745n 0.0v 629.755n 0.0v 634.745n 0.0v 634.755n 0.0v 639.745n 0.0v 639.755n 0.0v 644.745n 0.0v 644.755n 0.95v 649.745n 0.95v 649.755n 0.95v 654.745n 0.95v 654.755n 0.95v 659.745n 0.95v 659.755n 0.95v 664.745n 0.95v 664.755n 0.95v 669.745n 0.95v 669.755n 0.0v 674.745n 0.0v 674.755n 0.95v 679.745n 0.95v 679.755n 0.95v 684.745n 0.95v 684.755n 0.95v 689.745n 0.95v 689.755n 0.95v 694.745n 0.95v 694.755n 0.95v 699.745n 0.95v 699.755n 0.95v 704.745n 0.95v 704.755n 0.95v 709.745n 0.95v 709.755n 0.95v 714.745n 0.95v 714.755n 0.95v 719.745n 0.95v 719.755n 0.95v 724.745n 0.95v 724.755n 0.95v 729.745n 0.95v 729.755n 0.95v 734.745n 0.95v 734.755n 0.0v 739.745n 0.0v 739.755n 0.0v 744.745n 0.0v 744.755n 0.95v 749.745n 0.95v 749.755n 0.95v 754.745n 0.95v 754.755n 0.95v 759.745n 0.95v 759.755n 0.95v 764.745n 0.95v 764.755n 0.0v 769.745n 0.0v 769.755n 0.0v 774.745n 0.0v 774.755n 0.0v 779.745n 0.0v 779.755n 0.0v 784.745n 0.0v 784.755n 0.0v 789.745n 0.0v 789.755n 0.0v 794.745n 0.0v 794.755n 0.0v 799.745n 0.0v 799.755n 0.0v 804.745n 0.0v 804.755n 0.0v 809.745n 0.0v 809.755n 0.0v 814.745n 0.0v 814.755n 0.0v 819.745n 0.0v 819.755n 0.0v 824.745n 0.0v 824.755n 0.0v 829.745n 0.0v 829.755n 0.0v 834.745n 0.0v 834.755n 0.0v 839.745n 0.0v 839.755n 0.95v 844.745n 0.95v 844.755n 0.95v 849.745n 0.95v 849.755n 0.95v 854.745n 0.95v 854.755n 0.0v 859.745n 0.0v 859.755n 0.0v 864.745n 0.0v 864.755n 0.95v 869.745n 0.95v 869.755n 0.0v 874.745n 0.0v 874.755n 0.0v 879.745n 0.0v 879.755n 0.0v 884.745n 0.0v 884.755n 0.0v 889.745n 0.0v 889.755n 0.95v 894.745n 0.95v 894.755n 0.95v 899.745n 0.95v 899.755n 0.95v 904.745n 0.95v 904.755n 0.0v 909.745n 0.0v 909.755n 0.0v 914.745n 0.0v 914.755n 0.0v 919.745n 0.0v 919.755n 0.95v 924.745n 0.95v 924.755n 0.0v 929.745n 0.0v 929.755n 0.0v 934.745n 0.0v 934.755n 0.0v 939.745n 0.0v 939.755n 0.0v 944.745n 0.0v 944.755n 0.0v 949.745n 0.0v 949.755n 0.95v 954.745n 0.95v 954.755n 0.95v 959.745n 0.95v 959.755n 0.95v 964.745n 0.95v 964.755n 0.95v 969.745n 0.95v 969.755n 0.0v 974.745n 0.0v 974.755n 0.0v 979.745n 0.0v 979.755n 0.0v 984.745n 0.0v 984.755n 0.0v 989.745n 0.0v 989.755n 0.95v 994.745n 0.95v 994.755n 0.95v 999.745n 0.95v 999.755n 0.95v 1004.745n 0.95v 1004.755n 0.0v 1009.745n 0.0v 1009.755n 0.0v 1014.745n 0.0v 1014.755n 0.0v 1019.745n 0.0v 1019.755n 0.0v 1024.745n 0.0v 1024.755n 0.0v )
* (time, data): [(0, 0), (5, 1), (10, 1), (15, 1), (20, 1), (25, 0), (30, 0), (35, 0), (40, 1), (45, 0), (50, 0), (55, 0), (60, 1), (65, 1), (70, 1), (75, 0), (80, 1), (85, 0), (90, 0), (95, 0), (100, 0), (105, 1), (110, 1), (115, 0), (120, 0), (125, 0), (130, 1), (135, 1), (140, 1), (145, 1), (150, 1), (155, 1), (160, 1), (165, 0), (170, 0), (175, 0), (180, 0), (185, 1), (190, 1), (195, 1), (200, 1), (205, 1), (210, 1), (215, 1), (220, 1), (225, 1), (230, 1), (235, 1), (240, 1), (245, 1), (250, 1), (255, 1), (260, 1), (265, 0), (270, 1), (275, 1), (280, 1), (285, 0), (290, 0), (295, 0), (300, 1), (305, 1), (310, 1), (315, 1), (320, 1), (325, 1), (330, 1), (335, 1), (340, 1), (345, 0), (350, 0), (355, 0), (360, 1), (365, 0), (370, 0), (375, 0), (380, 0), (385, 0), (390, 0), (395, 0), (400, 0), (405, 0), (410, 1), (415, 1), (420, 1), (425, 1), (430, 1), (435, 1), (440, 1), (445, 1), (450, 1), (455, 1), (460, 1), (465, 1), (470, 1), (475, 1), (480, 0), (485, 1), (490, 0), (495, 0), (500, 0), (505, 0), (510, 0), (515, 0), (520, 1), (525, 1), (530, 1), (535, 1), (540, 1), (545, 1), (550, 1), (555, 1), (560, 0), (565, 0), (570, 0), (575, 0), (580, 0), (585, 0), (590, 0), (595, 1), (600, 1), (605, 1), (610, 1), (615, 1), (620, 1), (625, 1), (630, 1), (635, 1), (640, 0), (645, 1), (650, 1), (655, 1), (660, 1), (665, 1), (670, 0), (675, 1), (680, 1), (685, 1), (690, 1), (695, 1), (700, 1), (705, 1), (710, 1), (715, 1), (720, 0), (725, 0), (730, 0), (735, 0), (740, 0), (745, 0), (750, 0), (755, 0), (760, 0), (765, 1), (770, 1), (775, 1), (780, 1), (785, 1), (790, 1), (795, 1), (800, 0), (805, 0), (810, 0), (815, 0), (820, 0), (825, 0), (830, 0), (835, 0), (840, 0), (845, 1), (850, 1), (855, 1), (860, 1), (865, 1), (870, 1), (875, 1), (880, 1), (885, 1), (890, 1), (895, 1), (900, 1), (905, 1), (910, 1), (915, 1), (920, 0), (925, 0), (930, 0), (935, 1), (940, 1), (945, 1), (950, 1), (955, 0), (960, 0), (965, 0), (970, 1), (975, 1), (980, 0), (985, 1), (990, 1), (995, 1), (1000, 1), (1005, 0), (1010, 0), (1015, 0), (1020, 0), (1025, 0)]
Vdin0_4  din0_4  0 PWL (0n 0.0v 4.745n 0.0v 4.755n 0.95v 9.745n 0.95v 9.755n 0.95v 14.745n 0.95v 14.755n 0.95v 19.745n 0.95v 19.755n 0.95v 24.745n 0.95v 24.755n 0.0v 29.745n 0.0v 29.755n 0.0v 34.745n 0.0v 34.755n 0.0v 39.745n 0.0v 39.755n 0.95v 44.745n 0.95v 44.755n 0.0v 49.745n 0.0v 49.755n 0.0v 54.745n 0.0v 54.755n 0.0v 59.745n 0.0v 59.755n 0.95v 64.745n 0.95v 64.755n 0.95v 69.745n 0.95v 69.755n 0.95v 74.745n 0.95v 74.755n 0.0v 79.745n 0.0v 79.755n 0.95v 84.745n 0.95v 84.755n 0.0v 89.745n 0.0v 89.755n 0.0v 94.745n 0.0v 94.755n 0.0v 99.745n 0.0v 99.755n 0.0v 104.745n 0.0v 104.755n 0.95v 109.745n 0.95v 109.755n 0.95v 114.745n 0.95v 114.755n 0.0v 119.745n 0.0v 119.755n 0.0v 124.745n 0.0v 124.755n 0.0v 129.745n 0.0v 129.755n 0.95v 134.745n 0.95v 134.755n 0.95v 139.745n 0.95v 139.755n 0.95v 144.745n 0.95v 144.755n 0.95v 149.745n 0.95v 149.755n 0.95v 154.745n 0.95v 154.755n 0.95v 159.745n 0.95v 159.755n 0.95v 164.745n 0.95v 164.755n 0.0v 169.745n 0.0v 169.755n 0.0v 174.745n 0.0v 174.755n 0.0v 179.745n 0.0v 179.755n 0.0v 184.745n 0.0v 184.755n 0.95v 189.745n 0.95v 189.755n 0.95v 194.745n 0.95v 194.755n 0.95v 199.745n 0.95v 199.755n 0.95v 204.745n 0.95v 204.755n 0.95v 209.745n 0.95v 209.755n 0.95v 214.745n 0.95v 214.755n 0.95v 219.745n 0.95v 219.755n 0.95v 224.745n 0.95v 224.755n 0.95v 229.745n 0.95v 229.755n 0.95v 234.745n 0.95v 234.755n 0.95v 239.745n 0.95v 239.755n 0.95v 244.745n 0.95v 244.755n 0.95v 249.745n 0.95v 249.755n 0.95v 254.745n 0.95v 254.755n 0.95v 259.745n 0.95v 259.755n 0.95v 264.745n 0.95v 264.755n 0.0v 269.745n 0.0v 269.755n 0.95v 274.745n 0.95v 274.755n 0.95v 279.745n 0.95v 279.755n 0.95v 284.745n 0.95v 284.755n 0.0v 289.745n 0.0v 289.755n 0.0v 294.745n 0.0v 294.755n 0.0v 299.745n 0.0v 299.755n 0.95v 304.745n 0.95v 304.755n 0.95v 309.745n 0.95v 309.755n 0.95v 314.745n 0.95v 314.755n 0.95v 319.745n 0.95v 319.755n 0.95v 324.745n 0.95v 324.755n 0.95v 329.745n 0.95v 329.755n 0.95v 334.745n 0.95v 334.755n 0.95v 339.745n 0.95v 339.755n 0.95v 344.745n 0.95v 344.755n 0.0v 349.745n 0.0v 349.755n 0.0v 354.745n 0.0v 354.755n 0.0v 359.745n 0.0v 359.755n 0.95v 364.745n 0.95v 364.755n 0.0v 369.745n 0.0v 369.755n 0.0v 374.745n 0.0v 374.755n 0.0v 379.745n 0.0v 379.755n 0.0v 384.745n 0.0v 384.755n 0.0v 389.745n 0.0v 389.755n 0.0v 394.745n 0.0v 394.755n 0.0v 399.745n 0.0v 399.755n 0.0v 404.745n 0.0v 404.755n 0.0v 409.745n 0.0v 409.755n 0.95v 414.745n 0.95v 414.755n 0.95v 419.745n 0.95v 419.755n 0.95v 424.745n 0.95v 424.755n 0.95v 429.745n 0.95v 429.755n 0.95v 434.745n 0.95v 434.755n 0.95v 439.745n 0.95v 439.755n 0.95v 444.745n 0.95v 444.755n 0.95v 449.745n 0.95v 449.755n 0.95v 454.745n 0.95v 454.755n 0.95v 459.745n 0.95v 459.755n 0.95v 464.745n 0.95v 464.755n 0.95v 469.745n 0.95v 469.755n 0.95v 474.745n 0.95v 474.755n 0.95v 479.745n 0.95v 479.755n 0.0v 484.745n 0.0v 484.755n 0.95v 489.745n 0.95v 489.755n 0.0v 494.745n 0.0v 494.755n 0.0v 499.745n 0.0v 499.755n 0.0v 504.745n 0.0v 504.755n 0.0v 509.745n 0.0v 509.755n 0.0v 514.745n 0.0v 514.755n 0.0v 519.745n 0.0v 519.755n 0.95v 524.745n 0.95v 524.755n 0.95v 529.745n 0.95v 529.755n 0.95v 534.745n 0.95v 534.755n 0.95v 539.745n 0.95v 539.755n 0.95v 544.745n 0.95v 544.755n 0.95v 549.745n 0.95v 549.755n 0.95v 554.745n 0.95v 554.755n 0.95v 559.745n 0.95v 559.755n 0.0v 564.745n 0.0v 564.755n 0.0v 569.745n 0.0v 569.755n 0.0v 574.745n 0.0v 574.755n 0.0v 579.745n 0.0v 579.755n 0.0v 584.745n 0.0v 584.755n 0.0v 589.745n 0.0v 589.755n 0.0v 594.745n 0.0v 594.755n 0.95v 599.745n 0.95v 599.755n 0.95v 604.745n 0.95v 604.755n 0.95v 609.745n 0.95v 609.755n 0.95v 614.745n 0.95v 614.755n 0.95v 619.745n 0.95v 619.755n 0.95v 624.745n 0.95v 624.755n 0.95v 629.745n 0.95v 629.755n 0.95v 634.745n 0.95v 634.755n 0.95v 639.745n 0.95v 639.755n 0.0v 644.745n 0.0v 644.755n 0.95v 649.745n 0.95v 649.755n 0.95v 654.745n 0.95v 654.755n 0.95v 659.745n 0.95v 659.755n 0.95v 664.745n 0.95v 664.755n 0.95v 669.745n 0.95v 669.755n 0.0v 674.745n 0.0v 674.755n 0.95v 679.745n 0.95v 679.755n 0.95v 684.745n 0.95v 684.755n 0.95v 689.745n 0.95v 689.755n 0.95v 694.745n 0.95v 694.755n 0.95v 699.745n 0.95v 699.755n 0.95v 704.745n 0.95v 704.755n 0.95v 709.745n 0.95v 709.755n 0.95v 714.745n 0.95v 714.755n 0.95v 719.745n 0.95v 719.755n 0.0v 724.745n 0.0v 724.755n 0.0v 729.745n 0.0v 729.755n 0.0v 734.745n 0.0v 734.755n 0.0v 739.745n 0.0v 739.755n 0.0v 744.745n 0.0v 744.755n 0.0v 749.745n 0.0v 749.755n 0.0v 754.745n 0.0v 754.755n 0.0v 759.745n 0.0v 759.755n 0.0v 764.745n 0.0v 764.755n 0.95v 769.745n 0.95v 769.755n 0.95v 774.745n 0.95v 774.755n 0.95v 779.745n 0.95v 779.755n 0.95v 784.745n 0.95v 784.755n 0.95v 789.745n 0.95v 789.755n 0.95v 794.745n 0.95v 794.755n 0.95v 799.745n 0.95v 799.755n 0.0v 804.745n 0.0v 804.755n 0.0v 809.745n 0.0v 809.755n 0.0v 814.745n 0.0v 814.755n 0.0v 819.745n 0.0v 819.755n 0.0v 824.745n 0.0v 824.755n 0.0v 829.745n 0.0v 829.755n 0.0v 834.745n 0.0v 834.755n 0.0v 839.745n 0.0v 839.755n 0.0v 844.745n 0.0v 844.755n 0.95v 849.745n 0.95v 849.755n 0.95v 854.745n 0.95v 854.755n 0.95v 859.745n 0.95v 859.755n 0.95v 864.745n 0.95v 864.755n 0.95v 869.745n 0.95v 869.755n 0.95v 874.745n 0.95v 874.755n 0.95v 879.745n 0.95v 879.755n 0.95v 884.745n 0.95v 884.755n 0.95v 889.745n 0.95v 889.755n 0.95v 894.745n 0.95v 894.755n 0.95v 899.745n 0.95v 899.755n 0.95v 904.745n 0.95v 904.755n 0.95v 909.745n 0.95v 909.755n 0.95v 914.745n 0.95v 914.755n 0.95v 919.745n 0.95v 919.755n 0.0v 924.745n 0.0v 924.755n 0.0v 929.745n 0.0v 929.755n 0.0v 934.745n 0.0v 934.755n 0.95v 939.745n 0.95v 939.755n 0.95v 944.745n 0.95v 944.755n 0.95v 949.745n 0.95v 949.755n 0.95v 954.745n 0.95v 954.755n 0.0v 959.745n 0.0v 959.755n 0.0v 964.745n 0.0v 964.755n 0.0v 969.745n 0.0v 969.755n 0.95v 974.745n 0.95v 974.755n 0.95v 979.745n 0.95v 979.755n 0.0v 984.745n 0.0v 984.755n 0.95v 989.745n 0.95v 989.755n 0.95v 994.745n 0.95v 994.755n 0.95v 999.745n 0.95v 999.755n 0.95v 1004.745n 0.95v 1004.755n 0.0v 1009.745n 0.0v 1009.755n 0.0v 1014.745n 0.0v 1014.755n 0.0v 1019.745n 0.0v 1019.755n 0.0v 1024.745n 0.0v 1024.755n 0.0v )
* (time, data): [(0, 0), (5, 1), (10, 1), (15, 0), (20, 0), (25, 0), (30, 1), (35, 0), (40, 1), (45, 0), (50, 0), (55, 0), (60, 0), (65, 0), (70, 0), (75, 0), (80, 0), (85, 0), (90, 0), (95, 0), (100, 0), (105, 1), (110, 1), (115, 0), (120, 0), (125, 1), (130, 0), (135, 0), (140, 0), (145, 0), (150, 0), (155, 0), (160, 0), (165, 0), (170, 0), (175, 0), (180, 0), (185, 0), (190, 0), (195, 0), (200, 1), (205, 1), (210, 1), (215, 1), (220, 1), (225, 1), (230, 0), (235, 0), (240, 0), (245, 0), (250, 0), (255, 0), (260, 0), (265, 1), (270, 1), (275, 1), (280, 1), (285, 0), (290, 0), (295, 0), (300, 0), (305, 0), (310, 0), (315, 1), (320, 1), (325, 1), (330, 1), (335, 1), (340, 1), (345, 1), (350, 1), (355, 1), (360, 1), (365, 0), (370, 0), (375, 0), (380, 0), (385, 0), (390, 1), (395, 1), (400, 1), (405, 1), (410, 0), (415, 0), (420, 0), (425, 1), (430, 1), (435, 1), (440, 0), (445, 0), (450, 0), (455, 0), (460, 0), (465, 0), (470, 0), (475, 1), (480, 1), (485, 1), (490, 0), (495, 0), (500, 0), (505, 0), (510, 0), (515, 0), (520, 0), (525, 0), (530, 1), (535, 0), (540, 0), (545, 0), (550, 0), (555, 0), (560, 1), (565, 1), (570, 1), (575, 1), (580, 1), (585, 1), (590, 1), (595, 0), (600, 0), (605, 0), (610, 0), (615, 0), (620, 0), (625, 0), (630, 0), (635, 0), (640, 0), (645, 0), (650, 0), (655, 0), (660, 0), (665, 0), (670, 1), (675, 0), (680, 0), (685, 0), (690, 0), (695, 0), (700, 0), (705, 0), (710, 0), (715, 0), (720, 0), (725, 0), (730, 1), (735, 1), (740, 1), (745, 0), (750, 0), (755, 0), (760, 0), (765, 1), (770, 1), (775, 1), (780, 1), (785, 1), (790, 1), (795, 1), (800, 1), (805, 1), (810, 1), (815, 1), (820, 1), (825, 1), (830, 1), (835, 1), (840, 0), (845, 0), (850, 0), (855, 1), (860, 1), (865, 0), (870, 0), (875, 0), (880, 0), (885, 0), (890, 1), (895, 1), (900, 1), (905, 0), (910, 1), (915, 1), (920, 0), (925, 0), (930, 0), (935, 0), (940, 0), (945, 0), (950, 1), (955, 1), (960, 1), (965, 1), (970, 0), (975, 0), (980, 1), (985, 1), (990, 0), (995, 0), (1000, 0), (1005, 0), (1010, 0), (1015, 0), (1020, 0), (1025, 0)]
Vdin0_5  din0_5  0 PWL (0n 0.0v 4.745n 0.0v 4.755n 0.95v 9.745n 0.95v 9.755n 0.95v 14.745n 0.95v 14.755n 0.0v 19.745n 0.0v 19.755n 0.0v 24.745n 0.0v 24.755n 0.0v 29.745n 0.0v 29.755n 0.95v 34.745n 0.95v 34.755n 0.0v 39.745n 0.0v 39.755n 0.95v 44.745n 0.95v 44.755n 0.0v 49.745n 0.0v 49.755n 0.0v 54.745n 0.0v 54.755n 0.0v 59.745n 0.0v 59.755n 0.0v 64.745n 0.0v 64.755n 0.0v 69.745n 0.0v 69.755n 0.0v 74.745n 0.0v 74.755n 0.0v 79.745n 0.0v 79.755n 0.0v 84.745n 0.0v 84.755n 0.0v 89.745n 0.0v 89.755n 0.0v 94.745n 0.0v 94.755n 0.0v 99.745n 0.0v 99.755n 0.0v 104.745n 0.0v 104.755n 0.95v 109.745n 0.95v 109.755n 0.95v 114.745n 0.95v 114.755n 0.0v 119.745n 0.0v 119.755n 0.0v 124.745n 0.0v 124.755n 0.95v 129.745n 0.95v 129.755n 0.0v 134.745n 0.0v 134.755n 0.0v 139.745n 0.0v 139.755n 0.0v 144.745n 0.0v 144.755n 0.0v 149.745n 0.0v 149.755n 0.0v 154.745n 0.0v 154.755n 0.0v 159.745n 0.0v 159.755n 0.0v 164.745n 0.0v 164.755n 0.0v 169.745n 0.0v 169.755n 0.0v 174.745n 0.0v 174.755n 0.0v 179.745n 0.0v 179.755n 0.0v 184.745n 0.0v 184.755n 0.0v 189.745n 0.0v 189.755n 0.0v 194.745n 0.0v 194.755n 0.0v 199.745n 0.0v 199.755n 0.95v 204.745n 0.95v 204.755n 0.95v 209.745n 0.95v 209.755n 0.95v 214.745n 0.95v 214.755n 0.95v 219.745n 0.95v 219.755n 0.95v 224.745n 0.95v 224.755n 0.95v 229.745n 0.95v 229.755n 0.0v 234.745n 0.0v 234.755n 0.0v 239.745n 0.0v 239.755n 0.0v 244.745n 0.0v 244.755n 0.0v 249.745n 0.0v 249.755n 0.0v 254.745n 0.0v 254.755n 0.0v 259.745n 0.0v 259.755n 0.0v 264.745n 0.0v 264.755n 0.95v 269.745n 0.95v 269.755n 0.95v 274.745n 0.95v 274.755n 0.95v 279.745n 0.95v 279.755n 0.95v 284.745n 0.95v 284.755n 0.0v 289.745n 0.0v 289.755n 0.0v 294.745n 0.0v 294.755n 0.0v 299.745n 0.0v 299.755n 0.0v 304.745n 0.0v 304.755n 0.0v 309.745n 0.0v 309.755n 0.0v 314.745n 0.0v 314.755n 0.95v 319.745n 0.95v 319.755n 0.95v 324.745n 0.95v 324.755n 0.95v 329.745n 0.95v 329.755n 0.95v 334.745n 0.95v 334.755n 0.95v 339.745n 0.95v 339.755n 0.95v 344.745n 0.95v 344.755n 0.95v 349.745n 0.95v 349.755n 0.95v 354.745n 0.95v 354.755n 0.95v 359.745n 0.95v 359.755n 0.95v 364.745n 0.95v 364.755n 0.0v 369.745n 0.0v 369.755n 0.0v 374.745n 0.0v 374.755n 0.0v 379.745n 0.0v 379.755n 0.0v 384.745n 0.0v 384.755n 0.0v 389.745n 0.0v 389.755n 0.95v 394.745n 0.95v 394.755n 0.95v 399.745n 0.95v 399.755n 0.95v 404.745n 0.95v 404.755n 0.95v 409.745n 0.95v 409.755n 0.0v 414.745n 0.0v 414.755n 0.0v 419.745n 0.0v 419.755n 0.0v 424.745n 0.0v 424.755n 0.95v 429.745n 0.95v 429.755n 0.95v 434.745n 0.95v 434.755n 0.95v 439.745n 0.95v 439.755n 0.0v 444.745n 0.0v 444.755n 0.0v 449.745n 0.0v 449.755n 0.0v 454.745n 0.0v 454.755n 0.0v 459.745n 0.0v 459.755n 0.0v 464.745n 0.0v 464.755n 0.0v 469.745n 0.0v 469.755n 0.0v 474.745n 0.0v 474.755n 0.95v 479.745n 0.95v 479.755n 0.95v 484.745n 0.95v 484.755n 0.95v 489.745n 0.95v 489.755n 0.0v 494.745n 0.0v 494.755n 0.0v 499.745n 0.0v 499.755n 0.0v 504.745n 0.0v 504.755n 0.0v 509.745n 0.0v 509.755n 0.0v 514.745n 0.0v 514.755n 0.0v 519.745n 0.0v 519.755n 0.0v 524.745n 0.0v 524.755n 0.0v 529.745n 0.0v 529.755n 0.95v 534.745n 0.95v 534.755n 0.0v 539.745n 0.0v 539.755n 0.0v 544.745n 0.0v 544.755n 0.0v 549.745n 0.0v 549.755n 0.0v 554.745n 0.0v 554.755n 0.0v 559.745n 0.0v 559.755n 0.95v 564.745n 0.95v 564.755n 0.95v 569.745n 0.95v 569.755n 0.95v 574.745n 0.95v 574.755n 0.95v 579.745n 0.95v 579.755n 0.95v 584.745n 0.95v 584.755n 0.95v 589.745n 0.95v 589.755n 0.95v 594.745n 0.95v 594.755n 0.0v 599.745n 0.0v 599.755n 0.0v 604.745n 0.0v 604.755n 0.0v 609.745n 0.0v 609.755n 0.0v 614.745n 0.0v 614.755n 0.0v 619.745n 0.0v 619.755n 0.0v 624.745n 0.0v 624.755n 0.0v 629.745n 0.0v 629.755n 0.0v 634.745n 0.0v 634.755n 0.0v 639.745n 0.0v 639.755n 0.0v 644.745n 0.0v 644.755n 0.0v 649.745n 0.0v 649.755n 0.0v 654.745n 0.0v 654.755n 0.0v 659.745n 0.0v 659.755n 0.0v 664.745n 0.0v 664.755n 0.0v 669.745n 0.0v 669.755n 0.95v 674.745n 0.95v 674.755n 0.0v 679.745n 0.0v 679.755n 0.0v 684.745n 0.0v 684.755n 0.0v 689.745n 0.0v 689.755n 0.0v 694.745n 0.0v 694.755n 0.0v 699.745n 0.0v 699.755n 0.0v 704.745n 0.0v 704.755n 0.0v 709.745n 0.0v 709.755n 0.0v 714.745n 0.0v 714.755n 0.0v 719.745n 0.0v 719.755n 0.0v 724.745n 0.0v 724.755n 0.0v 729.745n 0.0v 729.755n 0.95v 734.745n 0.95v 734.755n 0.95v 739.745n 0.95v 739.755n 0.95v 744.745n 0.95v 744.755n 0.0v 749.745n 0.0v 749.755n 0.0v 754.745n 0.0v 754.755n 0.0v 759.745n 0.0v 759.755n 0.0v 764.745n 0.0v 764.755n 0.95v 769.745n 0.95v 769.755n 0.95v 774.745n 0.95v 774.755n 0.95v 779.745n 0.95v 779.755n 0.95v 784.745n 0.95v 784.755n 0.95v 789.745n 0.95v 789.755n 0.95v 794.745n 0.95v 794.755n 0.95v 799.745n 0.95v 799.755n 0.95v 804.745n 0.95v 804.755n 0.95v 809.745n 0.95v 809.755n 0.95v 814.745n 0.95v 814.755n 0.95v 819.745n 0.95v 819.755n 0.95v 824.745n 0.95v 824.755n 0.95v 829.745n 0.95v 829.755n 0.95v 834.745n 0.95v 834.755n 0.95v 839.745n 0.95v 839.755n 0.0v 844.745n 0.0v 844.755n 0.0v 849.745n 0.0v 849.755n 0.0v 854.745n 0.0v 854.755n 0.95v 859.745n 0.95v 859.755n 0.95v 864.745n 0.95v 864.755n 0.0v 869.745n 0.0v 869.755n 0.0v 874.745n 0.0v 874.755n 0.0v 879.745n 0.0v 879.755n 0.0v 884.745n 0.0v 884.755n 0.0v 889.745n 0.0v 889.755n 0.95v 894.745n 0.95v 894.755n 0.95v 899.745n 0.95v 899.755n 0.95v 904.745n 0.95v 904.755n 0.0v 909.745n 0.0v 909.755n 0.95v 914.745n 0.95v 914.755n 0.95v 919.745n 0.95v 919.755n 0.0v 924.745n 0.0v 924.755n 0.0v 929.745n 0.0v 929.755n 0.0v 934.745n 0.0v 934.755n 0.0v 939.745n 0.0v 939.755n 0.0v 944.745n 0.0v 944.755n 0.0v 949.745n 0.0v 949.755n 0.95v 954.745n 0.95v 954.755n 0.95v 959.745n 0.95v 959.755n 0.95v 964.745n 0.95v 964.755n 0.95v 969.745n 0.95v 969.755n 0.0v 974.745n 0.0v 974.755n 0.0v 979.745n 0.0v 979.755n 0.95v 984.745n 0.95v 984.755n 0.95v 989.745n 0.95v 989.755n 0.0v 994.745n 0.0v 994.755n 0.0v 999.745n 0.0v 999.755n 0.0v 1004.745n 0.0v 1004.755n 0.0v 1009.745n 0.0v 1009.755n 0.0v 1014.745n 0.0v 1014.755n 0.0v 1019.745n 0.0v 1019.755n 0.0v 1024.745n 0.0v 1024.755n 0.0v )
* (time, data): [(0, 0), (5, 0), (10, 0), (15, 0), (20, 0), (25, 0), (30, 0), (35, 1), (40, 1), (45, 1), (50, 0), (55, 0), (60, 1), (65, 1), (70, 1), (75, 1), (80, 1), (85, 0), (90, 0), (95, 0), (100, 0), (105, 0), (110, 0), (115, 1), (120, 1), (125, 0), (130, 1), (135, 1), (140, 1), (145, 1), (150, 1), (155, 1), (160, 1), (165, 0), (170, 0), (175, 0), (180, 0), (185, 0), (190, 0), (195, 0), (200, 0), (205, 0), (210, 0), (215, 0), (220, 0), (225, 0), (230, 0), (235, 0), (240, 0), (245, 0), (250, 0), (255, 0), (260, 0), (265, 0), (270, 0), (275, 0), (280, 0), (285, 0), (290, 0), (295, 0), (300, 1), (305, 1), (310, 1), (315, 1), (320, 1), (325, 1), (330, 1), (335, 1), (340, 1), (345, 1), (350, 1), (355, 1), (360, 0), (365, 1), (370, 1), (375, 1), (380, 1), (385, 1), (390, 0), (395, 0), (400, 0), (405, 0), (410, 1), (415, 1), (420, 1), (425, 1), (430, 1), (435, 1), (440, 0), (445, 0), (450, 0), (455, 0), (460, 1), (465, 0), (470, 0), (475, 0), (480, 1), (485, 0), (490, 0), (495, 0), (500, 1), (505, 1), (510, 1), (515, 1), (520, 1), (525, 1), (530, 1), (535, 0), (540, 1), (545, 1), (550, 1), (555, 0), (560, 0), (565, 0), (570, 0), (575, 0), (580, 0), (585, 0), (590, 0), (595, 1), (600, 1), (605, 1), (610, 1), (615, 1), (620, 1), (625, 1), (630, 1), (635, 1), (640, 1), (645, 1), (650, 1), (655, 1), (660, 1), (665, 1), (670, 1), (675, 1), (680, 1), (685, 1), (690, 1), (695, 1), (700, 1), (705, 1), (710, 1), (715, 1), (720, 1), (725, 1), (730, 1), (735, 1), (740, 1), (745, 1), (750, 1), (755, 1), (760, 1), (765, 0), (770, 0), (775, 0), (780, 0), (785, 0), (790, 0), (795, 0), (800, 0), (805, 0), (810, 0), (815, 0), (820, 0), (825, 0), (830, 0), (835, 0), (840, 0), (845, 0), (850, 1), (855, 0), (860, 0), (865, 1), (870, 0), (875, 0), (880, 0), (885, 0), (890, 0), (895, 0), (900, 0), (905, 0), (910, 0), (915, 0), (920, 0), (925, 0), (930, 0), (935, 0), (940, 0), (945, 0), (950, 1), (955, 0), (960, 0), (965, 0), (970, 1), (975, 1), (980, 1), (985, 1), (990, 1), (995, 1), (1000, 1), (1005, 1), (1010, 1), (1015, 1), (1020, 1), (1025, 1)]
Vdin0_6  din0_6  0 PWL (0n 0.0v 4.745n 0.0v 4.755n 0.0v 9.745n 0.0v 9.755n 0.0v 14.745n 0.0v 14.755n 0.0v 19.745n 0.0v 19.755n 0.0v 24.745n 0.0v 24.755n 0.0v 29.745n 0.0v 29.755n 0.0v 34.745n 0.0v 34.755n 0.95v 39.745n 0.95v 39.755n 0.95v 44.745n 0.95v 44.755n 0.95v 49.745n 0.95v 49.755n 0.0v 54.745n 0.0v 54.755n 0.0v 59.745n 0.0v 59.755n 0.95v 64.745n 0.95v 64.755n 0.95v 69.745n 0.95v 69.755n 0.95v 74.745n 0.95v 74.755n 0.95v 79.745n 0.95v 79.755n 0.95v 84.745n 0.95v 84.755n 0.0v 89.745n 0.0v 89.755n 0.0v 94.745n 0.0v 94.755n 0.0v 99.745n 0.0v 99.755n 0.0v 104.745n 0.0v 104.755n 0.0v 109.745n 0.0v 109.755n 0.0v 114.745n 0.0v 114.755n 0.95v 119.745n 0.95v 119.755n 0.95v 124.745n 0.95v 124.755n 0.0v 129.745n 0.0v 129.755n 0.95v 134.745n 0.95v 134.755n 0.95v 139.745n 0.95v 139.755n 0.95v 144.745n 0.95v 144.755n 0.95v 149.745n 0.95v 149.755n 0.95v 154.745n 0.95v 154.755n 0.95v 159.745n 0.95v 159.755n 0.95v 164.745n 0.95v 164.755n 0.0v 169.745n 0.0v 169.755n 0.0v 174.745n 0.0v 174.755n 0.0v 179.745n 0.0v 179.755n 0.0v 184.745n 0.0v 184.755n 0.0v 189.745n 0.0v 189.755n 0.0v 194.745n 0.0v 194.755n 0.0v 199.745n 0.0v 199.755n 0.0v 204.745n 0.0v 204.755n 0.0v 209.745n 0.0v 209.755n 0.0v 214.745n 0.0v 214.755n 0.0v 219.745n 0.0v 219.755n 0.0v 224.745n 0.0v 224.755n 0.0v 229.745n 0.0v 229.755n 0.0v 234.745n 0.0v 234.755n 0.0v 239.745n 0.0v 239.755n 0.0v 244.745n 0.0v 244.755n 0.0v 249.745n 0.0v 249.755n 0.0v 254.745n 0.0v 254.755n 0.0v 259.745n 0.0v 259.755n 0.0v 264.745n 0.0v 264.755n 0.0v 269.745n 0.0v 269.755n 0.0v 274.745n 0.0v 274.755n 0.0v 279.745n 0.0v 279.755n 0.0v 284.745n 0.0v 284.755n 0.0v 289.745n 0.0v 289.755n 0.0v 294.745n 0.0v 294.755n 0.0v 299.745n 0.0v 299.755n 0.95v 304.745n 0.95v 304.755n 0.95v 309.745n 0.95v 309.755n 0.95v 314.745n 0.95v 314.755n 0.95v 319.745n 0.95v 319.755n 0.95v 324.745n 0.95v 324.755n 0.95v 329.745n 0.95v 329.755n 0.95v 334.745n 0.95v 334.755n 0.95v 339.745n 0.95v 339.755n 0.95v 344.745n 0.95v 344.755n 0.95v 349.745n 0.95v 349.755n 0.95v 354.745n 0.95v 354.755n 0.95v 359.745n 0.95v 359.755n 0.0v 364.745n 0.0v 364.755n 0.95v 369.745n 0.95v 369.755n 0.95v 374.745n 0.95v 374.755n 0.95v 379.745n 0.95v 379.755n 0.95v 384.745n 0.95v 384.755n 0.95v 389.745n 0.95v 389.755n 0.0v 394.745n 0.0v 394.755n 0.0v 399.745n 0.0v 399.755n 0.0v 404.745n 0.0v 404.755n 0.0v 409.745n 0.0v 409.755n 0.95v 414.745n 0.95v 414.755n 0.95v 419.745n 0.95v 419.755n 0.95v 424.745n 0.95v 424.755n 0.95v 429.745n 0.95v 429.755n 0.95v 434.745n 0.95v 434.755n 0.95v 439.745n 0.95v 439.755n 0.0v 444.745n 0.0v 444.755n 0.0v 449.745n 0.0v 449.755n 0.0v 454.745n 0.0v 454.755n 0.0v 459.745n 0.0v 459.755n 0.95v 464.745n 0.95v 464.755n 0.0v 469.745n 0.0v 469.755n 0.0v 474.745n 0.0v 474.755n 0.0v 479.745n 0.0v 479.755n 0.95v 484.745n 0.95v 484.755n 0.0v 489.745n 0.0v 489.755n 0.0v 494.745n 0.0v 494.755n 0.0v 499.745n 0.0v 499.755n 0.95v 504.745n 0.95v 504.755n 0.95v 509.745n 0.95v 509.755n 0.95v 514.745n 0.95v 514.755n 0.95v 519.745n 0.95v 519.755n 0.95v 524.745n 0.95v 524.755n 0.95v 529.745n 0.95v 529.755n 0.95v 534.745n 0.95v 534.755n 0.0v 539.745n 0.0v 539.755n 0.95v 544.745n 0.95v 544.755n 0.95v 549.745n 0.95v 549.755n 0.95v 554.745n 0.95v 554.755n 0.0v 559.745n 0.0v 559.755n 0.0v 564.745n 0.0v 564.755n 0.0v 569.745n 0.0v 569.755n 0.0v 574.745n 0.0v 574.755n 0.0v 579.745n 0.0v 579.755n 0.0v 584.745n 0.0v 584.755n 0.0v 589.745n 0.0v 589.755n 0.0v 594.745n 0.0v 594.755n 0.95v 599.745n 0.95v 599.755n 0.95v 604.745n 0.95v 604.755n 0.95v 609.745n 0.95v 609.755n 0.95v 614.745n 0.95v 614.755n 0.95v 619.745n 0.95v 619.755n 0.95v 624.745n 0.95v 624.755n 0.95v 629.745n 0.95v 629.755n 0.95v 634.745n 0.95v 634.755n 0.95v 639.745n 0.95v 639.755n 0.95v 644.745n 0.95v 644.755n 0.95v 649.745n 0.95v 649.755n 0.95v 654.745n 0.95v 654.755n 0.95v 659.745n 0.95v 659.755n 0.95v 664.745n 0.95v 664.755n 0.95v 669.745n 0.95v 669.755n 0.95v 674.745n 0.95v 674.755n 0.95v 679.745n 0.95v 679.755n 0.95v 684.745n 0.95v 684.755n 0.95v 689.745n 0.95v 689.755n 0.95v 694.745n 0.95v 694.755n 0.95v 699.745n 0.95v 699.755n 0.95v 704.745n 0.95v 704.755n 0.95v 709.745n 0.95v 709.755n 0.95v 714.745n 0.95v 714.755n 0.95v 719.745n 0.95v 719.755n 0.95v 724.745n 0.95v 724.755n 0.95v 729.745n 0.95v 729.755n 0.95v 734.745n 0.95v 734.755n 0.95v 739.745n 0.95v 739.755n 0.95v 744.745n 0.95v 744.755n 0.95v 749.745n 0.95v 749.755n 0.95v 754.745n 0.95v 754.755n 0.95v 759.745n 0.95v 759.755n 0.95v 764.745n 0.95v 764.755n 0.0v 769.745n 0.0v 769.755n 0.0v 774.745n 0.0v 774.755n 0.0v 779.745n 0.0v 779.755n 0.0v 784.745n 0.0v 784.755n 0.0v 789.745n 0.0v 789.755n 0.0v 794.745n 0.0v 794.755n 0.0v 799.745n 0.0v 799.755n 0.0v 804.745n 0.0v 804.755n 0.0v 809.745n 0.0v 809.755n 0.0v 814.745n 0.0v 814.755n 0.0v 819.745n 0.0v 819.755n 0.0v 824.745n 0.0v 824.755n 0.0v 829.745n 0.0v 829.755n 0.0v 834.745n 0.0v 834.755n 0.0v 839.745n 0.0v 839.755n 0.0v 844.745n 0.0v 844.755n 0.0v 849.745n 0.0v 849.755n 0.95v 854.745n 0.95v 854.755n 0.0v 859.745n 0.0v 859.755n 0.0v 864.745n 0.0v 864.755n 0.95v 869.745n 0.95v 869.755n 0.0v 874.745n 0.0v 874.755n 0.0v 879.745n 0.0v 879.755n 0.0v 884.745n 0.0v 884.755n 0.0v 889.745n 0.0v 889.755n 0.0v 894.745n 0.0v 894.755n 0.0v 899.745n 0.0v 899.755n 0.0v 904.745n 0.0v 904.755n 0.0v 909.745n 0.0v 909.755n 0.0v 914.745n 0.0v 914.755n 0.0v 919.745n 0.0v 919.755n 0.0v 924.745n 0.0v 924.755n 0.0v 929.745n 0.0v 929.755n 0.0v 934.745n 0.0v 934.755n 0.0v 939.745n 0.0v 939.755n 0.0v 944.745n 0.0v 944.755n 0.0v 949.745n 0.0v 949.755n 0.95v 954.745n 0.95v 954.755n 0.0v 959.745n 0.0v 959.755n 0.0v 964.745n 0.0v 964.755n 0.0v 969.745n 0.0v 969.755n 0.95v 974.745n 0.95v 974.755n 0.95v 979.745n 0.95v 979.755n 0.95v 984.745n 0.95v 984.755n 0.95v 989.745n 0.95v 989.755n 0.95v 994.745n 0.95v 994.755n 0.95v 999.745n 0.95v 999.755n 0.95v 1004.745n 0.95v 1004.755n 0.95v 1009.745n 0.95v 1009.755n 0.95v 1014.745n 0.95v 1014.755n 0.95v 1019.745n 0.95v 1019.755n 0.95v 1024.745n 0.95v 1024.755n 0.95v )
* (time, data): [(0, 0), (5, 0), (10, 0), (15, 1), (20, 1), (25, 1), (30, 0), (35, 0), (40, 0), (45, 1), (50, 1), (55, 1), (60, 1), (65, 0), (70, 0), (75, 0), (80, 0), (85, 1), (90, 1), (95, 0), (100, 0), (105, 0), (110, 0), (115, 1), (120, 1), (125, 0), (130, 0), (135, 0), (140, 0), (145, 0), (150, 0), (155, 0), (160, 0), (165, 0), (170, 0), (175, 0), (180, 0), (185, 1), (190, 1), (195, 1), (200, 0), (205, 0), (210, 0), (215, 0), (220, 0), (225, 0), (230, 0), (235, 0), (240, 0), (245, 1), (250, 1), (255, 1), (260, 1), (265, 1), (270, 1), (275, 1), (280, 1), (285, 1), (290, 1), (295, 1), (300, 0), (305, 0), (310, 0), (315, 0), (320, 0), (325, 0), (330, 0), (335, 0), (340, 0), (345, 0), (350, 0), (355, 0), (360, 1), (365, 0), (370, 0), (375, 0), (380, 0), (385, 0), (390, 0), (395, 0), (400, 0), (405, 0), (410, 0), (415, 0), (420, 0), (425, 1), (430, 1), (435, 1), (440, 0), (445, 0), (450, 0), (455, 0), (460, 0), (465, 0), (470, 0), (475, 1), (480, 1), (485, 0), (490, 1), (495, 1), (500, 1), (505, 1), (510, 1), (515, 1), (520, 0), (525, 0), (530, 1), (535, 1), (540, 0), (545, 0), (550, 0), (555, 1), (560, 0), (565, 0), (570, 0), (575, 0), (580, 0), (585, 0), (590, 0), (595, 0), (600, 0), (605, 0), (610, 0), (615, 0), (620, 0), (625, 0), (630, 0), (635, 0), (640, 0), (645, 1), (650, 1), (655, 1), (660, 1), (665, 1), (670, 0), (675, 0), (680, 0), (685, 1), (690, 1), (695, 1), (700, 1), (705, 1), (710, 1), (715, 1), (720, 0), (725, 0), (730, 1), (735, 1), (740, 1), (745, 1), (750, 1), (755, 1), (760, 1), (765, 0), (770, 0), (775, 0), (780, 0), (785, 0), (790, 0), (795, 0), (800, 1), (805, 1), (810, 1), (815, 1), (820, 1), (825, 1), (830, 1), (835, 1), (840, 0), (845, 0), (850, 0), (855, 0), (860, 0), (865, 0), (870, 1), (875, 1), (880, 1), (885, 1), (890, 0), (895, 0), (900, 0), (905, 1), (910, 1), (915, 1), (920, 0), (925, 1), (930, 1), (935, 0), (940, 0), (945, 0), (950, 0), (955, 1), (960, 1), (965, 1), (970, 0), (975, 0), (980, 1), (985, 1), (990, 0), (995, 0), (1000, 0), (1005, 0), (1010, 0), (1015, 0), (1020, 0), (1025, 0)]
Vdin0_7  din0_7  0 PWL (0n 0.0v 4.745n 0.0v 4.755n 0.0v 9.745n 0.0v 9.755n 0.0v 14.745n 0.0v 14.755n 0.95v 19.745n 0.95v 19.755n 0.95v 24.745n 0.95v 24.755n 0.95v 29.745n 0.95v 29.755n 0.0v 34.745n 0.0v 34.755n 0.0v 39.745n 0.0v 39.755n 0.0v 44.745n 0.0v 44.755n 0.95v 49.745n 0.95v 49.755n 0.95v 54.745n 0.95v 54.755n 0.95v 59.745n 0.95v 59.755n 0.95v 64.745n 0.95v 64.755n 0.0v 69.745n 0.0v 69.755n 0.0v 74.745n 0.0v 74.755n 0.0v 79.745n 0.0v 79.755n 0.0v 84.745n 0.0v 84.755n 0.95v 89.745n 0.95v 89.755n 0.95v 94.745n 0.95v 94.755n 0.0v 99.745n 0.0v 99.755n 0.0v 104.745n 0.0v 104.755n 0.0v 109.745n 0.0v 109.755n 0.0v 114.745n 0.0v 114.755n 0.95v 119.745n 0.95v 119.755n 0.95v 124.745n 0.95v 124.755n 0.0v 129.745n 0.0v 129.755n 0.0v 134.745n 0.0v 134.755n 0.0v 139.745n 0.0v 139.755n 0.0v 144.745n 0.0v 144.755n 0.0v 149.745n 0.0v 149.755n 0.0v 154.745n 0.0v 154.755n 0.0v 159.745n 0.0v 159.755n 0.0v 164.745n 0.0v 164.755n 0.0v 169.745n 0.0v 169.755n 0.0v 174.745n 0.0v 174.755n 0.0v 179.745n 0.0v 179.755n 0.0v 184.745n 0.0v 184.755n 0.95v 189.745n 0.95v 189.755n 0.95v 194.745n 0.95v 194.755n 0.95v 199.745n 0.95v 199.755n 0.0v 204.745n 0.0v 204.755n 0.0v 209.745n 0.0v 209.755n 0.0v 214.745n 0.0v 214.755n 0.0v 219.745n 0.0v 219.755n 0.0v 224.745n 0.0v 224.755n 0.0v 229.745n 0.0v 229.755n 0.0v 234.745n 0.0v 234.755n 0.0v 239.745n 0.0v 239.755n 0.0v 244.745n 0.0v 244.755n 0.95v 249.745n 0.95v 249.755n 0.95v 254.745n 0.95v 254.755n 0.95v 259.745n 0.95v 259.755n 0.95v 264.745n 0.95v 264.755n 0.95v 269.745n 0.95v 269.755n 0.95v 274.745n 0.95v 274.755n 0.95v 279.745n 0.95v 279.755n 0.95v 284.745n 0.95v 284.755n 0.95v 289.745n 0.95v 289.755n 0.95v 294.745n 0.95v 294.755n 0.95v 299.745n 0.95v 299.755n 0.0v 304.745n 0.0v 304.755n 0.0v 309.745n 0.0v 309.755n 0.0v 314.745n 0.0v 314.755n 0.0v 319.745n 0.0v 319.755n 0.0v 324.745n 0.0v 324.755n 0.0v 329.745n 0.0v 329.755n 0.0v 334.745n 0.0v 334.755n 0.0v 339.745n 0.0v 339.755n 0.0v 344.745n 0.0v 344.755n 0.0v 349.745n 0.0v 349.755n 0.0v 354.745n 0.0v 354.755n 0.0v 359.745n 0.0v 359.755n 0.95v 364.745n 0.95v 364.755n 0.0v 369.745n 0.0v 369.755n 0.0v 374.745n 0.0v 374.755n 0.0v 379.745n 0.0v 379.755n 0.0v 384.745n 0.0v 384.755n 0.0v 389.745n 0.0v 389.755n 0.0v 394.745n 0.0v 394.755n 0.0v 399.745n 0.0v 399.755n 0.0v 404.745n 0.0v 404.755n 0.0v 409.745n 0.0v 409.755n 0.0v 414.745n 0.0v 414.755n 0.0v 419.745n 0.0v 419.755n 0.0v 424.745n 0.0v 424.755n 0.95v 429.745n 0.95v 429.755n 0.95v 434.745n 0.95v 434.755n 0.95v 439.745n 0.95v 439.755n 0.0v 444.745n 0.0v 444.755n 0.0v 449.745n 0.0v 449.755n 0.0v 454.745n 0.0v 454.755n 0.0v 459.745n 0.0v 459.755n 0.0v 464.745n 0.0v 464.755n 0.0v 469.745n 0.0v 469.755n 0.0v 474.745n 0.0v 474.755n 0.95v 479.745n 0.95v 479.755n 0.95v 484.745n 0.95v 484.755n 0.0v 489.745n 0.0v 489.755n 0.95v 494.745n 0.95v 494.755n 0.95v 499.745n 0.95v 499.755n 0.95v 504.745n 0.95v 504.755n 0.95v 509.745n 0.95v 509.755n 0.95v 514.745n 0.95v 514.755n 0.95v 519.745n 0.95v 519.755n 0.0v 524.745n 0.0v 524.755n 0.0v 529.745n 0.0v 529.755n 0.95v 534.745n 0.95v 534.755n 0.95v 539.745n 0.95v 539.755n 0.0v 544.745n 0.0v 544.755n 0.0v 549.745n 0.0v 549.755n 0.0v 554.745n 0.0v 554.755n 0.95v 559.745n 0.95v 559.755n 0.0v 564.745n 0.0v 564.755n 0.0v 569.745n 0.0v 569.755n 0.0v 574.745n 0.0v 574.755n 0.0v 579.745n 0.0v 579.755n 0.0v 584.745n 0.0v 584.755n 0.0v 589.745n 0.0v 589.755n 0.0v 594.745n 0.0v 594.755n 0.0v 599.745n 0.0v 599.755n 0.0v 604.745n 0.0v 604.755n 0.0v 609.745n 0.0v 609.755n 0.0v 614.745n 0.0v 614.755n 0.0v 619.745n 0.0v 619.755n 0.0v 624.745n 0.0v 624.755n 0.0v 629.745n 0.0v 629.755n 0.0v 634.745n 0.0v 634.755n 0.0v 639.745n 0.0v 639.755n 0.0v 644.745n 0.0v 644.755n 0.95v 649.745n 0.95v 649.755n 0.95v 654.745n 0.95v 654.755n 0.95v 659.745n 0.95v 659.755n 0.95v 664.745n 0.95v 664.755n 0.95v 669.745n 0.95v 669.755n 0.0v 674.745n 0.0v 674.755n 0.0v 679.745n 0.0v 679.755n 0.0v 684.745n 0.0v 684.755n 0.95v 689.745n 0.95v 689.755n 0.95v 694.745n 0.95v 694.755n 0.95v 699.745n 0.95v 699.755n 0.95v 704.745n 0.95v 704.755n 0.95v 709.745n 0.95v 709.755n 0.95v 714.745n 0.95v 714.755n 0.95v 719.745n 0.95v 719.755n 0.0v 724.745n 0.0v 724.755n 0.0v 729.745n 0.0v 729.755n 0.95v 734.745n 0.95v 734.755n 0.95v 739.745n 0.95v 739.755n 0.95v 744.745n 0.95v 744.755n 0.95v 749.745n 0.95v 749.755n 0.95v 754.745n 0.95v 754.755n 0.95v 759.745n 0.95v 759.755n 0.95v 764.745n 0.95v 764.755n 0.0v 769.745n 0.0v 769.755n 0.0v 774.745n 0.0v 774.755n 0.0v 779.745n 0.0v 779.755n 0.0v 784.745n 0.0v 784.755n 0.0v 789.745n 0.0v 789.755n 0.0v 794.745n 0.0v 794.755n 0.0v 799.745n 0.0v 799.755n 0.95v 804.745n 0.95v 804.755n 0.95v 809.745n 0.95v 809.755n 0.95v 814.745n 0.95v 814.755n 0.95v 819.745n 0.95v 819.755n 0.95v 824.745n 0.95v 824.755n 0.95v 829.745n 0.95v 829.755n 0.95v 834.745n 0.95v 834.755n 0.95v 839.745n 0.95v 839.755n 0.0v 844.745n 0.0v 844.755n 0.0v 849.745n 0.0v 849.755n 0.0v 854.745n 0.0v 854.755n 0.0v 859.745n 0.0v 859.755n 0.0v 864.745n 0.0v 864.755n 0.0v 869.745n 0.0v 869.755n 0.95v 874.745n 0.95v 874.755n 0.95v 879.745n 0.95v 879.755n 0.95v 884.745n 0.95v 884.755n 0.95v 889.745n 0.95v 889.755n 0.0v 894.745n 0.0v 894.755n 0.0v 899.745n 0.0v 899.755n 0.0v 904.745n 0.0v 904.755n 0.95v 909.745n 0.95v 909.755n 0.95v 914.745n 0.95v 914.755n 0.95v 919.745n 0.95v 919.755n 0.0v 924.745n 0.0v 924.755n 0.95v 929.745n 0.95v 929.755n 0.95v 934.745n 0.95v 934.755n 0.0v 939.745n 0.0v 939.755n 0.0v 944.745n 0.0v 944.755n 0.0v 949.745n 0.0v 949.755n 0.0v 954.745n 0.0v 954.755n 0.95v 959.745n 0.95v 959.755n 0.95v 964.745n 0.95v 964.755n 0.95v 969.745n 0.95v 969.755n 0.0v 974.745n 0.0v 974.755n 0.0v 979.745n 0.0v 979.755n 0.95v 984.745n 0.95v 984.755n 0.95v 989.745n 0.95v 989.755n 0.0v 994.745n 0.0v 994.755n 0.0v 999.745n 0.0v 999.755n 0.0v 1004.745n 0.0v 1004.755n 0.0v 1009.745n 0.0v 1009.755n 0.0v 1014.745n 0.0v 1014.755n 0.0v 1019.745n 0.0v 1019.755n 0.0v 1024.745n 0.0v 1024.755n 0.0v )
* (time, data): [(0, 0), (5, 1), (10, 1), (15, 1), (20, 1), (25, 1), (30, 1), (35, 0), (40, 0), (45, 1), (50, 0), (55, 0), (60, 1), (65, 1), (70, 1), (75, 0), (80, 0), (85, 1), (90, 1), (95, 1), (100, 1), (105, 0), (110, 0), (115, 0), (120, 0), (125, 0), (130, 0), (135, 0), (140, 0), (145, 0), (150, 0), (155, 0), (160, 0), (165, 1), (170, 1), (175, 1), (180, 1), (185, 0), (190, 0), (195, 0), (200, 0), (205, 0), (210, 0), (215, 0), (220, 0), (225, 0), (230, 1), (235, 1), (240, 1), (245, 0), (250, 0), (255, 0), (260, 0), (265, 1), (270, 0), (275, 0), (280, 0), (285, 1), (290, 1), (295, 1), (300, 1), (305, 1), (310, 1), (315, 0), (320, 0), (325, 0), (330, 0), (335, 0), (340, 0), (345, 1), (350, 1), (355, 1), (360, 1), (365, 1), (370, 1), (375, 1), (380, 1), (385, 1), (390, 1), (395, 1), (400, 1), (405, 1), (410, 1), (415, 1), (420, 1), (425, 1), (430, 1), (435, 1), (440, 1), (445, 0), (450, 0), (455, 0), (460, 1), (465, 1), (470, 1), (475, 1), (480, 1), (485, 1), (490, 0), (495, 0), (500, 1), (505, 1), (510, 1), (515, 1), (520, 0), (525, 0), (530, 0), (535, 0), (540, 0), (545, 0), (550, 0), (555, 1), (560, 0), (565, 0), (570, 0), (575, 0), (580, 0), (585, 0), (590, 0), (595, 1), (600, 1), (605, 1), (610, 1), (615, 1), (620, 1), (625, 1), (630, 1), (635, 1), (640, 0), (645, 0), (650, 0), (655, 0), (660, 0), (665, 0), (670, 1), (675, 1), (680, 1), (685, 0), (690, 0), (695, 0), (700, 0), (705, 0), (710, 0), (715, 0), (720, 0), (725, 0), (730, 0), (735, 1), (740, 1), (745, 0), (750, 0), (755, 0), (760, 0), (765, 0), (770, 0), (775, 0), (780, 0), (785, 0), (790, 0), (795, 0), (800, 0), (805, 0), (810, 0), (815, 0), (820, 0), (825, 0), (830, 0), (835, 0), (840, 0), (845, 0), (850, 1), (855, 1), (860, 1), (865, 1), (870, 1), (875, 1), (880, 1), (885, 1), (890, 1), (895, 1), (900, 1), (905, 0), (910, 1), (915, 1), (920, 1), (925, 1), (930, 1), (935, 0), (940, 0), (945, 0), (950, 0), (955, 0), (960, 0), (965, 0), (970, 0), (975, 0), (980, 1), (985, 0), (990, 0), (995, 0), (1000, 0), (1005, 0), (1010, 0), (1015, 0), (1020, 0), (1025, 0)]
Vdin0_8  din0_8  0 PWL (0n 0.0v 4.745n 0.0v 4.755n 0.95v 9.745n 0.95v 9.755n 0.95v 14.745n 0.95v 14.755n 0.95v 19.745n 0.95v 19.755n 0.95v 24.745n 0.95v 24.755n 0.95v 29.745n 0.95v 29.755n 0.95v 34.745n 0.95v 34.755n 0.0v 39.745n 0.0v 39.755n 0.0v 44.745n 0.0v 44.755n 0.95v 49.745n 0.95v 49.755n 0.0v 54.745n 0.0v 54.755n 0.0v 59.745n 0.0v 59.755n 0.95v 64.745n 0.95v 64.755n 0.95v 69.745n 0.95v 69.755n 0.95v 74.745n 0.95v 74.755n 0.0v 79.745n 0.0v 79.755n 0.0v 84.745n 0.0v 84.755n 0.95v 89.745n 0.95v 89.755n 0.95v 94.745n 0.95v 94.755n 0.95v 99.745n 0.95v 99.755n 0.95v 104.745n 0.95v 104.755n 0.0v 109.745n 0.0v 109.755n 0.0v 114.745n 0.0v 114.755n 0.0v 119.745n 0.0v 119.755n 0.0v 124.745n 0.0v 124.755n 0.0v 129.745n 0.0v 129.755n 0.0v 134.745n 0.0v 134.755n 0.0v 139.745n 0.0v 139.755n 0.0v 144.745n 0.0v 144.755n 0.0v 149.745n 0.0v 149.755n 0.0v 154.745n 0.0v 154.755n 0.0v 159.745n 0.0v 159.755n 0.0v 164.745n 0.0v 164.755n 0.95v 169.745n 0.95v 169.755n 0.95v 174.745n 0.95v 174.755n 0.95v 179.745n 0.95v 179.755n 0.95v 184.745n 0.95v 184.755n 0.0v 189.745n 0.0v 189.755n 0.0v 194.745n 0.0v 194.755n 0.0v 199.745n 0.0v 199.755n 0.0v 204.745n 0.0v 204.755n 0.0v 209.745n 0.0v 209.755n 0.0v 214.745n 0.0v 214.755n 0.0v 219.745n 0.0v 219.755n 0.0v 224.745n 0.0v 224.755n 0.0v 229.745n 0.0v 229.755n 0.95v 234.745n 0.95v 234.755n 0.95v 239.745n 0.95v 239.755n 0.95v 244.745n 0.95v 244.755n 0.0v 249.745n 0.0v 249.755n 0.0v 254.745n 0.0v 254.755n 0.0v 259.745n 0.0v 259.755n 0.0v 264.745n 0.0v 264.755n 0.95v 269.745n 0.95v 269.755n 0.0v 274.745n 0.0v 274.755n 0.0v 279.745n 0.0v 279.755n 0.0v 284.745n 0.0v 284.755n 0.95v 289.745n 0.95v 289.755n 0.95v 294.745n 0.95v 294.755n 0.95v 299.745n 0.95v 299.755n 0.95v 304.745n 0.95v 304.755n 0.95v 309.745n 0.95v 309.755n 0.95v 314.745n 0.95v 314.755n 0.0v 319.745n 0.0v 319.755n 0.0v 324.745n 0.0v 324.755n 0.0v 329.745n 0.0v 329.755n 0.0v 334.745n 0.0v 334.755n 0.0v 339.745n 0.0v 339.755n 0.0v 344.745n 0.0v 344.755n 0.95v 349.745n 0.95v 349.755n 0.95v 354.745n 0.95v 354.755n 0.95v 359.745n 0.95v 359.755n 0.95v 364.745n 0.95v 364.755n 0.95v 369.745n 0.95v 369.755n 0.95v 374.745n 0.95v 374.755n 0.95v 379.745n 0.95v 379.755n 0.95v 384.745n 0.95v 384.755n 0.95v 389.745n 0.95v 389.755n 0.95v 394.745n 0.95v 394.755n 0.95v 399.745n 0.95v 399.755n 0.95v 404.745n 0.95v 404.755n 0.95v 409.745n 0.95v 409.755n 0.95v 414.745n 0.95v 414.755n 0.95v 419.745n 0.95v 419.755n 0.95v 424.745n 0.95v 424.755n 0.95v 429.745n 0.95v 429.755n 0.95v 434.745n 0.95v 434.755n 0.95v 439.745n 0.95v 439.755n 0.95v 444.745n 0.95v 444.755n 0.0v 449.745n 0.0v 449.755n 0.0v 454.745n 0.0v 454.755n 0.0v 459.745n 0.0v 459.755n 0.95v 464.745n 0.95v 464.755n 0.95v 469.745n 0.95v 469.755n 0.95v 474.745n 0.95v 474.755n 0.95v 479.745n 0.95v 479.755n 0.95v 484.745n 0.95v 484.755n 0.95v 489.745n 0.95v 489.755n 0.0v 494.745n 0.0v 494.755n 0.0v 499.745n 0.0v 499.755n 0.95v 504.745n 0.95v 504.755n 0.95v 509.745n 0.95v 509.755n 0.95v 514.745n 0.95v 514.755n 0.95v 519.745n 0.95v 519.755n 0.0v 524.745n 0.0v 524.755n 0.0v 529.745n 0.0v 529.755n 0.0v 534.745n 0.0v 534.755n 0.0v 539.745n 0.0v 539.755n 0.0v 544.745n 0.0v 544.755n 0.0v 549.745n 0.0v 549.755n 0.0v 554.745n 0.0v 554.755n 0.95v 559.745n 0.95v 559.755n 0.0v 564.745n 0.0v 564.755n 0.0v 569.745n 0.0v 569.755n 0.0v 574.745n 0.0v 574.755n 0.0v 579.745n 0.0v 579.755n 0.0v 584.745n 0.0v 584.755n 0.0v 589.745n 0.0v 589.755n 0.0v 594.745n 0.0v 594.755n 0.95v 599.745n 0.95v 599.755n 0.95v 604.745n 0.95v 604.755n 0.95v 609.745n 0.95v 609.755n 0.95v 614.745n 0.95v 614.755n 0.95v 619.745n 0.95v 619.755n 0.95v 624.745n 0.95v 624.755n 0.95v 629.745n 0.95v 629.755n 0.95v 634.745n 0.95v 634.755n 0.95v 639.745n 0.95v 639.755n 0.0v 644.745n 0.0v 644.755n 0.0v 649.745n 0.0v 649.755n 0.0v 654.745n 0.0v 654.755n 0.0v 659.745n 0.0v 659.755n 0.0v 664.745n 0.0v 664.755n 0.0v 669.745n 0.0v 669.755n 0.95v 674.745n 0.95v 674.755n 0.95v 679.745n 0.95v 679.755n 0.95v 684.745n 0.95v 684.755n 0.0v 689.745n 0.0v 689.755n 0.0v 694.745n 0.0v 694.755n 0.0v 699.745n 0.0v 699.755n 0.0v 704.745n 0.0v 704.755n 0.0v 709.745n 0.0v 709.755n 0.0v 714.745n 0.0v 714.755n 0.0v 719.745n 0.0v 719.755n 0.0v 724.745n 0.0v 724.755n 0.0v 729.745n 0.0v 729.755n 0.0v 734.745n 0.0v 734.755n 0.95v 739.745n 0.95v 739.755n 0.95v 744.745n 0.95v 744.755n 0.0v 749.745n 0.0v 749.755n 0.0v 754.745n 0.0v 754.755n 0.0v 759.745n 0.0v 759.755n 0.0v 764.745n 0.0v 764.755n 0.0v 769.745n 0.0v 769.755n 0.0v 774.745n 0.0v 774.755n 0.0v 779.745n 0.0v 779.755n 0.0v 784.745n 0.0v 784.755n 0.0v 789.745n 0.0v 789.755n 0.0v 794.745n 0.0v 794.755n 0.0v 799.745n 0.0v 799.755n 0.0v 804.745n 0.0v 804.755n 0.0v 809.745n 0.0v 809.755n 0.0v 814.745n 0.0v 814.755n 0.0v 819.745n 0.0v 819.755n 0.0v 824.745n 0.0v 824.755n 0.0v 829.745n 0.0v 829.755n 0.0v 834.745n 0.0v 834.755n 0.0v 839.745n 0.0v 839.755n 0.0v 844.745n 0.0v 844.755n 0.0v 849.745n 0.0v 849.755n 0.95v 854.745n 0.95v 854.755n 0.95v 859.745n 0.95v 859.755n 0.95v 864.745n 0.95v 864.755n 0.95v 869.745n 0.95v 869.755n 0.95v 874.745n 0.95v 874.755n 0.95v 879.745n 0.95v 879.755n 0.95v 884.745n 0.95v 884.755n 0.95v 889.745n 0.95v 889.755n 0.95v 894.745n 0.95v 894.755n 0.95v 899.745n 0.95v 899.755n 0.95v 904.745n 0.95v 904.755n 0.0v 909.745n 0.0v 909.755n 0.95v 914.745n 0.95v 914.755n 0.95v 919.745n 0.95v 919.755n 0.95v 924.745n 0.95v 924.755n 0.95v 929.745n 0.95v 929.755n 0.95v 934.745n 0.95v 934.755n 0.0v 939.745n 0.0v 939.755n 0.0v 944.745n 0.0v 944.755n 0.0v 949.745n 0.0v 949.755n 0.0v 954.745n 0.0v 954.755n 0.0v 959.745n 0.0v 959.755n 0.0v 964.745n 0.0v 964.755n 0.0v 969.745n 0.0v 969.755n 0.0v 974.745n 0.0v 974.755n 0.0v 979.745n 0.0v 979.755n 0.95v 984.745n 0.95v 984.755n 0.0v 989.745n 0.0v 989.755n 0.0v 994.745n 0.0v 994.755n 0.0v 999.745n 0.0v 999.755n 0.0v 1004.745n 0.0v 1004.755n 0.0v 1009.745n 0.0v 1009.755n 0.0v 1014.745n 0.0v 1014.755n 0.0v 1019.745n 0.0v 1019.755n 0.0v 1024.745n 0.0v 1024.755n 0.0v )
* (time, data): [(0, 0), (5, 1), (10, 1), (15, 1), (20, 1), (25, 1), (30, 1), (35, 1), (40, 1), (45, 1), (50, 0), (55, 0), (60, 1), (65, 0), (70, 0), (75, 0), (80, 1), (85, 0), (90, 0), (95, 0), (100, 0), (105, 1), (110, 1), (115, 1), (120, 1), (125, 1), (130, 0), (135, 0), (140, 0), (145, 0), (150, 0), (155, 0), (160, 0), (165, 0), (170, 0), (175, 0), (180, 1), (185, 0), (190, 0), (195, 0), (200, 1), (205, 1), (210, 1), (215, 1), (220, 1), (225, 1), (230, 0), (235, 0), (240, 0), (245, 0), (250, 0), (255, 0), (260, 0), (265, 1), (270, 1), (275, 1), (280, 1), (285, 1), (290, 1), (295, 1), (300, 1), (305, 1), (310, 1), (315, 0), (320, 0), (325, 0), (330, 0), (335, 0), (340, 0), (345, 0), (350, 0), (355, 0), (360, 1), (365, 0), (370, 0), (375, 0), (380, 0), (385, 0), (390, 0), (395, 0), (400, 0), (405, 0), (410, 0), (415, 0), (420, 0), (425, 0), (430, 0), (435, 0), (440, 1), (445, 0), (450, 0), (455, 0), (460, 0), (465, 1), (470, 1), (475, 1), (480, 0), (485, 0), (490, 1), (495, 1), (500, 1), (505, 1), (510, 1), (515, 1), (520, 1), (525, 1), (530, 1), (535, 1), (540, 1), (545, 1), (550, 1), (555, 0), (560, 0), (565, 0), (570, 0), (575, 0), (580, 0), (585, 0), (590, 0), (595, 1), (600, 1), (605, 1), (610, 1), (615, 1), (620, 1), (625, 1), (630, 1), (635, 1), (640, 1), (645, 1), (650, 1), (655, 1), (660, 1), (665, 1), (670, 0), (675, 1), (680, 1), (685, 0), (690, 0), (695, 0), (700, 0), (705, 0), (710, 0), (715, 0), (720, 0), (725, 0), (730, 0), (735, 1), (740, 1), (745, 0), (750, 0), (755, 0), (760, 0), (765, 1), (770, 1), (775, 1), (780, 1), (785, 1), (790, 1), (795, 1), (800, 1), (805, 1), (810, 1), (815, 1), (820, 1), (825, 1), (830, 1), (835, 1), (840, 0), (845, 1), (850, 1), (855, 0), (860, 0), (865, 0), (870, 1), (875, 1), (880, 1), (885, 1), (890, 0), (895, 0), (900, 0), (905, 0), (910, 0), (915, 0), (920, 0), (925, 0), (930, 0), (935, 1), (940, 1), (945, 1), (950, 0), (955, 0), (960, 0), (965, 0), (970, 0), (975, 0), (980, 1), (985, 0), (990, 1), (995, 1), (1000, 1), (1005, 0), (1010, 0), (1015, 0), (1020, 0), (1025, 0)]
Vdin0_9  din0_9  0 PWL (0n 0.0v 4.745n 0.0v 4.755n 0.95v 9.745n 0.95v 9.755n 0.95v 14.745n 0.95v 14.755n 0.95v 19.745n 0.95v 19.755n 0.95v 24.745n 0.95v 24.755n 0.95v 29.745n 0.95v 29.755n 0.95v 34.745n 0.95v 34.755n 0.95v 39.745n 0.95v 39.755n 0.95v 44.745n 0.95v 44.755n 0.95v 49.745n 0.95v 49.755n 0.0v 54.745n 0.0v 54.755n 0.0v 59.745n 0.0v 59.755n 0.95v 64.745n 0.95v 64.755n 0.0v 69.745n 0.0v 69.755n 0.0v 74.745n 0.0v 74.755n 0.0v 79.745n 0.0v 79.755n 0.95v 84.745n 0.95v 84.755n 0.0v 89.745n 0.0v 89.755n 0.0v 94.745n 0.0v 94.755n 0.0v 99.745n 0.0v 99.755n 0.0v 104.745n 0.0v 104.755n 0.95v 109.745n 0.95v 109.755n 0.95v 114.745n 0.95v 114.755n 0.95v 119.745n 0.95v 119.755n 0.95v 124.745n 0.95v 124.755n 0.95v 129.745n 0.95v 129.755n 0.0v 134.745n 0.0v 134.755n 0.0v 139.745n 0.0v 139.755n 0.0v 144.745n 0.0v 144.755n 0.0v 149.745n 0.0v 149.755n 0.0v 154.745n 0.0v 154.755n 0.0v 159.745n 0.0v 159.755n 0.0v 164.745n 0.0v 164.755n 0.0v 169.745n 0.0v 169.755n 0.0v 174.745n 0.0v 174.755n 0.0v 179.745n 0.0v 179.755n 0.95v 184.745n 0.95v 184.755n 0.0v 189.745n 0.0v 189.755n 0.0v 194.745n 0.0v 194.755n 0.0v 199.745n 0.0v 199.755n 0.95v 204.745n 0.95v 204.755n 0.95v 209.745n 0.95v 209.755n 0.95v 214.745n 0.95v 214.755n 0.95v 219.745n 0.95v 219.755n 0.95v 224.745n 0.95v 224.755n 0.95v 229.745n 0.95v 229.755n 0.0v 234.745n 0.0v 234.755n 0.0v 239.745n 0.0v 239.755n 0.0v 244.745n 0.0v 244.755n 0.0v 249.745n 0.0v 249.755n 0.0v 254.745n 0.0v 254.755n 0.0v 259.745n 0.0v 259.755n 0.0v 264.745n 0.0v 264.755n 0.95v 269.745n 0.95v 269.755n 0.95v 274.745n 0.95v 274.755n 0.95v 279.745n 0.95v 279.755n 0.95v 284.745n 0.95v 284.755n 0.95v 289.745n 0.95v 289.755n 0.95v 294.745n 0.95v 294.755n 0.95v 299.745n 0.95v 299.755n 0.95v 304.745n 0.95v 304.755n 0.95v 309.745n 0.95v 309.755n 0.95v 314.745n 0.95v 314.755n 0.0v 319.745n 0.0v 319.755n 0.0v 324.745n 0.0v 324.755n 0.0v 329.745n 0.0v 329.755n 0.0v 334.745n 0.0v 334.755n 0.0v 339.745n 0.0v 339.755n 0.0v 344.745n 0.0v 344.755n 0.0v 349.745n 0.0v 349.755n 0.0v 354.745n 0.0v 354.755n 0.0v 359.745n 0.0v 359.755n 0.95v 364.745n 0.95v 364.755n 0.0v 369.745n 0.0v 369.755n 0.0v 374.745n 0.0v 374.755n 0.0v 379.745n 0.0v 379.755n 0.0v 384.745n 0.0v 384.755n 0.0v 389.745n 0.0v 389.755n 0.0v 394.745n 0.0v 394.755n 0.0v 399.745n 0.0v 399.755n 0.0v 404.745n 0.0v 404.755n 0.0v 409.745n 0.0v 409.755n 0.0v 414.745n 0.0v 414.755n 0.0v 419.745n 0.0v 419.755n 0.0v 424.745n 0.0v 424.755n 0.0v 429.745n 0.0v 429.755n 0.0v 434.745n 0.0v 434.755n 0.0v 439.745n 0.0v 439.755n 0.95v 444.745n 0.95v 444.755n 0.0v 449.745n 0.0v 449.755n 0.0v 454.745n 0.0v 454.755n 0.0v 459.745n 0.0v 459.755n 0.0v 464.745n 0.0v 464.755n 0.95v 469.745n 0.95v 469.755n 0.95v 474.745n 0.95v 474.755n 0.95v 479.745n 0.95v 479.755n 0.0v 484.745n 0.0v 484.755n 0.0v 489.745n 0.0v 489.755n 0.95v 494.745n 0.95v 494.755n 0.95v 499.745n 0.95v 499.755n 0.95v 504.745n 0.95v 504.755n 0.95v 509.745n 0.95v 509.755n 0.95v 514.745n 0.95v 514.755n 0.95v 519.745n 0.95v 519.755n 0.95v 524.745n 0.95v 524.755n 0.95v 529.745n 0.95v 529.755n 0.95v 534.745n 0.95v 534.755n 0.95v 539.745n 0.95v 539.755n 0.95v 544.745n 0.95v 544.755n 0.95v 549.745n 0.95v 549.755n 0.95v 554.745n 0.95v 554.755n 0.0v 559.745n 0.0v 559.755n 0.0v 564.745n 0.0v 564.755n 0.0v 569.745n 0.0v 569.755n 0.0v 574.745n 0.0v 574.755n 0.0v 579.745n 0.0v 579.755n 0.0v 584.745n 0.0v 584.755n 0.0v 589.745n 0.0v 589.755n 0.0v 594.745n 0.0v 594.755n 0.95v 599.745n 0.95v 599.755n 0.95v 604.745n 0.95v 604.755n 0.95v 609.745n 0.95v 609.755n 0.95v 614.745n 0.95v 614.755n 0.95v 619.745n 0.95v 619.755n 0.95v 624.745n 0.95v 624.755n 0.95v 629.745n 0.95v 629.755n 0.95v 634.745n 0.95v 634.755n 0.95v 639.745n 0.95v 639.755n 0.95v 644.745n 0.95v 644.755n 0.95v 649.745n 0.95v 649.755n 0.95v 654.745n 0.95v 654.755n 0.95v 659.745n 0.95v 659.755n 0.95v 664.745n 0.95v 664.755n 0.95v 669.745n 0.95v 669.755n 0.0v 674.745n 0.0v 674.755n 0.95v 679.745n 0.95v 679.755n 0.95v 684.745n 0.95v 684.755n 0.0v 689.745n 0.0v 689.755n 0.0v 694.745n 0.0v 694.755n 0.0v 699.745n 0.0v 699.755n 0.0v 704.745n 0.0v 704.755n 0.0v 709.745n 0.0v 709.755n 0.0v 714.745n 0.0v 714.755n 0.0v 719.745n 0.0v 719.755n 0.0v 724.745n 0.0v 724.755n 0.0v 729.745n 0.0v 729.755n 0.0v 734.745n 0.0v 734.755n 0.95v 739.745n 0.95v 739.755n 0.95v 744.745n 0.95v 744.755n 0.0v 749.745n 0.0v 749.755n 0.0v 754.745n 0.0v 754.755n 0.0v 759.745n 0.0v 759.755n 0.0v 764.745n 0.0v 764.755n 0.95v 769.745n 0.95v 769.755n 0.95v 774.745n 0.95v 774.755n 0.95v 779.745n 0.95v 779.755n 0.95v 784.745n 0.95v 784.755n 0.95v 789.745n 0.95v 789.755n 0.95v 794.745n 0.95v 794.755n 0.95v 799.745n 0.95v 799.755n 0.95v 804.745n 0.95v 804.755n 0.95v 809.745n 0.95v 809.755n 0.95v 814.745n 0.95v 814.755n 0.95v 819.745n 0.95v 819.755n 0.95v 824.745n 0.95v 824.755n 0.95v 829.745n 0.95v 829.755n 0.95v 834.745n 0.95v 834.755n 0.95v 839.745n 0.95v 839.755n 0.0v 844.745n 0.0v 844.755n 0.95v 849.745n 0.95v 849.755n 0.95v 854.745n 0.95v 854.755n 0.0v 859.745n 0.0v 859.755n 0.0v 864.745n 0.0v 864.755n 0.0v 869.745n 0.0v 869.755n 0.95v 874.745n 0.95v 874.755n 0.95v 879.745n 0.95v 879.755n 0.95v 884.745n 0.95v 884.755n 0.95v 889.745n 0.95v 889.755n 0.0v 894.745n 0.0v 894.755n 0.0v 899.745n 0.0v 899.755n 0.0v 904.745n 0.0v 904.755n 0.0v 909.745n 0.0v 909.755n 0.0v 914.745n 0.0v 914.755n 0.0v 919.745n 0.0v 919.755n 0.0v 924.745n 0.0v 924.755n 0.0v 929.745n 0.0v 929.755n 0.0v 934.745n 0.0v 934.755n 0.95v 939.745n 0.95v 939.755n 0.95v 944.745n 0.95v 944.755n 0.95v 949.745n 0.95v 949.755n 0.0v 954.745n 0.0v 954.755n 0.0v 959.745n 0.0v 959.755n 0.0v 964.745n 0.0v 964.755n 0.0v 969.745n 0.0v 969.755n 0.0v 974.745n 0.0v 974.755n 0.0v 979.745n 0.0v 979.755n 0.95v 984.745n 0.95v 984.755n 0.0v 989.745n 0.0v 989.755n 0.95v 994.745n 0.95v 994.755n 0.95v 999.745n 0.95v 999.755n 0.95v 1004.745n 0.95v 1004.755n 0.0v 1009.745n 0.0v 1009.755n 0.0v 1014.745n 0.0v 1014.755n 0.0v 1019.745n 0.0v 1019.755n 0.0v 1024.745n 0.0v 1024.755n 0.0v )
* (time, data): [(0, 0), (5, 0), (10, 1), (15, 0), (20, 0), (25, 1), (30, 1), (35, 1), (40, 1), (45, 0), (50, 0), (55, 0), (60, 0), (65, 1), (70, 1), (75, 1), (80, 1), (85, 1), (90, 1), (95, 1), (100, 1), (105, 1), (110, 1), (115, 0), (120, 0), (125, 0), (130, 0), (135, 0), (140, 0), (145, 0), (150, 0), (155, 0), (160, 0), (165, 0), (170, 0), (175, 0), (180, 1), (185, 1), (190, 1), (195, 1), (200, 1), (205, 1), (210, 1), (215, 1), (220, 1), (225, 1), (230, 0), (235, 0), (240, 0), (245, 0), (250, 0), (255, 0), (260, 0), (265, 0), (270, 0), (275, 0), (280, 0), (285, 1), (290, 1), (295, 1), (300, 1), (305, 1), (310, 1), (315, 0), (320, 0), (325, 0), (330, 0), (335, 0), (340, 0), (345, 1), (350, 1), (355, 1), (360, 0), (365, 1), (370, 1), (375, 1), (380, 1), (385, 1), (390, 0), (395, 0), (400, 0), (405, 0), (410, 1), (415, 1), (420, 1), (425, 1), (430, 1), (435, 0), (440, 1), (445, 1), (450, 1), (455, 1), (460, 0), (465, 0), (470, 0), (475, 1), (480, 1), (485, 0), (490, 1), (495, 1), (500, 0), (505, 0), (510, 0), (515, 0), (520, 0), (525, 0), (530, 0), (535, 1), (540, 1), (545, 1), (550, 1), (555, 0), (560, 0), (565, 0), (570, 0), (575, 0), (580, 0), (585, 0), (590, 0), (595, 1), (600, 1), (605, 1), (610, 1), (615, 1), (620, 1), (625, 1), (630, 1), (635, 1), (640, 1), (645, 1), (650, 1), (655, 1), (660, 1), (665, 1), (670, 0), (675, 1), (680, 1), (685, 1), (690, 1), (695, 1), (700, 1), (705, 1), (710, 1), (715, 1), (720, 1), (725, 1), (730, 0), (735, 0), (740, 0), (745, 0), (750, 0), (755, 0), (760, 0), (765, 0), (770, 0), (775, 0), (780, 0), (785, 0), (790, 0), (795, 0), (800, 1), (805, 1), (810, 1), (815, 1), (820, 1), (825, 1), (830, 1), (835, 1), (840, 1), (845, 0), (850, 0), (855, 1), (860, 1), (865, 0), (870, 0), (875, 0), (880, 0), (885, 1), (890, 1), (895, 1), (900, 1), (905, 0), (910, 0), (915, 0), (920, 1), (925, 1), (930, 1), (935, 0), (940, 0), (945, 0), (950, 0), (955, 0), (960, 0), (965, 0), (970, 0), (975, 0), (980, 1), (985, 0), (990, 1), (995, 1), (1000, 1), (1005, 1), (1010, 1), (1015, 1), (1020, 1), (1025, 1)]
Vdin0_10  din0_10  0 PWL (0n 0.0v 4.745n 0.0v 4.755n 0.0v 9.745n 0.0v 9.755n 0.95v 14.745n 0.95v 14.755n 0.0v 19.745n 0.0v 19.755n 0.0v 24.745n 0.0v 24.755n 0.95v 29.745n 0.95v 29.755n 0.95v 34.745n 0.95v 34.755n 0.95v 39.745n 0.95v 39.755n 0.95v 44.745n 0.95v 44.755n 0.0v 49.745n 0.0v 49.755n 0.0v 54.745n 0.0v 54.755n 0.0v 59.745n 0.0v 59.755n 0.0v 64.745n 0.0v 64.755n 0.95v 69.745n 0.95v 69.755n 0.95v 74.745n 0.95v 74.755n 0.95v 79.745n 0.95v 79.755n 0.95v 84.745n 0.95v 84.755n 0.95v 89.745n 0.95v 89.755n 0.95v 94.745n 0.95v 94.755n 0.95v 99.745n 0.95v 99.755n 0.95v 104.745n 0.95v 104.755n 0.95v 109.745n 0.95v 109.755n 0.95v 114.745n 0.95v 114.755n 0.0v 119.745n 0.0v 119.755n 0.0v 124.745n 0.0v 124.755n 0.0v 129.745n 0.0v 129.755n 0.0v 134.745n 0.0v 134.755n 0.0v 139.745n 0.0v 139.755n 0.0v 144.745n 0.0v 144.755n 0.0v 149.745n 0.0v 149.755n 0.0v 154.745n 0.0v 154.755n 0.0v 159.745n 0.0v 159.755n 0.0v 164.745n 0.0v 164.755n 0.0v 169.745n 0.0v 169.755n 0.0v 174.745n 0.0v 174.755n 0.0v 179.745n 0.0v 179.755n 0.95v 184.745n 0.95v 184.755n 0.95v 189.745n 0.95v 189.755n 0.95v 194.745n 0.95v 194.755n 0.95v 199.745n 0.95v 199.755n 0.95v 204.745n 0.95v 204.755n 0.95v 209.745n 0.95v 209.755n 0.95v 214.745n 0.95v 214.755n 0.95v 219.745n 0.95v 219.755n 0.95v 224.745n 0.95v 224.755n 0.95v 229.745n 0.95v 229.755n 0.0v 234.745n 0.0v 234.755n 0.0v 239.745n 0.0v 239.755n 0.0v 244.745n 0.0v 244.755n 0.0v 249.745n 0.0v 249.755n 0.0v 254.745n 0.0v 254.755n 0.0v 259.745n 0.0v 259.755n 0.0v 264.745n 0.0v 264.755n 0.0v 269.745n 0.0v 269.755n 0.0v 274.745n 0.0v 274.755n 0.0v 279.745n 0.0v 279.755n 0.0v 284.745n 0.0v 284.755n 0.95v 289.745n 0.95v 289.755n 0.95v 294.745n 0.95v 294.755n 0.95v 299.745n 0.95v 299.755n 0.95v 304.745n 0.95v 304.755n 0.95v 309.745n 0.95v 309.755n 0.95v 314.745n 0.95v 314.755n 0.0v 319.745n 0.0v 319.755n 0.0v 324.745n 0.0v 324.755n 0.0v 329.745n 0.0v 329.755n 0.0v 334.745n 0.0v 334.755n 0.0v 339.745n 0.0v 339.755n 0.0v 344.745n 0.0v 344.755n 0.95v 349.745n 0.95v 349.755n 0.95v 354.745n 0.95v 354.755n 0.95v 359.745n 0.95v 359.755n 0.0v 364.745n 0.0v 364.755n 0.95v 369.745n 0.95v 369.755n 0.95v 374.745n 0.95v 374.755n 0.95v 379.745n 0.95v 379.755n 0.95v 384.745n 0.95v 384.755n 0.95v 389.745n 0.95v 389.755n 0.0v 394.745n 0.0v 394.755n 0.0v 399.745n 0.0v 399.755n 0.0v 404.745n 0.0v 404.755n 0.0v 409.745n 0.0v 409.755n 0.95v 414.745n 0.95v 414.755n 0.95v 419.745n 0.95v 419.755n 0.95v 424.745n 0.95v 424.755n 0.95v 429.745n 0.95v 429.755n 0.95v 434.745n 0.95v 434.755n 0.0v 439.745n 0.0v 439.755n 0.95v 444.745n 0.95v 444.755n 0.95v 449.745n 0.95v 449.755n 0.95v 454.745n 0.95v 454.755n 0.95v 459.745n 0.95v 459.755n 0.0v 464.745n 0.0v 464.755n 0.0v 469.745n 0.0v 469.755n 0.0v 474.745n 0.0v 474.755n 0.95v 479.745n 0.95v 479.755n 0.95v 484.745n 0.95v 484.755n 0.0v 489.745n 0.0v 489.755n 0.95v 494.745n 0.95v 494.755n 0.95v 499.745n 0.95v 499.755n 0.0v 504.745n 0.0v 504.755n 0.0v 509.745n 0.0v 509.755n 0.0v 514.745n 0.0v 514.755n 0.0v 519.745n 0.0v 519.755n 0.0v 524.745n 0.0v 524.755n 0.0v 529.745n 0.0v 529.755n 0.0v 534.745n 0.0v 534.755n 0.95v 539.745n 0.95v 539.755n 0.95v 544.745n 0.95v 544.755n 0.95v 549.745n 0.95v 549.755n 0.95v 554.745n 0.95v 554.755n 0.0v 559.745n 0.0v 559.755n 0.0v 564.745n 0.0v 564.755n 0.0v 569.745n 0.0v 569.755n 0.0v 574.745n 0.0v 574.755n 0.0v 579.745n 0.0v 579.755n 0.0v 584.745n 0.0v 584.755n 0.0v 589.745n 0.0v 589.755n 0.0v 594.745n 0.0v 594.755n 0.95v 599.745n 0.95v 599.755n 0.95v 604.745n 0.95v 604.755n 0.95v 609.745n 0.95v 609.755n 0.95v 614.745n 0.95v 614.755n 0.95v 619.745n 0.95v 619.755n 0.95v 624.745n 0.95v 624.755n 0.95v 629.745n 0.95v 629.755n 0.95v 634.745n 0.95v 634.755n 0.95v 639.745n 0.95v 639.755n 0.95v 644.745n 0.95v 644.755n 0.95v 649.745n 0.95v 649.755n 0.95v 654.745n 0.95v 654.755n 0.95v 659.745n 0.95v 659.755n 0.95v 664.745n 0.95v 664.755n 0.95v 669.745n 0.95v 669.755n 0.0v 674.745n 0.0v 674.755n 0.95v 679.745n 0.95v 679.755n 0.95v 684.745n 0.95v 684.755n 0.95v 689.745n 0.95v 689.755n 0.95v 694.745n 0.95v 694.755n 0.95v 699.745n 0.95v 699.755n 0.95v 704.745n 0.95v 704.755n 0.95v 709.745n 0.95v 709.755n 0.95v 714.745n 0.95v 714.755n 0.95v 719.745n 0.95v 719.755n 0.95v 724.745n 0.95v 724.755n 0.95v 729.745n 0.95v 729.755n 0.0v 734.745n 0.0v 734.755n 0.0v 739.745n 0.0v 739.755n 0.0v 744.745n 0.0v 744.755n 0.0v 749.745n 0.0v 749.755n 0.0v 754.745n 0.0v 754.755n 0.0v 759.745n 0.0v 759.755n 0.0v 764.745n 0.0v 764.755n 0.0v 769.745n 0.0v 769.755n 0.0v 774.745n 0.0v 774.755n 0.0v 779.745n 0.0v 779.755n 0.0v 784.745n 0.0v 784.755n 0.0v 789.745n 0.0v 789.755n 0.0v 794.745n 0.0v 794.755n 0.0v 799.745n 0.0v 799.755n 0.95v 804.745n 0.95v 804.755n 0.95v 809.745n 0.95v 809.755n 0.95v 814.745n 0.95v 814.755n 0.95v 819.745n 0.95v 819.755n 0.95v 824.745n 0.95v 824.755n 0.95v 829.745n 0.95v 829.755n 0.95v 834.745n 0.95v 834.755n 0.95v 839.745n 0.95v 839.755n 0.95v 844.745n 0.95v 844.755n 0.0v 849.745n 0.0v 849.755n 0.0v 854.745n 0.0v 854.755n 0.95v 859.745n 0.95v 859.755n 0.95v 864.745n 0.95v 864.755n 0.0v 869.745n 0.0v 869.755n 0.0v 874.745n 0.0v 874.755n 0.0v 879.745n 0.0v 879.755n 0.0v 884.745n 0.0v 884.755n 0.95v 889.745n 0.95v 889.755n 0.95v 894.745n 0.95v 894.755n 0.95v 899.745n 0.95v 899.755n 0.95v 904.745n 0.95v 904.755n 0.0v 909.745n 0.0v 909.755n 0.0v 914.745n 0.0v 914.755n 0.0v 919.745n 0.0v 919.755n 0.95v 924.745n 0.95v 924.755n 0.95v 929.745n 0.95v 929.755n 0.95v 934.745n 0.95v 934.755n 0.0v 939.745n 0.0v 939.755n 0.0v 944.745n 0.0v 944.755n 0.0v 949.745n 0.0v 949.755n 0.0v 954.745n 0.0v 954.755n 0.0v 959.745n 0.0v 959.755n 0.0v 964.745n 0.0v 964.755n 0.0v 969.745n 0.0v 969.755n 0.0v 974.745n 0.0v 974.755n 0.0v 979.745n 0.0v 979.755n 0.95v 984.745n 0.95v 984.755n 0.0v 989.745n 0.0v 989.755n 0.95v 994.745n 0.95v 994.755n 0.95v 999.745n 0.95v 999.755n 0.95v 1004.745n 0.95v 1004.755n 0.95v 1009.745n 0.95v 1009.755n 0.95v 1014.745n 0.95v 1014.755n 0.95v 1019.745n 0.95v 1019.755n 0.95v 1024.745n 0.95v 1024.755n 0.95v )
* (time, data): [(0, 0), (5, 1), (10, 1), (15, 1), (20, 1), (25, 1), (30, 1), (35, 0), (40, 1), (45, 0), (50, 0), (55, 0), (60, 0), (65, 1), (70, 1), (75, 1), (80, 1), (85, 0), (90, 0), (95, 0), (100, 0), (105, 1), (110, 1), (115, 1), (120, 1), (125, 0), (130, 0), (135, 0), (140, 0), (145, 0), (150, 0), (155, 0), (160, 0), (165, 1), (170, 1), (175, 1), (180, 0), (185, 0), (190, 0), (195, 0), (200, 0), (205, 0), (210, 0), (215, 0), (220, 0), (225, 0), (230, 1), (235, 1), (240, 1), (245, 1), (250, 1), (255, 1), (260, 1), (265, 0), (270, 1), (275, 1), (280, 1), (285, 0), (290, 0), (295, 0), (300, 0), (305, 0), (310, 0), (315, 1), (320, 1), (325, 1), (330, 1), (335, 1), (340, 1), (345, 1), (350, 1), (355, 1), (360, 0), (365, 1), (370, 1), (375, 1), (380, 1), (385, 1), (390, 1), (395, 1), (400, 1), (405, 1), (410, 1), (415, 1), (420, 1), (425, 1), (430, 1), (435, 1), (440, 1), (445, 0), (450, 0), (455, 0), (460, 1), (465, 0), (470, 0), (475, 0), (480, 0), (485, 1), (490, 1), (495, 1), (500, 1), (505, 1), (510, 1), (515, 1), (520, 1), (525, 1), (530, 1), (535, 0), (540, 0), (545, 0), (550, 0), (555, 1), (560, 0), (565, 0), (570, 0), (575, 0), (580, 0), (585, 0), (590, 0), (595, 0), (600, 0), (605, 0), (610, 0), (615, 0), (620, 0), (625, 0), (630, 0), (635, 0), (640, 1), (645, 0), (650, 0), (655, 0), (660, 0), (665, 0), (670, 1), (675, 1), (680, 1), (685, 0), (690, 0), (695, 0), (700, 0), (705, 0), (710, 0), (715, 0), (720, 1), (725, 1), (730, 1), (735, 1), (740, 1), (745, 1), (750, 1), (755, 1), (760, 1), (765, 0), (770, 0), (775, 0), (780, 0), (785, 0), (790, 0), (795, 0), (800, 0), (805, 0), (810, 0), (815, 0), (820, 0), (825, 0), (830, 0), (835, 0), (840, 0), (845, 0), (850, 0), (855, 0), (860, 0), (865, 0), (870, 0), (875, 0), (880, 0), (885, 0), (890, 0), (895, 0), (900, 0), (905, 1), (910, 0), (915, 0), (920, 0), (925, 1), (930, 1), (935, 1), (940, 1), (945, 1), (950, 1), (955, 1), (960, 1), (965, 1), (970, 0), (975, 0), (980, 0), (985, 1), (990, 0), (995, 0), (1000, 0), (1005, 1), (1010, 1), (1015, 1), (1020, 1), (1025, 1)]
Vdin0_11  din0_11  0 PWL (0n 0.0v 4.745n 0.0v 4.755n 0.95v 9.745n 0.95v 9.755n 0.95v 14.745n 0.95v 14.755n 0.95v 19.745n 0.95v 19.755n 0.95v 24.745n 0.95v 24.755n 0.95v 29.745n 0.95v 29.755n 0.95v 34.745n 0.95v 34.755n 0.0v 39.745n 0.0v 39.755n 0.95v 44.745n 0.95v 44.755n 0.0v 49.745n 0.0v 49.755n 0.0v 54.745n 0.0v 54.755n 0.0v 59.745n 0.0v 59.755n 0.0v 64.745n 0.0v 64.755n 0.95v 69.745n 0.95v 69.755n 0.95v 74.745n 0.95v 74.755n 0.95v 79.745n 0.95v 79.755n 0.95v 84.745n 0.95v 84.755n 0.0v 89.745n 0.0v 89.755n 0.0v 94.745n 0.0v 94.755n 0.0v 99.745n 0.0v 99.755n 0.0v 104.745n 0.0v 104.755n 0.95v 109.745n 0.95v 109.755n 0.95v 114.745n 0.95v 114.755n 0.95v 119.745n 0.95v 119.755n 0.95v 124.745n 0.95v 124.755n 0.0v 129.745n 0.0v 129.755n 0.0v 134.745n 0.0v 134.755n 0.0v 139.745n 0.0v 139.755n 0.0v 144.745n 0.0v 144.755n 0.0v 149.745n 0.0v 149.755n 0.0v 154.745n 0.0v 154.755n 0.0v 159.745n 0.0v 159.755n 0.0v 164.745n 0.0v 164.755n 0.95v 169.745n 0.95v 169.755n 0.95v 174.745n 0.95v 174.755n 0.95v 179.745n 0.95v 179.755n 0.0v 184.745n 0.0v 184.755n 0.0v 189.745n 0.0v 189.755n 0.0v 194.745n 0.0v 194.755n 0.0v 199.745n 0.0v 199.755n 0.0v 204.745n 0.0v 204.755n 0.0v 209.745n 0.0v 209.755n 0.0v 214.745n 0.0v 214.755n 0.0v 219.745n 0.0v 219.755n 0.0v 224.745n 0.0v 224.755n 0.0v 229.745n 0.0v 229.755n 0.95v 234.745n 0.95v 234.755n 0.95v 239.745n 0.95v 239.755n 0.95v 244.745n 0.95v 244.755n 0.95v 249.745n 0.95v 249.755n 0.95v 254.745n 0.95v 254.755n 0.95v 259.745n 0.95v 259.755n 0.95v 264.745n 0.95v 264.755n 0.0v 269.745n 0.0v 269.755n 0.95v 274.745n 0.95v 274.755n 0.95v 279.745n 0.95v 279.755n 0.95v 284.745n 0.95v 284.755n 0.0v 289.745n 0.0v 289.755n 0.0v 294.745n 0.0v 294.755n 0.0v 299.745n 0.0v 299.755n 0.0v 304.745n 0.0v 304.755n 0.0v 309.745n 0.0v 309.755n 0.0v 314.745n 0.0v 314.755n 0.95v 319.745n 0.95v 319.755n 0.95v 324.745n 0.95v 324.755n 0.95v 329.745n 0.95v 329.755n 0.95v 334.745n 0.95v 334.755n 0.95v 339.745n 0.95v 339.755n 0.95v 344.745n 0.95v 344.755n 0.95v 349.745n 0.95v 349.755n 0.95v 354.745n 0.95v 354.755n 0.95v 359.745n 0.95v 359.755n 0.0v 364.745n 0.0v 364.755n 0.95v 369.745n 0.95v 369.755n 0.95v 374.745n 0.95v 374.755n 0.95v 379.745n 0.95v 379.755n 0.95v 384.745n 0.95v 384.755n 0.95v 389.745n 0.95v 389.755n 0.95v 394.745n 0.95v 394.755n 0.95v 399.745n 0.95v 399.755n 0.95v 404.745n 0.95v 404.755n 0.95v 409.745n 0.95v 409.755n 0.95v 414.745n 0.95v 414.755n 0.95v 419.745n 0.95v 419.755n 0.95v 424.745n 0.95v 424.755n 0.95v 429.745n 0.95v 429.755n 0.95v 434.745n 0.95v 434.755n 0.95v 439.745n 0.95v 439.755n 0.95v 444.745n 0.95v 444.755n 0.0v 449.745n 0.0v 449.755n 0.0v 454.745n 0.0v 454.755n 0.0v 459.745n 0.0v 459.755n 0.95v 464.745n 0.95v 464.755n 0.0v 469.745n 0.0v 469.755n 0.0v 474.745n 0.0v 474.755n 0.0v 479.745n 0.0v 479.755n 0.0v 484.745n 0.0v 484.755n 0.95v 489.745n 0.95v 489.755n 0.95v 494.745n 0.95v 494.755n 0.95v 499.745n 0.95v 499.755n 0.95v 504.745n 0.95v 504.755n 0.95v 509.745n 0.95v 509.755n 0.95v 514.745n 0.95v 514.755n 0.95v 519.745n 0.95v 519.755n 0.95v 524.745n 0.95v 524.755n 0.95v 529.745n 0.95v 529.755n 0.95v 534.745n 0.95v 534.755n 0.0v 539.745n 0.0v 539.755n 0.0v 544.745n 0.0v 544.755n 0.0v 549.745n 0.0v 549.755n 0.0v 554.745n 0.0v 554.755n 0.95v 559.745n 0.95v 559.755n 0.0v 564.745n 0.0v 564.755n 0.0v 569.745n 0.0v 569.755n 0.0v 574.745n 0.0v 574.755n 0.0v 579.745n 0.0v 579.755n 0.0v 584.745n 0.0v 584.755n 0.0v 589.745n 0.0v 589.755n 0.0v 594.745n 0.0v 594.755n 0.0v 599.745n 0.0v 599.755n 0.0v 604.745n 0.0v 604.755n 0.0v 609.745n 0.0v 609.755n 0.0v 614.745n 0.0v 614.755n 0.0v 619.745n 0.0v 619.755n 0.0v 624.745n 0.0v 624.755n 0.0v 629.745n 0.0v 629.755n 0.0v 634.745n 0.0v 634.755n 0.0v 639.745n 0.0v 639.755n 0.95v 644.745n 0.95v 644.755n 0.0v 649.745n 0.0v 649.755n 0.0v 654.745n 0.0v 654.755n 0.0v 659.745n 0.0v 659.755n 0.0v 664.745n 0.0v 664.755n 0.0v 669.745n 0.0v 669.755n 0.95v 674.745n 0.95v 674.755n 0.95v 679.745n 0.95v 679.755n 0.95v 684.745n 0.95v 684.755n 0.0v 689.745n 0.0v 689.755n 0.0v 694.745n 0.0v 694.755n 0.0v 699.745n 0.0v 699.755n 0.0v 704.745n 0.0v 704.755n 0.0v 709.745n 0.0v 709.755n 0.0v 714.745n 0.0v 714.755n 0.0v 719.745n 0.0v 719.755n 0.95v 724.745n 0.95v 724.755n 0.95v 729.745n 0.95v 729.755n 0.95v 734.745n 0.95v 734.755n 0.95v 739.745n 0.95v 739.755n 0.95v 744.745n 0.95v 744.755n 0.95v 749.745n 0.95v 749.755n 0.95v 754.745n 0.95v 754.755n 0.95v 759.745n 0.95v 759.755n 0.95v 764.745n 0.95v 764.755n 0.0v 769.745n 0.0v 769.755n 0.0v 774.745n 0.0v 774.755n 0.0v 779.745n 0.0v 779.755n 0.0v 784.745n 0.0v 784.755n 0.0v 789.745n 0.0v 789.755n 0.0v 794.745n 0.0v 794.755n 0.0v 799.745n 0.0v 799.755n 0.0v 804.745n 0.0v 804.755n 0.0v 809.745n 0.0v 809.755n 0.0v 814.745n 0.0v 814.755n 0.0v 819.745n 0.0v 819.755n 0.0v 824.745n 0.0v 824.755n 0.0v 829.745n 0.0v 829.755n 0.0v 834.745n 0.0v 834.755n 0.0v 839.745n 0.0v 839.755n 0.0v 844.745n 0.0v 844.755n 0.0v 849.745n 0.0v 849.755n 0.0v 854.745n 0.0v 854.755n 0.0v 859.745n 0.0v 859.755n 0.0v 864.745n 0.0v 864.755n 0.0v 869.745n 0.0v 869.755n 0.0v 874.745n 0.0v 874.755n 0.0v 879.745n 0.0v 879.755n 0.0v 884.745n 0.0v 884.755n 0.0v 889.745n 0.0v 889.755n 0.0v 894.745n 0.0v 894.755n 0.0v 899.745n 0.0v 899.755n 0.0v 904.745n 0.0v 904.755n 0.95v 909.745n 0.95v 909.755n 0.0v 914.745n 0.0v 914.755n 0.0v 919.745n 0.0v 919.755n 0.0v 924.745n 0.0v 924.755n 0.95v 929.745n 0.95v 929.755n 0.95v 934.745n 0.95v 934.755n 0.95v 939.745n 0.95v 939.755n 0.95v 944.745n 0.95v 944.755n 0.95v 949.745n 0.95v 949.755n 0.95v 954.745n 0.95v 954.755n 0.95v 959.745n 0.95v 959.755n 0.95v 964.745n 0.95v 964.755n 0.95v 969.745n 0.95v 969.755n 0.0v 974.745n 0.0v 974.755n 0.0v 979.745n 0.0v 979.755n 0.0v 984.745n 0.0v 984.755n 0.95v 989.745n 0.95v 989.755n 0.0v 994.745n 0.0v 994.755n 0.0v 999.745n 0.0v 999.755n 0.0v 1004.745n 0.0v 1004.755n 0.95v 1009.745n 0.95v 1009.755n 0.95v 1014.745n 0.95v 1014.755n 0.95v 1019.745n 0.95v 1019.755n 0.95v 1024.745n 0.95v 1024.755n 0.95v )
* (time, data): [(0, 0), (5, 0), (10, 1), (15, 1), (20, 1), (25, 1), (30, 1), (35, 1), (40, 0), (45, 1), (50, 1), (55, 1), (60, 0), (65, 0), (70, 0), (75, 0), (80, 1), (85, 1), (90, 1), (95, 1), (100, 1), (105, 1), (110, 1), (115, 1), (120, 1), (125, 0), (130, 1), (135, 1), (140, 1), (145, 1), (150, 1), (155, 1), (160, 1), (165, 1), (170, 1), (175, 1), (180, 1), (185, 0), (190, 0), (195, 0), (200, 1), (205, 1), (210, 1), (215, 1), (220, 1), (225, 1), (230, 0), (235, 0), (240, 0), (245, 1), (250, 1), (255, 1), (260, 1), (265, 0), (270, 0), (275, 0), (280, 0), (285, 1), (290, 1), (295, 1), (300, 1), (305, 1), (310, 1), (315, 0), (320, 0), (325, 0), (330, 0), (335, 0), (340, 0), (345, 1), (350, 1), (355, 1), (360, 0), (365, 1), (370, 1), (375, 1), (380, 1), (385, 1), (390, 1), (395, 1), (400, 1), (405, 1), (410, 1), (415, 1), (420, 1), (425, 1), (430, 1), (435, 1), (440, 0), (445, 1), (450, 1), (455, 1), (460, 1), (465, 1), (470, 1), (475, 0), (480, 1), (485, 0), (490, 1), (495, 1), (500, 1), (505, 1), (510, 1), (515, 1), (520, 0), (525, 0), (530, 1), (535, 0), (540, 0), (545, 0), (550, 0), (555, 0), (560, 0), (565, 0), (570, 0), (575, 0), (580, 0), (585, 0), (590, 0), (595, 1), (600, 1), (605, 1), (610, 1), (615, 1), (620, 1), (625, 1), (630, 1), (635, 1), (640, 1), (645, 1), (650, 1), (655, 1), (660, 1), (665, 1), (670, 0), (675, 0), (680, 0), (685, 1), (690, 1), (695, 1), (700, 1), (705, 1), (710, 1), (715, 1), (720, 1), (725, 1), (730, 0), (735, 0), (740, 0), (745, 1), (750, 1), (755, 1), (760, 1), (765, 1), (770, 1), (775, 1), (780, 1), (785, 1), (790, 1), (795, 1), (800, 1), (805, 1), (810, 1), (815, 1), (820, 1), (825, 1), (830, 1), (835, 1), (840, 1), (845, 1), (850, 1), (855, 0), (860, 0), (865, 0), (870, 1), (875, 1), (880, 1), (885, 0), (890, 1), (895, 1), (900, 1), (905, 0), (910, 1), (915, 1), (920, 0), (925, 0), (930, 0), (935, 1), (940, 1), (945, 1), (950, 0), (955, 1), (960, 1), (965, 1), (970, 1), (975, 1), (980, 0), (985, 1), (990, 0), (995, 0), (1000, 0), (1005, 1), (1010, 1), (1015, 1), (1020, 1), (1025, 1)]
Vdin0_12  din0_12  0 PWL (0n 0.0v 4.745n 0.0v 4.755n 0.0v 9.745n 0.0v 9.755n 0.95v 14.745n 0.95v 14.755n 0.95v 19.745n 0.95v 19.755n 0.95v 24.745n 0.95v 24.755n 0.95v 29.745n 0.95v 29.755n 0.95v 34.745n 0.95v 34.755n 0.95v 39.745n 0.95v 39.755n 0.0v 44.745n 0.0v 44.755n 0.95v 49.745n 0.95v 49.755n 0.95v 54.745n 0.95v 54.755n 0.95v 59.745n 0.95v 59.755n 0.0v 64.745n 0.0v 64.755n 0.0v 69.745n 0.0v 69.755n 0.0v 74.745n 0.0v 74.755n 0.0v 79.745n 0.0v 79.755n 0.95v 84.745n 0.95v 84.755n 0.95v 89.745n 0.95v 89.755n 0.95v 94.745n 0.95v 94.755n 0.95v 99.745n 0.95v 99.755n 0.95v 104.745n 0.95v 104.755n 0.95v 109.745n 0.95v 109.755n 0.95v 114.745n 0.95v 114.755n 0.95v 119.745n 0.95v 119.755n 0.95v 124.745n 0.95v 124.755n 0.0v 129.745n 0.0v 129.755n 0.95v 134.745n 0.95v 134.755n 0.95v 139.745n 0.95v 139.755n 0.95v 144.745n 0.95v 144.755n 0.95v 149.745n 0.95v 149.755n 0.95v 154.745n 0.95v 154.755n 0.95v 159.745n 0.95v 159.755n 0.95v 164.745n 0.95v 164.755n 0.95v 169.745n 0.95v 169.755n 0.95v 174.745n 0.95v 174.755n 0.95v 179.745n 0.95v 179.755n 0.95v 184.745n 0.95v 184.755n 0.0v 189.745n 0.0v 189.755n 0.0v 194.745n 0.0v 194.755n 0.0v 199.745n 0.0v 199.755n 0.95v 204.745n 0.95v 204.755n 0.95v 209.745n 0.95v 209.755n 0.95v 214.745n 0.95v 214.755n 0.95v 219.745n 0.95v 219.755n 0.95v 224.745n 0.95v 224.755n 0.95v 229.745n 0.95v 229.755n 0.0v 234.745n 0.0v 234.755n 0.0v 239.745n 0.0v 239.755n 0.0v 244.745n 0.0v 244.755n 0.95v 249.745n 0.95v 249.755n 0.95v 254.745n 0.95v 254.755n 0.95v 259.745n 0.95v 259.755n 0.95v 264.745n 0.95v 264.755n 0.0v 269.745n 0.0v 269.755n 0.0v 274.745n 0.0v 274.755n 0.0v 279.745n 0.0v 279.755n 0.0v 284.745n 0.0v 284.755n 0.95v 289.745n 0.95v 289.755n 0.95v 294.745n 0.95v 294.755n 0.95v 299.745n 0.95v 299.755n 0.95v 304.745n 0.95v 304.755n 0.95v 309.745n 0.95v 309.755n 0.95v 314.745n 0.95v 314.755n 0.0v 319.745n 0.0v 319.755n 0.0v 324.745n 0.0v 324.755n 0.0v 329.745n 0.0v 329.755n 0.0v 334.745n 0.0v 334.755n 0.0v 339.745n 0.0v 339.755n 0.0v 344.745n 0.0v 344.755n 0.95v 349.745n 0.95v 349.755n 0.95v 354.745n 0.95v 354.755n 0.95v 359.745n 0.95v 359.755n 0.0v 364.745n 0.0v 364.755n 0.95v 369.745n 0.95v 369.755n 0.95v 374.745n 0.95v 374.755n 0.95v 379.745n 0.95v 379.755n 0.95v 384.745n 0.95v 384.755n 0.95v 389.745n 0.95v 389.755n 0.95v 394.745n 0.95v 394.755n 0.95v 399.745n 0.95v 399.755n 0.95v 404.745n 0.95v 404.755n 0.95v 409.745n 0.95v 409.755n 0.95v 414.745n 0.95v 414.755n 0.95v 419.745n 0.95v 419.755n 0.95v 424.745n 0.95v 424.755n 0.95v 429.745n 0.95v 429.755n 0.95v 434.745n 0.95v 434.755n 0.95v 439.745n 0.95v 439.755n 0.0v 444.745n 0.0v 444.755n 0.95v 449.745n 0.95v 449.755n 0.95v 454.745n 0.95v 454.755n 0.95v 459.745n 0.95v 459.755n 0.95v 464.745n 0.95v 464.755n 0.95v 469.745n 0.95v 469.755n 0.95v 474.745n 0.95v 474.755n 0.0v 479.745n 0.0v 479.755n 0.95v 484.745n 0.95v 484.755n 0.0v 489.745n 0.0v 489.755n 0.95v 494.745n 0.95v 494.755n 0.95v 499.745n 0.95v 499.755n 0.95v 504.745n 0.95v 504.755n 0.95v 509.745n 0.95v 509.755n 0.95v 514.745n 0.95v 514.755n 0.95v 519.745n 0.95v 519.755n 0.0v 524.745n 0.0v 524.755n 0.0v 529.745n 0.0v 529.755n 0.95v 534.745n 0.95v 534.755n 0.0v 539.745n 0.0v 539.755n 0.0v 544.745n 0.0v 544.755n 0.0v 549.745n 0.0v 549.755n 0.0v 554.745n 0.0v 554.755n 0.0v 559.745n 0.0v 559.755n 0.0v 564.745n 0.0v 564.755n 0.0v 569.745n 0.0v 569.755n 0.0v 574.745n 0.0v 574.755n 0.0v 579.745n 0.0v 579.755n 0.0v 584.745n 0.0v 584.755n 0.0v 589.745n 0.0v 589.755n 0.0v 594.745n 0.0v 594.755n 0.95v 599.745n 0.95v 599.755n 0.95v 604.745n 0.95v 604.755n 0.95v 609.745n 0.95v 609.755n 0.95v 614.745n 0.95v 614.755n 0.95v 619.745n 0.95v 619.755n 0.95v 624.745n 0.95v 624.755n 0.95v 629.745n 0.95v 629.755n 0.95v 634.745n 0.95v 634.755n 0.95v 639.745n 0.95v 639.755n 0.95v 644.745n 0.95v 644.755n 0.95v 649.745n 0.95v 649.755n 0.95v 654.745n 0.95v 654.755n 0.95v 659.745n 0.95v 659.755n 0.95v 664.745n 0.95v 664.755n 0.95v 669.745n 0.95v 669.755n 0.0v 674.745n 0.0v 674.755n 0.0v 679.745n 0.0v 679.755n 0.0v 684.745n 0.0v 684.755n 0.95v 689.745n 0.95v 689.755n 0.95v 694.745n 0.95v 694.755n 0.95v 699.745n 0.95v 699.755n 0.95v 704.745n 0.95v 704.755n 0.95v 709.745n 0.95v 709.755n 0.95v 714.745n 0.95v 714.755n 0.95v 719.745n 0.95v 719.755n 0.95v 724.745n 0.95v 724.755n 0.95v 729.745n 0.95v 729.755n 0.0v 734.745n 0.0v 734.755n 0.0v 739.745n 0.0v 739.755n 0.0v 744.745n 0.0v 744.755n 0.95v 749.745n 0.95v 749.755n 0.95v 754.745n 0.95v 754.755n 0.95v 759.745n 0.95v 759.755n 0.95v 764.745n 0.95v 764.755n 0.95v 769.745n 0.95v 769.755n 0.95v 774.745n 0.95v 774.755n 0.95v 779.745n 0.95v 779.755n 0.95v 784.745n 0.95v 784.755n 0.95v 789.745n 0.95v 789.755n 0.95v 794.745n 0.95v 794.755n 0.95v 799.745n 0.95v 799.755n 0.95v 804.745n 0.95v 804.755n 0.95v 809.745n 0.95v 809.755n 0.95v 814.745n 0.95v 814.755n 0.95v 819.745n 0.95v 819.755n 0.95v 824.745n 0.95v 824.755n 0.95v 829.745n 0.95v 829.755n 0.95v 834.745n 0.95v 834.755n 0.95v 839.745n 0.95v 839.755n 0.95v 844.745n 0.95v 844.755n 0.95v 849.745n 0.95v 849.755n 0.95v 854.745n 0.95v 854.755n 0.0v 859.745n 0.0v 859.755n 0.0v 864.745n 0.0v 864.755n 0.0v 869.745n 0.0v 869.755n 0.95v 874.745n 0.95v 874.755n 0.95v 879.745n 0.95v 879.755n 0.95v 884.745n 0.95v 884.755n 0.0v 889.745n 0.0v 889.755n 0.95v 894.745n 0.95v 894.755n 0.95v 899.745n 0.95v 899.755n 0.95v 904.745n 0.95v 904.755n 0.0v 909.745n 0.0v 909.755n 0.95v 914.745n 0.95v 914.755n 0.95v 919.745n 0.95v 919.755n 0.0v 924.745n 0.0v 924.755n 0.0v 929.745n 0.0v 929.755n 0.0v 934.745n 0.0v 934.755n 0.95v 939.745n 0.95v 939.755n 0.95v 944.745n 0.95v 944.755n 0.95v 949.745n 0.95v 949.755n 0.0v 954.745n 0.0v 954.755n 0.95v 959.745n 0.95v 959.755n 0.95v 964.745n 0.95v 964.755n 0.95v 969.745n 0.95v 969.755n 0.95v 974.745n 0.95v 974.755n 0.95v 979.745n 0.95v 979.755n 0.0v 984.745n 0.0v 984.755n 0.95v 989.745n 0.95v 989.755n 0.0v 994.745n 0.0v 994.755n 0.0v 999.745n 0.0v 999.755n 0.0v 1004.745n 0.0v 1004.755n 0.95v 1009.745n 0.95v 1009.755n 0.95v 1014.745n 0.95v 1014.755n 0.95v 1019.745n 0.95v 1019.755n 0.95v 1024.745n 0.95v 1024.755n 0.95v )
* (time, data): [(0, 0), (5, 1), (10, 0), (15, 1), (20, 1), (25, 0), (30, 0), (35, 1), (40, 1), (45, 0), (50, 0), (55, 0), (60, 0), (65, 1), (70, 1), (75, 1), (80, 1), (85, 0), (90, 0), (95, 1), (100, 1), (105, 1), (110, 1), (115, 1), (120, 1), (125, 1), (130, 1), (135, 1), (140, 1), (145, 1), (150, 1), (155, 1), (160, 1), (165, 0), (170, 0), (175, 0), (180, 0), (185, 1), (190, 1), (195, 1), (200, 1), (205, 1), (210, 1), (215, 1), (220, 1), (225, 1), (230, 1), (235, 1), (240, 1), (245, 0), (250, 0), (255, 0), (260, 0), (265, 0), (270, 0), (275, 0), (280, 0), (285, 0), (290, 0), (295, 0), (300, 1), (305, 1), (310, 1), (315, 0), (320, 0), (325, 0), (330, 0), (335, 0), (340, 0), (345, 0), (350, 0), (355, 0), (360, 0), (365, 0), (370, 0), (375, 0), (380, 0), (385, 0), (390, 1), (395, 1), (400, 1), (405, 1), (410, 1), (415, 1), (420, 1), (425, 0), (430, 0), (435, 0), (440, 0), (445, 1), (450, 1), (455, 1), (460, 0), (465, 1), (470, 1), (475, 0), (480, 0), (485, 1), (490, 0), (495, 0), (500, 0), (505, 0), (510, 0), (515, 0), (520, 0), (525, 0), (530, 1), (535, 0), (540, 1), (545, 1), (550, 1), (555, 0), (560, 1), (565, 1), (570, 1), (575, 1), (580, 1), (585, 1), (590, 1), (595, 1), (600, 1), (605, 1), (610, 1), (615, 1), (620, 1), (625, 1), (630, 1), (635, 1), (640, 1), (645, 0), (650, 0), (655, 0), (660, 0), (665, 0), (670, 1), (675, 1), (680, 1), (685, 0), (690, 0), (695, 0), (700, 0), (705, 0), (710, 0), (715, 0), (720, 1), (725, 1), (730, 1), (735, 0), (740, 0), (745, 1), (750, 1), (755, 1), (760, 1), (765, 1), (770, 1), (775, 1), (780, 1), (785, 1), (790, 1), (795, 1), (800, 0), (805, 0), (810, 0), (815, 0), (820, 0), (825, 0), (830, 0), (835, 0), (840, 1), (845, 0), (850, 0), (855, 1), (860, 1), (865, 1), (870, 0), (875, 0), (880, 0), (885, 0), (890, 0), (895, 0), (900, 0), (905, 0), (910, 0), (915, 0), (920, 1), (925, 1), (930, 1), (935, 1), (940, 1), (945, 1), (950, 0), (955, 0), (960, 0), (965, 0), (970, 0), (975, 0), (980, 0), (985, 0), (990, 1), (995, 1), (1000, 1), (1005, 1), (1010, 1), (1015, 1), (1020, 1), (1025, 1)]
Vdin0_13  din0_13  0 PWL (0n 0.0v 4.745n 0.0v 4.755n 0.95v 9.745n 0.95v 9.755n 0.0v 14.745n 0.0v 14.755n 0.95v 19.745n 0.95v 19.755n 0.95v 24.745n 0.95v 24.755n 0.0v 29.745n 0.0v 29.755n 0.0v 34.745n 0.0v 34.755n 0.95v 39.745n 0.95v 39.755n 0.95v 44.745n 0.95v 44.755n 0.0v 49.745n 0.0v 49.755n 0.0v 54.745n 0.0v 54.755n 0.0v 59.745n 0.0v 59.755n 0.0v 64.745n 0.0v 64.755n 0.95v 69.745n 0.95v 69.755n 0.95v 74.745n 0.95v 74.755n 0.95v 79.745n 0.95v 79.755n 0.95v 84.745n 0.95v 84.755n 0.0v 89.745n 0.0v 89.755n 0.0v 94.745n 0.0v 94.755n 0.95v 99.745n 0.95v 99.755n 0.95v 104.745n 0.95v 104.755n 0.95v 109.745n 0.95v 109.755n 0.95v 114.745n 0.95v 114.755n 0.95v 119.745n 0.95v 119.755n 0.95v 124.745n 0.95v 124.755n 0.95v 129.745n 0.95v 129.755n 0.95v 134.745n 0.95v 134.755n 0.95v 139.745n 0.95v 139.755n 0.95v 144.745n 0.95v 144.755n 0.95v 149.745n 0.95v 149.755n 0.95v 154.745n 0.95v 154.755n 0.95v 159.745n 0.95v 159.755n 0.95v 164.745n 0.95v 164.755n 0.0v 169.745n 0.0v 169.755n 0.0v 174.745n 0.0v 174.755n 0.0v 179.745n 0.0v 179.755n 0.0v 184.745n 0.0v 184.755n 0.95v 189.745n 0.95v 189.755n 0.95v 194.745n 0.95v 194.755n 0.95v 199.745n 0.95v 199.755n 0.95v 204.745n 0.95v 204.755n 0.95v 209.745n 0.95v 209.755n 0.95v 214.745n 0.95v 214.755n 0.95v 219.745n 0.95v 219.755n 0.95v 224.745n 0.95v 224.755n 0.95v 229.745n 0.95v 229.755n 0.95v 234.745n 0.95v 234.755n 0.95v 239.745n 0.95v 239.755n 0.95v 244.745n 0.95v 244.755n 0.0v 249.745n 0.0v 249.755n 0.0v 254.745n 0.0v 254.755n 0.0v 259.745n 0.0v 259.755n 0.0v 264.745n 0.0v 264.755n 0.0v 269.745n 0.0v 269.755n 0.0v 274.745n 0.0v 274.755n 0.0v 279.745n 0.0v 279.755n 0.0v 284.745n 0.0v 284.755n 0.0v 289.745n 0.0v 289.755n 0.0v 294.745n 0.0v 294.755n 0.0v 299.745n 0.0v 299.755n 0.95v 304.745n 0.95v 304.755n 0.95v 309.745n 0.95v 309.755n 0.95v 314.745n 0.95v 314.755n 0.0v 319.745n 0.0v 319.755n 0.0v 324.745n 0.0v 324.755n 0.0v 329.745n 0.0v 329.755n 0.0v 334.745n 0.0v 334.755n 0.0v 339.745n 0.0v 339.755n 0.0v 344.745n 0.0v 344.755n 0.0v 349.745n 0.0v 349.755n 0.0v 354.745n 0.0v 354.755n 0.0v 359.745n 0.0v 359.755n 0.0v 364.745n 0.0v 364.755n 0.0v 369.745n 0.0v 369.755n 0.0v 374.745n 0.0v 374.755n 0.0v 379.745n 0.0v 379.755n 0.0v 384.745n 0.0v 384.755n 0.0v 389.745n 0.0v 389.755n 0.95v 394.745n 0.95v 394.755n 0.95v 399.745n 0.95v 399.755n 0.95v 404.745n 0.95v 404.755n 0.95v 409.745n 0.95v 409.755n 0.95v 414.745n 0.95v 414.755n 0.95v 419.745n 0.95v 419.755n 0.95v 424.745n 0.95v 424.755n 0.0v 429.745n 0.0v 429.755n 0.0v 434.745n 0.0v 434.755n 0.0v 439.745n 0.0v 439.755n 0.0v 444.745n 0.0v 444.755n 0.95v 449.745n 0.95v 449.755n 0.95v 454.745n 0.95v 454.755n 0.95v 459.745n 0.95v 459.755n 0.0v 464.745n 0.0v 464.755n 0.95v 469.745n 0.95v 469.755n 0.95v 474.745n 0.95v 474.755n 0.0v 479.745n 0.0v 479.755n 0.0v 484.745n 0.0v 484.755n 0.95v 489.745n 0.95v 489.755n 0.0v 494.745n 0.0v 494.755n 0.0v 499.745n 0.0v 499.755n 0.0v 504.745n 0.0v 504.755n 0.0v 509.745n 0.0v 509.755n 0.0v 514.745n 0.0v 514.755n 0.0v 519.745n 0.0v 519.755n 0.0v 524.745n 0.0v 524.755n 0.0v 529.745n 0.0v 529.755n 0.95v 534.745n 0.95v 534.755n 0.0v 539.745n 0.0v 539.755n 0.95v 544.745n 0.95v 544.755n 0.95v 549.745n 0.95v 549.755n 0.95v 554.745n 0.95v 554.755n 0.0v 559.745n 0.0v 559.755n 0.95v 564.745n 0.95v 564.755n 0.95v 569.745n 0.95v 569.755n 0.95v 574.745n 0.95v 574.755n 0.95v 579.745n 0.95v 579.755n 0.95v 584.745n 0.95v 584.755n 0.95v 589.745n 0.95v 589.755n 0.95v 594.745n 0.95v 594.755n 0.95v 599.745n 0.95v 599.755n 0.95v 604.745n 0.95v 604.755n 0.95v 609.745n 0.95v 609.755n 0.95v 614.745n 0.95v 614.755n 0.95v 619.745n 0.95v 619.755n 0.95v 624.745n 0.95v 624.755n 0.95v 629.745n 0.95v 629.755n 0.95v 634.745n 0.95v 634.755n 0.95v 639.745n 0.95v 639.755n 0.95v 644.745n 0.95v 644.755n 0.0v 649.745n 0.0v 649.755n 0.0v 654.745n 0.0v 654.755n 0.0v 659.745n 0.0v 659.755n 0.0v 664.745n 0.0v 664.755n 0.0v 669.745n 0.0v 669.755n 0.95v 674.745n 0.95v 674.755n 0.95v 679.745n 0.95v 679.755n 0.95v 684.745n 0.95v 684.755n 0.0v 689.745n 0.0v 689.755n 0.0v 694.745n 0.0v 694.755n 0.0v 699.745n 0.0v 699.755n 0.0v 704.745n 0.0v 704.755n 0.0v 709.745n 0.0v 709.755n 0.0v 714.745n 0.0v 714.755n 0.0v 719.745n 0.0v 719.755n 0.95v 724.745n 0.95v 724.755n 0.95v 729.745n 0.95v 729.755n 0.95v 734.745n 0.95v 734.755n 0.0v 739.745n 0.0v 739.755n 0.0v 744.745n 0.0v 744.755n 0.95v 749.745n 0.95v 749.755n 0.95v 754.745n 0.95v 754.755n 0.95v 759.745n 0.95v 759.755n 0.95v 764.745n 0.95v 764.755n 0.95v 769.745n 0.95v 769.755n 0.95v 774.745n 0.95v 774.755n 0.95v 779.745n 0.95v 779.755n 0.95v 784.745n 0.95v 784.755n 0.95v 789.745n 0.95v 789.755n 0.95v 794.745n 0.95v 794.755n 0.95v 799.745n 0.95v 799.755n 0.0v 804.745n 0.0v 804.755n 0.0v 809.745n 0.0v 809.755n 0.0v 814.745n 0.0v 814.755n 0.0v 819.745n 0.0v 819.755n 0.0v 824.745n 0.0v 824.755n 0.0v 829.745n 0.0v 829.755n 0.0v 834.745n 0.0v 834.755n 0.0v 839.745n 0.0v 839.755n 0.95v 844.745n 0.95v 844.755n 0.0v 849.745n 0.0v 849.755n 0.0v 854.745n 0.0v 854.755n 0.95v 859.745n 0.95v 859.755n 0.95v 864.745n 0.95v 864.755n 0.95v 869.745n 0.95v 869.755n 0.0v 874.745n 0.0v 874.755n 0.0v 879.745n 0.0v 879.755n 0.0v 884.745n 0.0v 884.755n 0.0v 889.745n 0.0v 889.755n 0.0v 894.745n 0.0v 894.755n 0.0v 899.745n 0.0v 899.755n 0.0v 904.745n 0.0v 904.755n 0.0v 909.745n 0.0v 909.755n 0.0v 914.745n 0.0v 914.755n 0.0v 919.745n 0.0v 919.755n 0.95v 924.745n 0.95v 924.755n 0.95v 929.745n 0.95v 929.755n 0.95v 934.745n 0.95v 934.755n 0.95v 939.745n 0.95v 939.755n 0.95v 944.745n 0.95v 944.755n 0.95v 949.745n 0.95v 949.755n 0.0v 954.745n 0.0v 954.755n 0.0v 959.745n 0.0v 959.755n 0.0v 964.745n 0.0v 964.755n 0.0v 969.745n 0.0v 969.755n 0.0v 974.745n 0.0v 974.755n 0.0v 979.745n 0.0v 979.755n 0.0v 984.745n 0.0v 984.755n 0.0v 989.745n 0.0v 989.755n 0.95v 994.745n 0.95v 994.755n 0.95v 999.745n 0.95v 999.755n 0.95v 1004.745n 0.95v 1004.755n 0.95v 1009.745n 0.95v 1009.755n 0.95v 1014.745n 0.95v 1014.755n 0.95v 1019.745n 0.95v 1019.755n 0.95v 1024.745n 0.95v 1024.755n 0.95v )
* (time, data): [(0, 0), (5, 0), (10, 1), (15, 1), (20, 1), (25, 1), (30, 0), (35, 1), (40, 1), (45, 0), (50, 1), (55, 1), (60, 1), (65, 1), (70, 1), (75, 1), (80, 0), (85, 1), (90, 1), (95, 0), (100, 0), (105, 0), (110, 0), (115, 1), (120, 1), (125, 0), (130, 1), (135, 1), (140, 1), (145, 1), (150, 1), (155, 1), (160, 1), (165, 0), (170, 0), (175, 0), (180, 0), (185, 0), (190, 0), (195, 0), (200, 0), (205, 0), (210, 0), (215, 0), (220, 0), (225, 0), (230, 0), (235, 0), (240, 0), (245, 1), (250, 1), (255, 1), (260, 1), (265, 1), (270, 0), (275, 0), (280, 0), (285, 1), (290, 1), (295, 1), (300, 1), (305, 1), (310, 1), (315, 0), (320, 0), (325, 0), (330, 0), (335, 0), (340, 0), (345, 0), (350, 0), (355, 0), (360, 1), (365, 0), (370, 0), (375, 0), (380, 0), (385, 0), (390, 1), (395, 1), (400, 1), (405, 1), (410, 0), (415, 0), (420, 0), (425, 1), (430, 1), (435, 1), (440, 0), (445, 1), (450, 1), (455, 1), (460, 0), (465, 1), (470, 1), (475, 1), (480, 1), (485, 1), (490, 1), (495, 1), (500, 0), (505, 0), (510, 0), (515, 0), (520, 1), (525, 1), (530, 1), (535, 0), (540, 0), (545, 0), (550, 0), (555, 0), (560, 0), (565, 0), (570, 0), (575, 0), (580, 0), (585, 0), (590, 0), (595, 1), (600, 1), (605, 1), (610, 1), (615, 1), (620, 1), (625, 1), (630, 1), (635, 1), (640, 0), (645, 1), (650, 1), (655, 1), (660, 1), (665, 1), (670, 0), (675, 0), (680, 0), (685, 0), (690, 0), (695, 0), (700, 0), (705, 0), (710, 0), (715, 0), (720, 0), (725, 0), (730, 0), (735, 0), (740, 0), (745, 1), (750, 1), (755, 1), (760, 1), (765, 0), (770, 0), (775, 0), (780, 0), (785, 0), (790, 0), (795, 0), (800, 0), (805, 0), (810, 0), (815, 0), (820, 0), (825, 0), (830, 0), (835, 0), (840, 0), (845, 0), (850, 0), (855, 1), (860, 1), (865, 0), (870, 0), (875, 0), (880, 0), (885, 0), (890, 0), (895, 0), (900, 0), (905, 0), (910, 1), (915, 1), (920, 0), (925, 0), (930, 0), (935, 1), (940, 1), (945, 1), (950, 0), (955, 1), (960, 1), (965, 1), (970, 1), (975, 1), (980, 0), (985, 0), (990, 1), (995, 1), (1000, 1), (1005, 1), (1010, 1), (1015, 1), (1020, 1), (1025, 1)]
Vdin0_14  din0_14  0 PWL (0n 0.0v 4.745n 0.0v 4.755n 0.0v 9.745n 0.0v 9.755n 0.95v 14.745n 0.95v 14.755n 0.95v 19.745n 0.95v 19.755n 0.95v 24.745n 0.95v 24.755n 0.95v 29.745n 0.95v 29.755n 0.0v 34.745n 0.0v 34.755n 0.95v 39.745n 0.95v 39.755n 0.95v 44.745n 0.95v 44.755n 0.0v 49.745n 0.0v 49.755n 0.95v 54.745n 0.95v 54.755n 0.95v 59.745n 0.95v 59.755n 0.95v 64.745n 0.95v 64.755n 0.95v 69.745n 0.95v 69.755n 0.95v 74.745n 0.95v 74.755n 0.95v 79.745n 0.95v 79.755n 0.0v 84.745n 0.0v 84.755n 0.95v 89.745n 0.95v 89.755n 0.95v 94.745n 0.95v 94.755n 0.0v 99.745n 0.0v 99.755n 0.0v 104.745n 0.0v 104.755n 0.0v 109.745n 0.0v 109.755n 0.0v 114.745n 0.0v 114.755n 0.95v 119.745n 0.95v 119.755n 0.95v 124.745n 0.95v 124.755n 0.0v 129.745n 0.0v 129.755n 0.95v 134.745n 0.95v 134.755n 0.95v 139.745n 0.95v 139.755n 0.95v 144.745n 0.95v 144.755n 0.95v 149.745n 0.95v 149.755n 0.95v 154.745n 0.95v 154.755n 0.95v 159.745n 0.95v 159.755n 0.95v 164.745n 0.95v 164.755n 0.0v 169.745n 0.0v 169.755n 0.0v 174.745n 0.0v 174.755n 0.0v 179.745n 0.0v 179.755n 0.0v 184.745n 0.0v 184.755n 0.0v 189.745n 0.0v 189.755n 0.0v 194.745n 0.0v 194.755n 0.0v 199.745n 0.0v 199.755n 0.0v 204.745n 0.0v 204.755n 0.0v 209.745n 0.0v 209.755n 0.0v 214.745n 0.0v 214.755n 0.0v 219.745n 0.0v 219.755n 0.0v 224.745n 0.0v 224.755n 0.0v 229.745n 0.0v 229.755n 0.0v 234.745n 0.0v 234.755n 0.0v 239.745n 0.0v 239.755n 0.0v 244.745n 0.0v 244.755n 0.95v 249.745n 0.95v 249.755n 0.95v 254.745n 0.95v 254.755n 0.95v 259.745n 0.95v 259.755n 0.95v 264.745n 0.95v 264.755n 0.95v 269.745n 0.95v 269.755n 0.0v 274.745n 0.0v 274.755n 0.0v 279.745n 0.0v 279.755n 0.0v 284.745n 0.0v 284.755n 0.95v 289.745n 0.95v 289.755n 0.95v 294.745n 0.95v 294.755n 0.95v 299.745n 0.95v 299.755n 0.95v 304.745n 0.95v 304.755n 0.95v 309.745n 0.95v 309.755n 0.95v 314.745n 0.95v 314.755n 0.0v 319.745n 0.0v 319.755n 0.0v 324.745n 0.0v 324.755n 0.0v 329.745n 0.0v 329.755n 0.0v 334.745n 0.0v 334.755n 0.0v 339.745n 0.0v 339.755n 0.0v 344.745n 0.0v 344.755n 0.0v 349.745n 0.0v 349.755n 0.0v 354.745n 0.0v 354.755n 0.0v 359.745n 0.0v 359.755n 0.95v 364.745n 0.95v 364.755n 0.0v 369.745n 0.0v 369.755n 0.0v 374.745n 0.0v 374.755n 0.0v 379.745n 0.0v 379.755n 0.0v 384.745n 0.0v 384.755n 0.0v 389.745n 0.0v 389.755n 0.95v 394.745n 0.95v 394.755n 0.95v 399.745n 0.95v 399.755n 0.95v 404.745n 0.95v 404.755n 0.95v 409.745n 0.95v 409.755n 0.0v 414.745n 0.0v 414.755n 0.0v 419.745n 0.0v 419.755n 0.0v 424.745n 0.0v 424.755n 0.95v 429.745n 0.95v 429.755n 0.95v 434.745n 0.95v 434.755n 0.95v 439.745n 0.95v 439.755n 0.0v 444.745n 0.0v 444.755n 0.95v 449.745n 0.95v 449.755n 0.95v 454.745n 0.95v 454.755n 0.95v 459.745n 0.95v 459.755n 0.0v 464.745n 0.0v 464.755n 0.95v 469.745n 0.95v 469.755n 0.95v 474.745n 0.95v 474.755n 0.95v 479.745n 0.95v 479.755n 0.95v 484.745n 0.95v 484.755n 0.95v 489.745n 0.95v 489.755n 0.95v 494.745n 0.95v 494.755n 0.95v 499.745n 0.95v 499.755n 0.0v 504.745n 0.0v 504.755n 0.0v 509.745n 0.0v 509.755n 0.0v 514.745n 0.0v 514.755n 0.0v 519.745n 0.0v 519.755n 0.95v 524.745n 0.95v 524.755n 0.95v 529.745n 0.95v 529.755n 0.95v 534.745n 0.95v 534.755n 0.0v 539.745n 0.0v 539.755n 0.0v 544.745n 0.0v 544.755n 0.0v 549.745n 0.0v 549.755n 0.0v 554.745n 0.0v 554.755n 0.0v 559.745n 0.0v 559.755n 0.0v 564.745n 0.0v 564.755n 0.0v 569.745n 0.0v 569.755n 0.0v 574.745n 0.0v 574.755n 0.0v 579.745n 0.0v 579.755n 0.0v 584.745n 0.0v 584.755n 0.0v 589.745n 0.0v 589.755n 0.0v 594.745n 0.0v 594.755n 0.95v 599.745n 0.95v 599.755n 0.95v 604.745n 0.95v 604.755n 0.95v 609.745n 0.95v 609.755n 0.95v 614.745n 0.95v 614.755n 0.95v 619.745n 0.95v 619.755n 0.95v 624.745n 0.95v 624.755n 0.95v 629.745n 0.95v 629.755n 0.95v 634.745n 0.95v 634.755n 0.95v 639.745n 0.95v 639.755n 0.0v 644.745n 0.0v 644.755n 0.95v 649.745n 0.95v 649.755n 0.95v 654.745n 0.95v 654.755n 0.95v 659.745n 0.95v 659.755n 0.95v 664.745n 0.95v 664.755n 0.95v 669.745n 0.95v 669.755n 0.0v 674.745n 0.0v 674.755n 0.0v 679.745n 0.0v 679.755n 0.0v 684.745n 0.0v 684.755n 0.0v 689.745n 0.0v 689.755n 0.0v 694.745n 0.0v 694.755n 0.0v 699.745n 0.0v 699.755n 0.0v 704.745n 0.0v 704.755n 0.0v 709.745n 0.0v 709.755n 0.0v 714.745n 0.0v 714.755n 0.0v 719.745n 0.0v 719.755n 0.0v 724.745n 0.0v 724.755n 0.0v 729.745n 0.0v 729.755n 0.0v 734.745n 0.0v 734.755n 0.0v 739.745n 0.0v 739.755n 0.0v 744.745n 0.0v 744.755n 0.95v 749.745n 0.95v 749.755n 0.95v 754.745n 0.95v 754.755n 0.95v 759.745n 0.95v 759.755n 0.95v 764.745n 0.95v 764.755n 0.0v 769.745n 0.0v 769.755n 0.0v 774.745n 0.0v 774.755n 0.0v 779.745n 0.0v 779.755n 0.0v 784.745n 0.0v 784.755n 0.0v 789.745n 0.0v 789.755n 0.0v 794.745n 0.0v 794.755n 0.0v 799.745n 0.0v 799.755n 0.0v 804.745n 0.0v 804.755n 0.0v 809.745n 0.0v 809.755n 0.0v 814.745n 0.0v 814.755n 0.0v 819.745n 0.0v 819.755n 0.0v 824.745n 0.0v 824.755n 0.0v 829.745n 0.0v 829.755n 0.0v 834.745n 0.0v 834.755n 0.0v 839.745n 0.0v 839.755n 0.0v 844.745n 0.0v 844.755n 0.0v 849.745n 0.0v 849.755n 0.0v 854.745n 0.0v 854.755n 0.95v 859.745n 0.95v 859.755n 0.95v 864.745n 0.95v 864.755n 0.0v 869.745n 0.0v 869.755n 0.0v 874.745n 0.0v 874.755n 0.0v 879.745n 0.0v 879.755n 0.0v 884.745n 0.0v 884.755n 0.0v 889.745n 0.0v 889.755n 0.0v 894.745n 0.0v 894.755n 0.0v 899.745n 0.0v 899.755n 0.0v 904.745n 0.0v 904.755n 0.0v 909.745n 0.0v 909.755n 0.95v 914.745n 0.95v 914.755n 0.95v 919.745n 0.95v 919.755n 0.0v 924.745n 0.0v 924.755n 0.0v 929.745n 0.0v 929.755n 0.0v 934.745n 0.0v 934.755n 0.95v 939.745n 0.95v 939.755n 0.95v 944.745n 0.95v 944.755n 0.95v 949.745n 0.95v 949.755n 0.0v 954.745n 0.0v 954.755n 0.95v 959.745n 0.95v 959.755n 0.95v 964.745n 0.95v 964.755n 0.95v 969.745n 0.95v 969.755n 0.95v 974.745n 0.95v 974.755n 0.95v 979.745n 0.95v 979.755n 0.0v 984.745n 0.0v 984.755n 0.0v 989.745n 0.0v 989.755n 0.95v 994.745n 0.95v 994.755n 0.95v 999.745n 0.95v 999.755n 0.95v 1004.745n 0.95v 1004.755n 0.95v 1009.745n 0.95v 1009.755n 0.95v 1014.745n 0.95v 1014.755n 0.95v 1019.745n 0.95v 1019.755n 0.95v 1024.745n 0.95v 1024.755n 0.95v )
* (time, data): [(0, 0), (5, 1), (10, 0), (15, 1), (20, 1), (25, 1), (30, 1), (35, 0), (40, 0), (45, 1), (50, 0), (55, 0), (60, 1), (65, 0), (70, 0), (75, 1), (80, 1), (85, 0), (90, 0), (95, 1), (100, 1), (105, 0), (110, 0), (115, 1), (120, 1), (125, 0), (130, 1), (135, 1), (140, 1), (145, 1), (150, 1), (155, 1), (160, 1), (165, 1), (170, 1), (175, 1), (180, 0), (185, 1), (190, 1), (195, 1), (200, 0), (205, 0), (210, 0), (215, 0), (220, 0), (225, 0), (230, 1), (235, 1), (240, 1), (245, 0), (250, 0), (255, 0), (260, 0), (265, 0), (270, 0), (275, 0), (280, 0), (285, 0), (290, 0), (295, 0), (300, 1), (305, 1), (310, 1), (315, 0), (320, 0), (325, 0), (330, 0), (335, 0), (340, 0), (345, 0), (350, 0), (355, 0), (360, 1), (365, 0), (370, 0), (375, 0), (380, 0), (385, 0), (390, 0), (395, 0), (400, 0), (405, 0), (410, 0), (415, 0), (420, 0), (425, 0), (430, 0), (435, 1), (440, 0), (445, 0), (450, 0), (455, 0), (460, 1), (465, 0), (470, 0), (475, 1), (480, 1), (485, 1), (490, 0), (495, 0), (500, 1), (505, 1), (510, 1), (515, 1), (520, 1), (525, 1), (530, 1), (535, 0), (540, 0), (545, 0), (550, 0), (555, 1), (560, 0), (565, 0), (570, 0), (575, 0), (580, 0), (585, 0), (590, 0), (595, 0), (600, 0), (605, 0), (610, 0), (615, 0), (620, 0), (625, 0), (630, 0), (635, 0), (640, 0), (645, 1), (650, 1), (655, 1), (660, 1), (665, 1), (670, 0), (675, 1), (680, 1), (685, 0), (690, 0), (695, 0), (700, 0), (705, 0), (710, 0), (715, 0), (720, 1), (725, 1), (730, 1), (735, 0), (740, 0), (745, 0), (750, 0), (755, 0), (760, 0), (765, 1), (770, 1), (775, 1), (780, 1), (785, 1), (790, 1), (795, 1), (800, 0), (805, 0), (810, 0), (815, 0), (820, 0), (825, 0), (830, 0), (835, 0), (840, 1), (845, 0), (850, 1), (855, 0), (860, 0), (865, 1), (870, 0), (875, 0), (880, 0), (885, 1), (890, 1), (895, 1), (900, 1), (905, 1), (910, 0), (915, 0), (920, 0), (925, 0), (930, 0), (935, 1), (940, 1), (945, 1), (950, 0), (955, 1), (960, 1), (965, 1), (970, 0), (975, 0), (980, 0), (985, 0), (990, 0), (995, 0), (1000, 0), (1005, 0), (1010, 0), (1015, 0), (1020, 0), (1025, 0)]
Vdin0_15  din0_15  0 PWL (0n 0.0v 4.745n 0.0v 4.755n 0.95v 9.745n 0.95v 9.755n 0.0v 14.745n 0.0v 14.755n 0.95v 19.745n 0.95v 19.755n 0.95v 24.745n 0.95v 24.755n 0.95v 29.745n 0.95v 29.755n 0.95v 34.745n 0.95v 34.755n 0.0v 39.745n 0.0v 39.755n 0.0v 44.745n 0.0v 44.755n 0.95v 49.745n 0.95v 49.755n 0.0v 54.745n 0.0v 54.755n 0.0v 59.745n 0.0v 59.755n 0.95v 64.745n 0.95v 64.755n 0.0v 69.745n 0.0v 69.755n 0.0v 74.745n 0.0v 74.755n 0.95v 79.745n 0.95v 79.755n 0.95v 84.745n 0.95v 84.755n 0.0v 89.745n 0.0v 89.755n 0.0v 94.745n 0.0v 94.755n 0.95v 99.745n 0.95v 99.755n 0.95v 104.745n 0.95v 104.755n 0.0v 109.745n 0.0v 109.755n 0.0v 114.745n 0.0v 114.755n 0.95v 119.745n 0.95v 119.755n 0.95v 124.745n 0.95v 124.755n 0.0v 129.745n 0.0v 129.755n 0.95v 134.745n 0.95v 134.755n 0.95v 139.745n 0.95v 139.755n 0.95v 144.745n 0.95v 144.755n 0.95v 149.745n 0.95v 149.755n 0.95v 154.745n 0.95v 154.755n 0.95v 159.745n 0.95v 159.755n 0.95v 164.745n 0.95v 164.755n 0.95v 169.745n 0.95v 169.755n 0.95v 174.745n 0.95v 174.755n 0.95v 179.745n 0.95v 179.755n 0.0v 184.745n 0.0v 184.755n 0.95v 189.745n 0.95v 189.755n 0.95v 194.745n 0.95v 194.755n 0.95v 199.745n 0.95v 199.755n 0.0v 204.745n 0.0v 204.755n 0.0v 209.745n 0.0v 209.755n 0.0v 214.745n 0.0v 214.755n 0.0v 219.745n 0.0v 219.755n 0.0v 224.745n 0.0v 224.755n 0.0v 229.745n 0.0v 229.755n 0.95v 234.745n 0.95v 234.755n 0.95v 239.745n 0.95v 239.755n 0.95v 244.745n 0.95v 244.755n 0.0v 249.745n 0.0v 249.755n 0.0v 254.745n 0.0v 254.755n 0.0v 259.745n 0.0v 259.755n 0.0v 264.745n 0.0v 264.755n 0.0v 269.745n 0.0v 269.755n 0.0v 274.745n 0.0v 274.755n 0.0v 279.745n 0.0v 279.755n 0.0v 284.745n 0.0v 284.755n 0.0v 289.745n 0.0v 289.755n 0.0v 294.745n 0.0v 294.755n 0.0v 299.745n 0.0v 299.755n 0.95v 304.745n 0.95v 304.755n 0.95v 309.745n 0.95v 309.755n 0.95v 314.745n 0.95v 314.755n 0.0v 319.745n 0.0v 319.755n 0.0v 324.745n 0.0v 324.755n 0.0v 329.745n 0.0v 329.755n 0.0v 334.745n 0.0v 334.755n 0.0v 339.745n 0.0v 339.755n 0.0v 344.745n 0.0v 344.755n 0.0v 349.745n 0.0v 349.755n 0.0v 354.745n 0.0v 354.755n 0.0v 359.745n 0.0v 359.755n 0.95v 364.745n 0.95v 364.755n 0.0v 369.745n 0.0v 369.755n 0.0v 374.745n 0.0v 374.755n 0.0v 379.745n 0.0v 379.755n 0.0v 384.745n 0.0v 384.755n 0.0v 389.745n 0.0v 389.755n 0.0v 394.745n 0.0v 394.755n 0.0v 399.745n 0.0v 399.755n 0.0v 404.745n 0.0v 404.755n 0.0v 409.745n 0.0v 409.755n 0.0v 414.745n 0.0v 414.755n 0.0v 419.745n 0.0v 419.755n 0.0v 424.745n 0.0v 424.755n 0.0v 429.745n 0.0v 429.755n 0.0v 434.745n 0.0v 434.755n 0.95v 439.745n 0.95v 439.755n 0.0v 444.745n 0.0v 444.755n 0.0v 449.745n 0.0v 449.755n 0.0v 454.745n 0.0v 454.755n 0.0v 459.745n 0.0v 459.755n 0.95v 464.745n 0.95v 464.755n 0.0v 469.745n 0.0v 469.755n 0.0v 474.745n 0.0v 474.755n 0.95v 479.745n 0.95v 479.755n 0.95v 484.745n 0.95v 484.755n 0.95v 489.745n 0.95v 489.755n 0.0v 494.745n 0.0v 494.755n 0.0v 499.745n 0.0v 499.755n 0.95v 504.745n 0.95v 504.755n 0.95v 509.745n 0.95v 509.755n 0.95v 514.745n 0.95v 514.755n 0.95v 519.745n 0.95v 519.755n 0.95v 524.745n 0.95v 524.755n 0.95v 529.745n 0.95v 529.755n 0.95v 534.745n 0.95v 534.755n 0.0v 539.745n 0.0v 539.755n 0.0v 544.745n 0.0v 544.755n 0.0v 549.745n 0.0v 549.755n 0.0v 554.745n 0.0v 554.755n 0.95v 559.745n 0.95v 559.755n 0.0v 564.745n 0.0v 564.755n 0.0v 569.745n 0.0v 569.755n 0.0v 574.745n 0.0v 574.755n 0.0v 579.745n 0.0v 579.755n 0.0v 584.745n 0.0v 584.755n 0.0v 589.745n 0.0v 589.755n 0.0v 594.745n 0.0v 594.755n 0.0v 599.745n 0.0v 599.755n 0.0v 604.745n 0.0v 604.755n 0.0v 609.745n 0.0v 609.755n 0.0v 614.745n 0.0v 614.755n 0.0v 619.745n 0.0v 619.755n 0.0v 624.745n 0.0v 624.755n 0.0v 629.745n 0.0v 629.755n 0.0v 634.745n 0.0v 634.755n 0.0v 639.745n 0.0v 639.755n 0.0v 644.745n 0.0v 644.755n 0.95v 649.745n 0.95v 649.755n 0.95v 654.745n 0.95v 654.755n 0.95v 659.745n 0.95v 659.755n 0.95v 664.745n 0.95v 664.755n 0.95v 669.745n 0.95v 669.755n 0.0v 674.745n 0.0v 674.755n 0.95v 679.745n 0.95v 679.755n 0.95v 684.745n 0.95v 684.755n 0.0v 689.745n 0.0v 689.755n 0.0v 694.745n 0.0v 694.755n 0.0v 699.745n 0.0v 699.755n 0.0v 704.745n 0.0v 704.755n 0.0v 709.745n 0.0v 709.755n 0.0v 714.745n 0.0v 714.755n 0.0v 719.745n 0.0v 719.755n 0.95v 724.745n 0.95v 724.755n 0.95v 729.745n 0.95v 729.755n 0.95v 734.745n 0.95v 734.755n 0.0v 739.745n 0.0v 739.755n 0.0v 744.745n 0.0v 744.755n 0.0v 749.745n 0.0v 749.755n 0.0v 754.745n 0.0v 754.755n 0.0v 759.745n 0.0v 759.755n 0.0v 764.745n 0.0v 764.755n 0.95v 769.745n 0.95v 769.755n 0.95v 774.745n 0.95v 774.755n 0.95v 779.745n 0.95v 779.755n 0.95v 784.745n 0.95v 784.755n 0.95v 789.745n 0.95v 789.755n 0.95v 794.745n 0.95v 794.755n 0.95v 799.745n 0.95v 799.755n 0.0v 804.745n 0.0v 804.755n 0.0v 809.745n 0.0v 809.755n 0.0v 814.745n 0.0v 814.755n 0.0v 819.745n 0.0v 819.755n 0.0v 824.745n 0.0v 824.755n 0.0v 829.745n 0.0v 829.755n 0.0v 834.745n 0.0v 834.755n 0.0v 839.745n 0.0v 839.755n 0.95v 844.745n 0.95v 844.755n 0.0v 849.745n 0.0v 849.755n 0.95v 854.745n 0.95v 854.755n 0.0v 859.745n 0.0v 859.755n 0.0v 864.745n 0.0v 864.755n 0.95v 869.745n 0.95v 869.755n 0.0v 874.745n 0.0v 874.755n 0.0v 879.745n 0.0v 879.755n 0.0v 884.745n 0.0v 884.755n 0.95v 889.745n 0.95v 889.755n 0.95v 894.745n 0.95v 894.755n 0.95v 899.745n 0.95v 899.755n 0.95v 904.745n 0.95v 904.755n 0.95v 909.745n 0.95v 909.755n 0.0v 914.745n 0.0v 914.755n 0.0v 919.745n 0.0v 919.755n 0.0v 924.745n 0.0v 924.755n 0.0v 929.745n 0.0v 929.755n 0.0v 934.745n 0.0v 934.755n 0.95v 939.745n 0.95v 939.755n 0.95v 944.745n 0.95v 944.755n 0.95v 949.745n 0.95v 949.755n 0.0v 954.745n 0.0v 954.755n 0.95v 959.745n 0.95v 959.755n 0.95v 964.745n 0.95v 964.755n 0.95v 969.745n 0.95v 969.755n 0.0v 974.745n 0.0v 974.755n 0.0v 979.745n 0.0v 979.755n 0.0v 984.745n 0.0v 984.755n 0.0v 989.745n 0.0v 989.755n 0.0v 994.745n 0.0v 994.755n 0.0v 999.745n 0.0v 999.755n 0.0v 1004.745n 0.0v 1004.755n 0.0v 1009.745n 0.0v 1009.755n 0.0v 1014.745n 0.0v 1014.755n 0.0v 1019.745n 0.0v 1019.755n 0.0v 1024.745n 0.0v 1024.755n 0.0v )
* (time, data): [(0, 0), (5, 1), (10, 1), (15, 0), (20, 0), (25, 0), (30, 0), (35, 1), (40, 1), (45, 1), (50, 1), (55, 1), (60, 0), (65, 1), (70, 1), (75, 0), (80, 1), (85, 0), (90, 0), (95, 1), (100, 1), (105, 0), (110, 0), (115, 0), (120, 0), (125, 1), (130, 0), (135, 0), (140, 0), (145, 0), (150, 0), (155, 0), (160, 0), (165, 1), (170, 1), (175, 1), (180, 0), (185, 1), (190, 1), (195, 1), (200, 1), (205, 1), (210, 1), (215, 1), (220, 1), (225, 1), (230, 0), (235, 0), (240, 0), (245, 0), (250, 0), (255, 0), (260, 0), (265, 0), (270, 0), (275, 0), (280, 0), (285, 1), (290, 1), (295, 1), (300, 1), (305, 1), (310, 1), (315, 0), (320, 0), (325, 0), (330, 0), (335, 0), (340, 0), (345, 0), (350, 0), (355, 0), (360, 1), (365, 1), (370, 1), (375, 1), (380, 1), (385, 1), (390, 1), (395, 1), (400, 1), (405, 1), (410, 1), (415, 1), (420, 1), (425, 0), (430, 0), (435, 1), (440, 0), (445, 1), (450, 1), (455, 1), (460, 0), (465, 0), (470, 0), (475, 0), (480, 0), (485, 1), (490, 1), (495, 1), (500, 1), (505, 1), (510, 1), (515, 1), (520, 1), (525, 1), (530, 1), (535, 0), (540, 0), (545, 0), (550, 0), (555, 0), (560, 0), (565, 0), (570, 0), (575, 0), (580, 0), (585, 0), (590, 0), (595, 0), (600, 0), (605, 0), (610, 0), (615, 0), (620, 0), (625, 0), (630, 0), (635, 0), (640, 1), (645, 1), (650, 1), (655, 1), (660, 1), (665, 1), (670, 1), (675, 1), (680, 1), (685, 1), (690, 1), (695, 1), (700, 1), (705, 1), (710, 1), (715, 1), (720, 1), (725, 1), (730, 0), (735, 1), (740, 1), (745, 1), (750, 1), (755, 1), (760, 1), (765, 0), (770, 0), (775, 0), (780, 0), (785, 0), (790, 0), (795, 0), (800, 0), (805, 0), (810, 0), (815, 0), (820, 0), (825, 0), (830, 0), (835, 0), (840, 1), (845, 1), (850, 1), (855, 0), (860, 0), (865, 1), (870, 1), (875, 1), (880, 1), (885, 1), (890, 0), (895, 0), (900, 0), (905, 0), (910, 1), (915, 1), (920, 1), (925, 0), (930, 0), (935, 1), (940, 1), (945, 1), (950, 0), (955, 0), (960, 0), (965, 0), (970, 1), (975, 1), (980, 0), (985, 0), (990, 0), (995, 0), (1000, 0), (1005, 1), (1010, 1), (1015, 1), (1020, 1), (1025, 1)]
Vdin0_16  din0_16  0 PWL (0n 0.0v 4.745n 0.0v 4.755n 0.95v 9.745n 0.95v 9.755n 0.95v 14.745n 0.95v 14.755n 0.0v 19.745n 0.0v 19.755n 0.0v 24.745n 0.0v 24.755n 0.0v 29.745n 0.0v 29.755n 0.0v 34.745n 0.0v 34.755n 0.95v 39.745n 0.95v 39.755n 0.95v 44.745n 0.95v 44.755n 0.95v 49.745n 0.95v 49.755n 0.95v 54.745n 0.95v 54.755n 0.95v 59.745n 0.95v 59.755n 0.0v 64.745n 0.0v 64.755n 0.95v 69.745n 0.95v 69.755n 0.95v 74.745n 0.95v 74.755n 0.0v 79.745n 0.0v 79.755n 0.95v 84.745n 0.95v 84.755n 0.0v 89.745n 0.0v 89.755n 0.0v 94.745n 0.0v 94.755n 0.95v 99.745n 0.95v 99.755n 0.95v 104.745n 0.95v 104.755n 0.0v 109.745n 0.0v 109.755n 0.0v 114.745n 0.0v 114.755n 0.0v 119.745n 0.0v 119.755n 0.0v 124.745n 0.0v 124.755n 0.95v 129.745n 0.95v 129.755n 0.0v 134.745n 0.0v 134.755n 0.0v 139.745n 0.0v 139.755n 0.0v 144.745n 0.0v 144.755n 0.0v 149.745n 0.0v 149.755n 0.0v 154.745n 0.0v 154.755n 0.0v 159.745n 0.0v 159.755n 0.0v 164.745n 0.0v 164.755n 0.95v 169.745n 0.95v 169.755n 0.95v 174.745n 0.95v 174.755n 0.95v 179.745n 0.95v 179.755n 0.0v 184.745n 0.0v 184.755n 0.95v 189.745n 0.95v 189.755n 0.95v 194.745n 0.95v 194.755n 0.95v 199.745n 0.95v 199.755n 0.95v 204.745n 0.95v 204.755n 0.95v 209.745n 0.95v 209.755n 0.95v 214.745n 0.95v 214.755n 0.95v 219.745n 0.95v 219.755n 0.95v 224.745n 0.95v 224.755n 0.95v 229.745n 0.95v 229.755n 0.0v 234.745n 0.0v 234.755n 0.0v 239.745n 0.0v 239.755n 0.0v 244.745n 0.0v 244.755n 0.0v 249.745n 0.0v 249.755n 0.0v 254.745n 0.0v 254.755n 0.0v 259.745n 0.0v 259.755n 0.0v 264.745n 0.0v 264.755n 0.0v 269.745n 0.0v 269.755n 0.0v 274.745n 0.0v 274.755n 0.0v 279.745n 0.0v 279.755n 0.0v 284.745n 0.0v 284.755n 0.95v 289.745n 0.95v 289.755n 0.95v 294.745n 0.95v 294.755n 0.95v 299.745n 0.95v 299.755n 0.95v 304.745n 0.95v 304.755n 0.95v 309.745n 0.95v 309.755n 0.95v 314.745n 0.95v 314.755n 0.0v 319.745n 0.0v 319.755n 0.0v 324.745n 0.0v 324.755n 0.0v 329.745n 0.0v 329.755n 0.0v 334.745n 0.0v 334.755n 0.0v 339.745n 0.0v 339.755n 0.0v 344.745n 0.0v 344.755n 0.0v 349.745n 0.0v 349.755n 0.0v 354.745n 0.0v 354.755n 0.0v 359.745n 0.0v 359.755n 0.95v 364.745n 0.95v 364.755n 0.95v 369.745n 0.95v 369.755n 0.95v 374.745n 0.95v 374.755n 0.95v 379.745n 0.95v 379.755n 0.95v 384.745n 0.95v 384.755n 0.95v 389.745n 0.95v 389.755n 0.95v 394.745n 0.95v 394.755n 0.95v 399.745n 0.95v 399.755n 0.95v 404.745n 0.95v 404.755n 0.95v 409.745n 0.95v 409.755n 0.95v 414.745n 0.95v 414.755n 0.95v 419.745n 0.95v 419.755n 0.95v 424.745n 0.95v 424.755n 0.0v 429.745n 0.0v 429.755n 0.0v 434.745n 0.0v 434.755n 0.95v 439.745n 0.95v 439.755n 0.0v 444.745n 0.0v 444.755n 0.95v 449.745n 0.95v 449.755n 0.95v 454.745n 0.95v 454.755n 0.95v 459.745n 0.95v 459.755n 0.0v 464.745n 0.0v 464.755n 0.0v 469.745n 0.0v 469.755n 0.0v 474.745n 0.0v 474.755n 0.0v 479.745n 0.0v 479.755n 0.0v 484.745n 0.0v 484.755n 0.95v 489.745n 0.95v 489.755n 0.95v 494.745n 0.95v 494.755n 0.95v 499.745n 0.95v 499.755n 0.95v 504.745n 0.95v 504.755n 0.95v 509.745n 0.95v 509.755n 0.95v 514.745n 0.95v 514.755n 0.95v 519.745n 0.95v 519.755n 0.95v 524.745n 0.95v 524.755n 0.95v 529.745n 0.95v 529.755n 0.95v 534.745n 0.95v 534.755n 0.0v 539.745n 0.0v 539.755n 0.0v 544.745n 0.0v 544.755n 0.0v 549.745n 0.0v 549.755n 0.0v 554.745n 0.0v 554.755n 0.0v 559.745n 0.0v 559.755n 0.0v 564.745n 0.0v 564.755n 0.0v 569.745n 0.0v 569.755n 0.0v 574.745n 0.0v 574.755n 0.0v 579.745n 0.0v 579.755n 0.0v 584.745n 0.0v 584.755n 0.0v 589.745n 0.0v 589.755n 0.0v 594.745n 0.0v 594.755n 0.0v 599.745n 0.0v 599.755n 0.0v 604.745n 0.0v 604.755n 0.0v 609.745n 0.0v 609.755n 0.0v 614.745n 0.0v 614.755n 0.0v 619.745n 0.0v 619.755n 0.0v 624.745n 0.0v 624.755n 0.0v 629.745n 0.0v 629.755n 0.0v 634.745n 0.0v 634.755n 0.0v 639.745n 0.0v 639.755n 0.95v 644.745n 0.95v 644.755n 0.95v 649.745n 0.95v 649.755n 0.95v 654.745n 0.95v 654.755n 0.95v 659.745n 0.95v 659.755n 0.95v 664.745n 0.95v 664.755n 0.95v 669.745n 0.95v 669.755n 0.95v 674.745n 0.95v 674.755n 0.95v 679.745n 0.95v 679.755n 0.95v 684.745n 0.95v 684.755n 0.95v 689.745n 0.95v 689.755n 0.95v 694.745n 0.95v 694.755n 0.95v 699.745n 0.95v 699.755n 0.95v 704.745n 0.95v 704.755n 0.95v 709.745n 0.95v 709.755n 0.95v 714.745n 0.95v 714.755n 0.95v 719.745n 0.95v 719.755n 0.95v 724.745n 0.95v 724.755n 0.95v 729.745n 0.95v 729.755n 0.0v 734.745n 0.0v 734.755n 0.95v 739.745n 0.95v 739.755n 0.95v 744.745n 0.95v 744.755n 0.95v 749.745n 0.95v 749.755n 0.95v 754.745n 0.95v 754.755n 0.95v 759.745n 0.95v 759.755n 0.95v 764.745n 0.95v 764.755n 0.0v 769.745n 0.0v 769.755n 0.0v 774.745n 0.0v 774.755n 0.0v 779.745n 0.0v 779.755n 0.0v 784.745n 0.0v 784.755n 0.0v 789.745n 0.0v 789.755n 0.0v 794.745n 0.0v 794.755n 0.0v 799.745n 0.0v 799.755n 0.0v 804.745n 0.0v 804.755n 0.0v 809.745n 0.0v 809.755n 0.0v 814.745n 0.0v 814.755n 0.0v 819.745n 0.0v 819.755n 0.0v 824.745n 0.0v 824.755n 0.0v 829.745n 0.0v 829.755n 0.0v 834.745n 0.0v 834.755n 0.0v 839.745n 0.0v 839.755n 0.95v 844.745n 0.95v 844.755n 0.95v 849.745n 0.95v 849.755n 0.95v 854.745n 0.95v 854.755n 0.0v 859.745n 0.0v 859.755n 0.0v 864.745n 0.0v 864.755n 0.95v 869.745n 0.95v 869.755n 0.95v 874.745n 0.95v 874.755n 0.95v 879.745n 0.95v 879.755n 0.95v 884.745n 0.95v 884.755n 0.95v 889.745n 0.95v 889.755n 0.0v 894.745n 0.0v 894.755n 0.0v 899.745n 0.0v 899.755n 0.0v 904.745n 0.0v 904.755n 0.0v 909.745n 0.0v 909.755n 0.95v 914.745n 0.95v 914.755n 0.95v 919.745n 0.95v 919.755n 0.95v 924.745n 0.95v 924.755n 0.0v 929.745n 0.0v 929.755n 0.0v 934.745n 0.0v 934.755n 0.95v 939.745n 0.95v 939.755n 0.95v 944.745n 0.95v 944.755n 0.95v 949.745n 0.95v 949.755n 0.0v 954.745n 0.0v 954.755n 0.0v 959.745n 0.0v 959.755n 0.0v 964.745n 0.0v 964.755n 0.0v 969.745n 0.0v 969.755n 0.95v 974.745n 0.95v 974.755n 0.95v 979.745n 0.95v 979.755n 0.0v 984.745n 0.0v 984.755n 0.0v 989.745n 0.0v 989.755n 0.0v 994.745n 0.0v 994.755n 0.0v 999.745n 0.0v 999.755n 0.0v 1004.745n 0.0v 1004.755n 0.95v 1009.745n 0.95v 1009.755n 0.95v 1014.745n 0.95v 1014.755n 0.95v 1019.745n 0.95v 1019.755n 0.95v 1024.745n 0.95v 1024.755n 0.95v )
* (time, data): [(0, 0), (5, 0), (10, 0), (15, 0), (20, 0), (25, 1), (30, 1), (35, 1), (40, 1), (45, 1), (50, 0), (55, 0), (60, 0), (65, 0), (70, 0), (75, 1), (80, 1), (85, 1), (90, 1), (95, 0), (100, 0), (105, 0), (110, 0), (115, 0), (120, 0), (125, 1), (130, 0), (135, 0), (140, 0), (145, 0), (150, 0), (155, 0), (160, 0), (165, 0), (170, 0), (175, 0), (180, 1), (185, 0), (190, 0), (195, 0), (200, 1), (205, 1), (210, 1), (215, 1), (220, 1), (225, 1), (230, 0), (235, 0), (240, 0), (245, 0), (250, 0), (255, 0), (260, 0), (265, 0), (270, 0), (275, 0), (280, 0), (285, 1), (290, 1), (295, 1), (300, 0), (305, 0), (310, 0), (315, 0), (320, 0), (325, 0), (330, 0), (335, 0), (340, 0), (345, 0), (350, 0), (355, 0), (360, 1), (365, 0), (370, 0), (375, 0), (380, 0), (385, 0), (390, 1), (395, 1), (400, 1), (405, 1), (410, 1), (415, 1), (420, 1), (425, 0), (430, 0), (435, 0), (440, 1), (445, 0), (450, 0), (455, 0), (460, 1), (465, 1), (470, 1), (475, 1), (480, 1), (485, 1), (490, 1), (495, 1), (500, 1), (505, 1), (510, 1), (515, 1), (520, 1), (525, 1), (530, 1), (535, 0), (540, 1), (545, 1), (550, 1), (555, 1), (560, 1), (565, 1), (570, 1), (575, 1), (580, 1), (585, 1), (590, 1), (595, 0), (600, 0), (605, 0), (610, 0), (615, 0), (620, 0), (625, 0), (630, 0), (635, 0), (640, 0), (645, 1), (650, 1), (655, 1), (660, 1), (665, 1), (670, 1), (675, 0), (680, 0), (685, 0), (690, 0), (695, 0), (700, 0), (705, 0), (710, 0), (715, 0), (720, 0), (725, 0), (730, 0), (735, 0), (740, 0), (745, 1), (750, 1), (755, 1), (760, 1), (765, 0), (770, 0), (775, 0), (780, 0), (785, 0), (790, 0), (795, 0), (800, 1), (805, 1), (810, 1), (815, 1), (820, 1), (825, 1), (830, 1), (835, 1), (840, 0), (845, 1), (850, 1), (855, 1), (860, 1), (865, 0), (870, 1), (875, 1), (880, 1), (885, 1), (890, 1), (895, 1), (900, 1), (905, 1), (910, 0), (915, 0), (920, 1), (925, 0), (930, 0), (935, 0), (940, 0), (945, 0), (950, 0), (955, 1), (960, 1), (965, 1), (970, 1), (975, 1), (980, 0), (985, 0), (990, 0), (995, 0), (1000, 0), (1005, 1), (1010, 1), (1015, 1), (1020, 1), (1025, 1)]
Vdin0_17  din0_17  0 PWL (0n 0.0v 4.745n 0.0v 4.755n 0.0v 9.745n 0.0v 9.755n 0.0v 14.745n 0.0v 14.755n 0.0v 19.745n 0.0v 19.755n 0.0v 24.745n 0.0v 24.755n 0.95v 29.745n 0.95v 29.755n 0.95v 34.745n 0.95v 34.755n 0.95v 39.745n 0.95v 39.755n 0.95v 44.745n 0.95v 44.755n 0.95v 49.745n 0.95v 49.755n 0.0v 54.745n 0.0v 54.755n 0.0v 59.745n 0.0v 59.755n 0.0v 64.745n 0.0v 64.755n 0.0v 69.745n 0.0v 69.755n 0.0v 74.745n 0.0v 74.755n 0.95v 79.745n 0.95v 79.755n 0.95v 84.745n 0.95v 84.755n 0.95v 89.745n 0.95v 89.755n 0.95v 94.745n 0.95v 94.755n 0.0v 99.745n 0.0v 99.755n 0.0v 104.745n 0.0v 104.755n 0.0v 109.745n 0.0v 109.755n 0.0v 114.745n 0.0v 114.755n 0.0v 119.745n 0.0v 119.755n 0.0v 124.745n 0.0v 124.755n 0.95v 129.745n 0.95v 129.755n 0.0v 134.745n 0.0v 134.755n 0.0v 139.745n 0.0v 139.755n 0.0v 144.745n 0.0v 144.755n 0.0v 149.745n 0.0v 149.755n 0.0v 154.745n 0.0v 154.755n 0.0v 159.745n 0.0v 159.755n 0.0v 164.745n 0.0v 164.755n 0.0v 169.745n 0.0v 169.755n 0.0v 174.745n 0.0v 174.755n 0.0v 179.745n 0.0v 179.755n 0.95v 184.745n 0.95v 184.755n 0.0v 189.745n 0.0v 189.755n 0.0v 194.745n 0.0v 194.755n 0.0v 199.745n 0.0v 199.755n 0.95v 204.745n 0.95v 204.755n 0.95v 209.745n 0.95v 209.755n 0.95v 214.745n 0.95v 214.755n 0.95v 219.745n 0.95v 219.755n 0.95v 224.745n 0.95v 224.755n 0.95v 229.745n 0.95v 229.755n 0.0v 234.745n 0.0v 234.755n 0.0v 239.745n 0.0v 239.755n 0.0v 244.745n 0.0v 244.755n 0.0v 249.745n 0.0v 249.755n 0.0v 254.745n 0.0v 254.755n 0.0v 259.745n 0.0v 259.755n 0.0v 264.745n 0.0v 264.755n 0.0v 269.745n 0.0v 269.755n 0.0v 274.745n 0.0v 274.755n 0.0v 279.745n 0.0v 279.755n 0.0v 284.745n 0.0v 284.755n 0.95v 289.745n 0.95v 289.755n 0.95v 294.745n 0.95v 294.755n 0.95v 299.745n 0.95v 299.755n 0.0v 304.745n 0.0v 304.755n 0.0v 309.745n 0.0v 309.755n 0.0v 314.745n 0.0v 314.755n 0.0v 319.745n 0.0v 319.755n 0.0v 324.745n 0.0v 324.755n 0.0v 329.745n 0.0v 329.755n 0.0v 334.745n 0.0v 334.755n 0.0v 339.745n 0.0v 339.755n 0.0v 344.745n 0.0v 344.755n 0.0v 349.745n 0.0v 349.755n 0.0v 354.745n 0.0v 354.755n 0.0v 359.745n 0.0v 359.755n 0.95v 364.745n 0.95v 364.755n 0.0v 369.745n 0.0v 369.755n 0.0v 374.745n 0.0v 374.755n 0.0v 379.745n 0.0v 379.755n 0.0v 384.745n 0.0v 384.755n 0.0v 389.745n 0.0v 389.755n 0.95v 394.745n 0.95v 394.755n 0.95v 399.745n 0.95v 399.755n 0.95v 404.745n 0.95v 404.755n 0.95v 409.745n 0.95v 409.755n 0.95v 414.745n 0.95v 414.755n 0.95v 419.745n 0.95v 419.755n 0.95v 424.745n 0.95v 424.755n 0.0v 429.745n 0.0v 429.755n 0.0v 434.745n 0.0v 434.755n 0.0v 439.745n 0.0v 439.755n 0.95v 444.745n 0.95v 444.755n 0.0v 449.745n 0.0v 449.755n 0.0v 454.745n 0.0v 454.755n 0.0v 459.745n 0.0v 459.755n 0.95v 464.745n 0.95v 464.755n 0.95v 469.745n 0.95v 469.755n 0.95v 474.745n 0.95v 474.755n 0.95v 479.745n 0.95v 479.755n 0.95v 484.745n 0.95v 484.755n 0.95v 489.745n 0.95v 489.755n 0.95v 494.745n 0.95v 494.755n 0.95v 499.745n 0.95v 499.755n 0.95v 504.745n 0.95v 504.755n 0.95v 509.745n 0.95v 509.755n 0.95v 514.745n 0.95v 514.755n 0.95v 519.745n 0.95v 519.755n 0.95v 524.745n 0.95v 524.755n 0.95v 529.745n 0.95v 529.755n 0.95v 534.745n 0.95v 534.755n 0.0v 539.745n 0.0v 539.755n 0.95v 544.745n 0.95v 544.755n 0.95v 549.745n 0.95v 549.755n 0.95v 554.745n 0.95v 554.755n 0.95v 559.745n 0.95v 559.755n 0.95v 564.745n 0.95v 564.755n 0.95v 569.745n 0.95v 569.755n 0.95v 574.745n 0.95v 574.755n 0.95v 579.745n 0.95v 579.755n 0.95v 584.745n 0.95v 584.755n 0.95v 589.745n 0.95v 589.755n 0.95v 594.745n 0.95v 594.755n 0.0v 599.745n 0.0v 599.755n 0.0v 604.745n 0.0v 604.755n 0.0v 609.745n 0.0v 609.755n 0.0v 614.745n 0.0v 614.755n 0.0v 619.745n 0.0v 619.755n 0.0v 624.745n 0.0v 624.755n 0.0v 629.745n 0.0v 629.755n 0.0v 634.745n 0.0v 634.755n 0.0v 639.745n 0.0v 639.755n 0.0v 644.745n 0.0v 644.755n 0.95v 649.745n 0.95v 649.755n 0.95v 654.745n 0.95v 654.755n 0.95v 659.745n 0.95v 659.755n 0.95v 664.745n 0.95v 664.755n 0.95v 669.745n 0.95v 669.755n 0.95v 674.745n 0.95v 674.755n 0.0v 679.745n 0.0v 679.755n 0.0v 684.745n 0.0v 684.755n 0.0v 689.745n 0.0v 689.755n 0.0v 694.745n 0.0v 694.755n 0.0v 699.745n 0.0v 699.755n 0.0v 704.745n 0.0v 704.755n 0.0v 709.745n 0.0v 709.755n 0.0v 714.745n 0.0v 714.755n 0.0v 719.745n 0.0v 719.755n 0.0v 724.745n 0.0v 724.755n 0.0v 729.745n 0.0v 729.755n 0.0v 734.745n 0.0v 734.755n 0.0v 739.745n 0.0v 739.755n 0.0v 744.745n 0.0v 744.755n 0.95v 749.745n 0.95v 749.755n 0.95v 754.745n 0.95v 754.755n 0.95v 759.745n 0.95v 759.755n 0.95v 764.745n 0.95v 764.755n 0.0v 769.745n 0.0v 769.755n 0.0v 774.745n 0.0v 774.755n 0.0v 779.745n 0.0v 779.755n 0.0v 784.745n 0.0v 784.755n 0.0v 789.745n 0.0v 789.755n 0.0v 794.745n 0.0v 794.755n 0.0v 799.745n 0.0v 799.755n 0.95v 804.745n 0.95v 804.755n 0.95v 809.745n 0.95v 809.755n 0.95v 814.745n 0.95v 814.755n 0.95v 819.745n 0.95v 819.755n 0.95v 824.745n 0.95v 824.755n 0.95v 829.745n 0.95v 829.755n 0.95v 834.745n 0.95v 834.755n 0.95v 839.745n 0.95v 839.755n 0.0v 844.745n 0.0v 844.755n 0.95v 849.745n 0.95v 849.755n 0.95v 854.745n 0.95v 854.755n 0.95v 859.745n 0.95v 859.755n 0.95v 864.745n 0.95v 864.755n 0.0v 869.745n 0.0v 869.755n 0.95v 874.745n 0.95v 874.755n 0.95v 879.745n 0.95v 879.755n 0.95v 884.745n 0.95v 884.755n 0.95v 889.745n 0.95v 889.755n 0.95v 894.745n 0.95v 894.755n 0.95v 899.745n 0.95v 899.755n 0.95v 904.745n 0.95v 904.755n 0.95v 909.745n 0.95v 909.755n 0.0v 914.745n 0.0v 914.755n 0.0v 919.745n 0.0v 919.755n 0.95v 924.745n 0.95v 924.755n 0.0v 929.745n 0.0v 929.755n 0.0v 934.745n 0.0v 934.755n 0.0v 939.745n 0.0v 939.755n 0.0v 944.745n 0.0v 944.755n 0.0v 949.745n 0.0v 949.755n 0.0v 954.745n 0.0v 954.755n 0.95v 959.745n 0.95v 959.755n 0.95v 964.745n 0.95v 964.755n 0.95v 969.745n 0.95v 969.755n 0.95v 974.745n 0.95v 974.755n 0.95v 979.745n 0.95v 979.755n 0.0v 984.745n 0.0v 984.755n 0.0v 989.745n 0.0v 989.755n 0.0v 994.745n 0.0v 994.755n 0.0v 999.745n 0.0v 999.755n 0.0v 1004.745n 0.0v 1004.755n 0.95v 1009.745n 0.95v 1009.755n 0.95v 1014.745n 0.95v 1014.755n 0.95v 1019.745n 0.95v 1019.755n 0.95v 1024.745n 0.95v 1024.755n 0.95v )
* (time, data): [(0, 0), (5, 1), (10, 1), (15, 1), (20, 1), (25, 1), (30, 1), (35, 1), (40, 0), (45, 1), (50, 0), (55, 0), (60, 0), (65, 0), (70, 0), (75, 1), (80, 1), (85, 0), (90, 0), (95, 1), (100, 1), (105, 1), (110, 1), (115, 1), (120, 1), (125, 1), (130, 0), (135, 0), (140, 0), (145, 0), (150, 0), (155, 0), (160, 0), (165, 1), (170, 1), (175, 1), (180, 0), (185, 0), (190, 0), (195, 0), (200, 1), (205, 1), (210, 1), (215, 1), (220, 1), (225, 1), (230, 1), (235, 1), (240, 1), (245, 1), (250, 1), (255, 1), (260, 1), (265, 1), (270, 1), (275, 1), (280, 1), (285, 1), (290, 1), (295, 1), (300, 1), (305, 1), (310, 1), (315, 0), (320, 0), (325, 0), (330, 0), (335, 0), (340, 0), (345, 1), (350, 1), (355, 1), (360, 1), (365, 1), (370, 1), (375, 1), (380, 1), (385, 1), (390, 0), (395, 0), (400, 0), (405, 0), (410, 1), (415, 1), (420, 1), (425, 0), (430, 0), (435, 0), (440, 0), (445, 1), (450, 1), (455, 1), (460, 0), (465, 0), (470, 0), (475, 0), (480, 0), (485, 0), (490, 1), (495, 1), (500, 0), (505, 0), (510, 0), (515, 0), (520, 1), (525, 1), (530, 0), (535, 0), (540, 1), (545, 1), (550, 1), (555, 1), (560, 1), (565, 1), (570, 1), (575, 1), (580, 1), (585, 1), (590, 1), (595, 0), (600, 0), (605, 0), (610, 0), (615, 0), (620, 0), (625, 0), (630, 0), (635, 0), (640, 0), (645, 0), (650, 0), (655, 0), (660, 0), (665, 0), (670, 1), (675, 1), (680, 1), (685, 0), (690, 0), (695, 0), (700, 0), (705, 0), (710, 0), (715, 0), (720, 0), (725, 0), (730, 1), (735, 1), (740, 1), (745, 1), (750, 1), (755, 1), (760, 1), (765, 0), (770, 0), (775, 0), (780, 0), (785, 0), (790, 0), (795, 0), (800, 1), (805, 1), (810, 1), (815, 1), (820, 1), (825, 1), (830, 1), (835, 1), (840, 0), (845, 1), (850, 1), (855, 1), (860, 1), (865, 0), (870, 1), (875, 1), (880, 1), (885, 1), (890, 0), (895, 0), (900, 0), (905, 0), (910, 1), (915, 1), (920, 0), (925, 1), (930, 1), (935, 0), (940, 0), (945, 0), (950, 1), (955, 0), (960, 0), (965, 0), (970, 0), (975, 0), (980, 0), (985, 1), (990, 0), (995, 0), (1000, 0), (1005, 0), (1010, 0), (1015, 0), (1020, 0), (1025, 0)]
Vdin0_18  din0_18  0 PWL (0n 0.0v 4.745n 0.0v 4.755n 0.95v 9.745n 0.95v 9.755n 0.95v 14.745n 0.95v 14.755n 0.95v 19.745n 0.95v 19.755n 0.95v 24.745n 0.95v 24.755n 0.95v 29.745n 0.95v 29.755n 0.95v 34.745n 0.95v 34.755n 0.95v 39.745n 0.95v 39.755n 0.0v 44.745n 0.0v 44.755n 0.95v 49.745n 0.95v 49.755n 0.0v 54.745n 0.0v 54.755n 0.0v 59.745n 0.0v 59.755n 0.0v 64.745n 0.0v 64.755n 0.0v 69.745n 0.0v 69.755n 0.0v 74.745n 0.0v 74.755n 0.95v 79.745n 0.95v 79.755n 0.95v 84.745n 0.95v 84.755n 0.0v 89.745n 0.0v 89.755n 0.0v 94.745n 0.0v 94.755n 0.95v 99.745n 0.95v 99.755n 0.95v 104.745n 0.95v 104.755n 0.95v 109.745n 0.95v 109.755n 0.95v 114.745n 0.95v 114.755n 0.95v 119.745n 0.95v 119.755n 0.95v 124.745n 0.95v 124.755n 0.95v 129.745n 0.95v 129.755n 0.0v 134.745n 0.0v 134.755n 0.0v 139.745n 0.0v 139.755n 0.0v 144.745n 0.0v 144.755n 0.0v 149.745n 0.0v 149.755n 0.0v 154.745n 0.0v 154.755n 0.0v 159.745n 0.0v 159.755n 0.0v 164.745n 0.0v 164.755n 0.95v 169.745n 0.95v 169.755n 0.95v 174.745n 0.95v 174.755n 0.95v 179.745n 0.95v 179.755n 0.0v 184.745n 0.0v 184.755n 0.0v 189.745n 0.0v 189.755n 0.0v 194.745n 0.0v 194.755n 0.0v 199.745n 0.0v 199.755n 0.95v 204.745n 0.95v 204.755n 0.95v 209.745n 0.95v 209.755n 0.95v 214.745n 0.95v 214.755n 0.95v 219.745n 0.95v 219.755n 0.95v 224.745n 0.95v 224.755n 0.95v 229.745n 0.95v 229.755n 0.95v 234.745n 0.95v 234.755n 0.95v 239.745n 0.95v 239.755n 0.95v 244.745n 0.95v 244.755n 0.95v 249.745n 0.95v 249.755n 0.95v 254.745n 0.95v 254.755n 0.95v 259.745n 0.95v 259.755n 0.95v 264.745n 0.95v 264.755n 0.95v 269.745n 0.95v 269.755n 0.95v 274.745n 0.95v 274.755n 0.95v 279.745n 0.95v 279.755n 0.95v 284.745n 0.95v 284.755n 0.95v 289.745n 0.95v 289.755n 0.95v 294.745n 0.95v 294.755n 0.95v 299.745n 0.95v 299.755n 0.95v 304.745n 0.95v 304.755n 0.95v 309.745n 0.95v 309.755n 0.95v 314.745n 0.95v 314.755n 0.0v 319.745n 0.0v 319.755n 0.0v 324.745n 0.0v 324.755n 0.0v 329.745n 0.0v 329.755n 0.0v 334.745n 0.0v 334.755n 0.0v 339.745n 0.0v 339.755n 0.0v 344.745n 0.0v 344.755n 0.95v 349.745n 0.95v 349.755n 0.95v 354.745n 0.95v 354.755n 0.95v 359.745n 0.95v 359.755n 0.95v 364.745n 0.95v 364.755n 0.95v 369.745n 0.95v 369.755n 0.95v 374.745n 0.95v 374.755n 0.95v 379.745n 0.95v 379.755n 0.95v 384.745n 0.95v 384.755n 0.95v 389.745n 0.95v 389.755n 0.0v 394.745n 0.0v 394.755n 0.0v 399.745n 0.0v 399.755n 0.0v 404.745n 0.0v 404.755n 0.0v 409.745n 0.0v 409.755n 0.95v 414.745n 0.95v 414.755n 0.95v 419.745n 0.95v 419.755n 0.95v 424.745n 0.95v 424.755n 0.0v 429.745n 0.0v 429.755n 0.0v 434.745n 0.0v 434.755n 0.0v 439.745n 0.0v 439.755n 0.0v 444.745n 0.0v 444.755n 0.95v 449.745n 0.95v 449.755n 0.95v 454.745n 0.95v 454.755n 0.95v 459.745n 0.95v 459.755n 0.0v 464.745n 0.0v 464.755n 0.0v 469.745n 0.0v 469.755n 0.0v 474.745n 0.0v 474.755n 0.0v 479.745n 0.0v 479.755n 0.0v 484.745n 0.0v 484.755n 0.0v 489.745n 0.0v 489.755n 0.95v 494.745n 0.95v 494.755n 0.95v 499.745n 0.95v 499.755n 0.0v 504.745n 0.0v 504.755n 0.0v 509.745n 0.0v 509.755n 0.0v 514.745n 0.0v 514.755n 0.0v 519.745n 0.0v 519.755n 0.95v 524.745n 0.95v 524.755n 0.95v 529.745n 0.95v 529.755n 0.0v 534.745n 0.0v 534.755n 0.0v 539.745n 0.0v 539.755n 0.95v 544.745n 0.95v 544.755n 0.95v 549.745n 0.95v 549.755n 0.95v 554.745n 0.95v 554.755n 0.95v 559.745n 0.95v 559.755n 0.95v 564.745n 0.95v 564.755n 0.95v 569.745n 0.95v 569.755n 0.95v 574.745n 0.95v 574.755n 0.95v 579.745n 0.95v 579.755n 0.95v 584.745n 0.95v 584.755n 0.95v 589.745n 0.95v 589.755n 0.95v 594.745n 0.95v 594.755n 0.0v 599.745n 0.0v 599.755n 0.0v 604.745n 0.0v 604.755n 0.0v 609.745n 0.0v 609.755n 0.0v 614.745n 0.0v 614.755n 0.0v 619.745n 0.0v 619.755n 0.0v 624.745n 0.0v 624.755n 0.0v 629.745n 0.0v 629.755n 0.0v 634.745n 0.0v 634.755n 0.0v 639.745n 0.0v 639.755n 0.0v 644.745n 0.0v 644.755n 0.0v 649.745n 0.0v 649.755n 0.0v 654.745n 0.0v 654.755n 0.0v 659.745n 0.0v 659.755n 0.0v 664.745n 0.0v 664.755n 0.0v 669.745n 0.0v 669.755n 0.95v 674.745n 0.95v 674.755n 0.95v 679.745n 0.95v 679.755n 0.95v 684.745n 0.95v 684.755n 0.0v 689.745n 0.0v 689.755n 0.0v 694.745n 0.0v 694.755n 0.0v 699.745n 0.0v 699.755n 0.0v 704.745n 0.0v 704.755n 0.0v 709.745n 0.0v 709.755n 0.0v 714.745n 0.0v 714.755n 0.0v 719.745n 0.0v 719.755n 0.0v 724.745n 0.0v 724.755n 0.0v 729.745n 0.0v 729.755n 0.95v 734.745n 0.95v 734.755n 0.95v 739.745n 0.95v 739.755n 0.95v 744.745n 0.95v 744.755n 0.95v 749.745n 0.95v 749.755n 0.95v 754.745n 0.95v 754.755n 0.95v 759.745n 0.95v 759.755n 0.95v 764.745n 0.95v 764.755n 0.0v 769.745n 0.0v 769.755n 0.0v 774.745n 0.0v 774.755n 0.0v 779.745n 0.0v 779.755n 0.0v 784.745n 0.0v 784.755n 0.0v 789.745n 0.0v 789.755n 0.0v 794.745n 0.0v 794.755n 0.0v 799.745n 0.0v 799.755n 0.95v 804.745n 0.95v 804.755n 0.95v 809.745n 0.95v 809.755n 0.95v 814.745n 0.95v 814.755n 0.95v 819.745n 0.95v 819.755n 0.95v 824.745n 0.95v 824.755n 0.95v 829.745n 0.95v 829.755n 0.95v 834.745n 0.95v 834.755n 0.95v 839.745n 0.95v 839.755n 0.0v 844.745n 0.0v 844.755n 0.95v 849.745n 0.95v 849.755n 0.95v 854.745n 0.95v 854.755n 0.95v 859.745n 0.95v 859.755n 0.95v 864.745n 0.95v 864.755n 0.0v 869.745n 0.0v 869.755n 0.95v 874.745n 0.95v 874.755n 0.95v 879.745n 0.95v 879.755n 0.95v 884.745n 0.95v 884.755n 0.95v 889.745n 0.95v 889.755n 0.0v 894.745n 0.0v 894.755n 0.0v 899.745n 0.0v 899.755n 0.0v 904.745n 0.0v 904.755n 0.0v 909.745n 0.0v 909.755n 0.95v 914.745n 0.95v 914.755n 0.95v 919.745n 0.95v 919.755n 0.0v 924.745n 0.0v 924.755n 0.95v 929.745n 0.95v 929.755n 0.95v 934.745n 0.95v 934.755n 0.0v 939.745n 0.0v 939.755n 0.0v 944.745n 0.0v 944.755n 0.0v 949.745n 0.0v 949.755n 0.95v 954.745n 0.95v 954.755n 0.0v 959.745n 0.0v 959.755n 0.0v 964.745n 0.0v 964.755n 0.0v 969.745n 0.0v 969.755n 0.0v 974.745n 0.0v 974.755n 0.0v 979.745n 0.0v 979.755n 0.0v 984.745n 0.0v 984.755n 0.95v 989.745n 0.95v 989.755n 0.0v 994.745n 0.0v 994.755n 0.0v 999.745n 0.0v 999.755n 0.0v 1004.745n 0.0v 1004.755n 0.0v 1009.745n 0.0v 1009.755n 0.0v 1014.745n 0.0v 1014.755n 0.0v 1019.745n 0.0v 1019.755n 0.0v 1024.745n 0.0v 1024.755n 0.0v )
* (time, data): [(0, 0), (5, 1), (10, 0), (15, 1), (20, 1), (25, 1), (30, 1), (35, 0), (40, 1), (45, 0), (50, 1), (55, 1), (60, 0), (65, 0), (70, 0), (75, 0), (80, 1), (85, 0), (90, 0), (95, 0), (100, 0), (105, 0), (110, 0), (115, 0), (120, 0), (125, 1), (130, 0), (135, 0), (140, 0), (145, 0), (150, 0), (155, 0), (160, 0), (165, 1), (170, 1), (175, 1), (180, 1), (185, 0), (190, 0), (195, 0), (200, 1), (205, 1), (210, 1), (215, 1), (220, 1), (225, 1), (230, 1), (235, 1), (240, 1), (245, 0), (250, 0), (255, 0), (260, 0), (265, 0), (270, 0), (275, 0), (280, 0), (285, 0), (290, 0), (295, 0), (300, 0), (305, 0), (310, 0), (315, 0), (320, 0), (325, 0), (330, 0), (335, 0), (340, 0), (345, 1), (350, 1), (355, 1), (360, 0), (365, 0), (370, 0), (375, 0), (380, 0), (385, 0), (390, 1), (395, 1), (400, 1), (405, 1), (410, 1), (415, 1), (420, 1), (425, 1), (430, 1), (435, 1), (440, 0), (445, 0), (450, 0), (455, 0), (460, 1), (465, 0), (470, 0), (475, 1), (480, 0), (485, 1), (490, 0), (495, 0), (500, 0), (505, 0), (510, 0), (515, 0), (520, 1), (525, 1), (530, 0), (535, 0), (540, 1), (545, 1), (550, 1), (555, 0), (560, 0), (565, 0), (570, 0), (575, 0), (580, 0), (585, 0), (590, 0), (595, 0), (600, 0), (605, 0), (610, 0), (615, 0), (620, 0), (625, 0), (630, 0), (635, 0), (640, 0), (645, 0), (650, 0), (655, 0), (660, 0), (665, 0), (670, 1), (675, 0), (680, 0), (685, 1), (690, 1), (695, 1), (700, 1), (705, 1), (710, 1), (715, 1), (720, 0), (725, 0), (730, 1), (735, 1), (740, 1), (745, 0), (750, 0), (755, 0), (760, 0), (765, 0), (770, 0), (775, 0), (780, 0), (785, 0), (790, 0), (795, 0), (800, 0), (805, 0), (810, 0), (815, 0), (820, 0), (825, 0), (830, 0), (835, 0), (840, 1), (845, 1), (850, 0), (855, 1), (860, 1), (865, 1), (870, 1), (875, 1), (880, 1), (885, 0), (890, 1), (895, 1), (900, 1), (905, 0), (910, 1), (915, 1), (920, 0), (925, 1), (930, 1), (935, 1), (940, 1), (945, 1), (950, 0), (955, 1), (960, 1), (965, 1), (970, 0), (975, 0), (980, 0), (985, 1), (990, 1), (995, 1), (1000, 1), (1005, 1), (1010, 1), (1015, 1), (1020, 1), (1025, 1)]
Vdin0_19  din0_19  0 PWL (0n 0.0v 4.745n 0.0v 4.755n 0.95v 9.745n 0.95v 9.755n 0.0v 14.745n 0.0v 14.755n 0.95v 19.745n 0.95v 19.755n 0.95v 24.745n 0.95v 24.755n 0.95v 29.745n 0.95v 29.755n 0.95v 34.745n 0.95v 34.755n 0.0v 39.745n 0.0v 39.755n 0.95v 44.745n 0.95v 44.755n 0.0v 49.745n 0.0v 49.755n 0.95v 54.745n 0.95v 54.755n 0.95v 59.745n 0.95v 59.755n 0.0v 64.745n 0.0v 64.755n 0.0v 69.745n 0.0v 69.755n 0.0v 74.745n 0.0v 74.755n 0.0v 79.745n 0.0v 79.755n 0.95v 84.745n 0.95v 84.755n 0.0v 89.745n 0.0v 89.755n 0.0v 94.745n 0.0v 94.755n 0.0v 99.745n 0.0v 99.755n 0.0v 104.745n 0.0v 104.755n 0.0v 109.745n 0.0v 109.755n 0.0v 114.745n 0.0v 114.755n 0.0v 119.745n 0.0v 119.755n 0.0v 124.745n 0.0v 124.755n 0.95v 129.745n 0.95v 129.755n 0.0v 134.745n 0.0v 134.755n 0.0v 139.745n 0.0v 139.755n 0.0v 144.745n 0.0v 144.755n 0.0v 149.745n 0.0v 149.755n 0.0v 154.745n 0.0v 154.755n 0.0v 159.745n 0.0v 159.755n 0.0v 164.745n 0.0v 164.755n 0.95v 169.745n 0.95v 169.755n 0.95v 174.745n 0.95v 174.755n 0.95v 179.745n 0.95v 179.755n 0.95v 184.745n 0.95v 184.755n 0.0v 189.745n 0.0v 189.755n 0.0v 194.745n 0.0v 194.755n 0.0v 199.745n 0.0v 199.755n 0.95v 204.745n 0.95v 204.755n 0.95v 209.745n 0.95v 209.755n 0.95v 214.745n 0.95v 214.755n 0.95v 219.745n 0.95v 219.755n 0.95v 224.745n 0.95v 224.755n 0.95v 229.745n 0.95v 229.755n 0.95v 234.745n 0.95v 234.755n 0.95v 239.745n 0.95v 239.755n 0.95v 244.745n 0.95v 244.755n 0.0v 249.745n 0.0v 249.755n 0.0v 254.745n 0.0v 254.755n 0.0v 259.745n 0.0v 259.755n 0.0v 264.745n 0.0v 264.755n 0.0v 269.745n 0.0v 269.755n 0.0v 274.745n 0.0v 274.755n 0.0v 279.745n 0.0v 279.755n 0.0v 284.745n 0.0v 284.755n 0.0v 289.745n 0.0v 289.755n 0.0v 294.745n 0.0v 294.755n 0.0v 299.745n 0.0v 299.755n 0.0v 304.745n 0.0v 304.755n 0.0v 309.745n 0.0v 309.755n 0.0v 314.745n 0.0v 314.755n 0.0v 319.745n 0.0v 319.755n 0.0v 324.745n 0.0v 324.755n 0.0v 329.745n 0.0v 329.755n 0.0v 334.745n 0.0v 334.755n 0.0v 339.745n 0.0v 339.755n 0.0v 344.745n 0.0v 344.755n 0.95v 349.745n 0.95v 349.755n 0.95v 354.745n 0.95v 354.755n 0.95v 359.745n 0.95v 359.755n 0.0v 364.745n 0.0v 364.755n 0.0v 369.745n 0.0v 369.755n 0.0v 374.745n 0.0v 374.755n 0.0v 379.745n 0.0v 379.755n 0.0v 384.745n 0.0v 384.755n 0.0v 389.745n 0.0v 389.755n 0.95v 394.745n 0.95v 394.755n 0.95v 399.745n 0.95v 399.755n 0.95v 404.745n 0.95v 404.755n 0.95v 409.745n 0.95v 409.755n 0.95v 414.745n 0.95v 414.755n 0.95v 419.745n 0.95v 419.755n 0.95v 424.745n 0.95v 424.755n 0.95v 429.745n 0.95v 429.755n 0.95v 434.745n 0.95v 434.755n 0.95v 439.745n 0.95v 439.755n 0.0v 444.745n 0.0v 444.755n 0.0v 449.745n 0.0v 449.755n 0.0v 454.745n 0.0v 454.755n 0.0v 459.745n 0.0v 459.755n 0.95v 464.745n 0.95v 464.755n 0.0v 469.745n 0.0v 469.755n 0.0v 474.745n 0.0v 474.755n 0.95v 479.745n 0.95v 479.755n 0.0v 484.745n 0.0v 484.755n 0.95v 489.745n 0.95v 489.755n 0.0v 494.745n 0.0v 494.755n 0.0v 499.745n 0.0v 499.755n 0.0v 504.745n 0.0v 504.755n 0.0v 509.745n 0.0v 509.755n 0.0v 514.745n 0.0v 514.755n 0.0v 519.745n 0.0v 519.755n 0.95v 524.745n 0.95v 524.755n 0.95v 529.745n 0.95v 529.755n 0.0v 534.745n 0.0v 534.755n 0.0v 539.745n 0.0v 539.755n 0.95v 544.745n 0.95v 544.755n 0.95v 549.745n 0.95v 549.755n 0.95v 554.745n 0.95v 554.755n 0.0v 559.745n 0.0v 559.755n 0.0v 564.745n 0.0v 564.755n 0.0v 569.745n 0.0v 569.755n 0.0v 574.745n 0.0v 574.755n 0.0v 579.745n 0.0v 579.755n 0.0v 584.745n 0.0v 584.755n 0.0v 589.745n 0.0v 589.755n 0.0v 594.745n 0.0v 594.755n 0.0v 599.745n 0.0v 599.755n 0.0v 604.745n 0.0v 604.755n 0.0v 609.745n 0.0v 609.755n 0.0v 614.745n 0.0v 614.755n 0.0v 619.745n 0.0v 619.755n 0.0v 624.745n 0.0v 624.755n 0.0v 629.745n 0.0v 629.755n 0.0v 634.745n 0.0v 634.755n 0.0v 639.745n 0.0v 639.755n 0.0v 644.745n 0.0v 644.755n 0.0v 649.745n 0.0v 649.755n 0.0v 654.745n 0.0v 654.755n 0.0v 659.745n 0.0v 659.755n 0.0v 664.745n 0.0v 664.755n 0.0v 669.745n 0.0v 669.755n 0.95v 674.745n 0.95v 674.755n 0.0v 679.745n 0.0v 679.755n 0.0v 684.745n 0.0v 684.755n 0.95v 689.745n 0.95v 689.755n 0.95v 694.745n 0.95v 694.755n 0.95v 699.745n 0.95v 699.755n 0.95v 704.745n 0.95v 704.755n 0.95v 709.745n 0.95v 709.755n 0.95v 714.745n 0.95v 714.755n 0.95v 719.745n 0.95v 719.755n 0.0v 724.745n 0.0v 724.755n 0.0v 729.745n 0.0v 729.755n 0.95v 734.745n 0.95v 734.755n 0.95v 739.745n 0.95v 739.755n 0.95v 744.745n 0.95v 744.755n 0.0v 749.745n 0.0v 749.755n 0.0v 754.745n 0.0v 754.755n 0.0v 759.745n 0.0v 759.755n 0.0v 764.745n 0.0v 764.755n 0.0v 769.745n 0.0v 769.755n 0.0v 774.745n 0.0v 774.755n 0.0v 779.745n 0.0v 779.755n 0.0v 784.745n 0.0v 784.755n 0.0v 789.745n 0.0v 789.755n 0.0v 794.745n 0.0v 794.755n 0.0v 799.745n 0.0v 799.755n 0.0v 804.745n 0.0v 804.755n 0.0v 809.745n 0.0v 809.755n 0.0v 814.745n 0.0v 814.755n 0.0v 819.745n 0.0v 819.755n 0.0v 824.745n 0.0v 824.755n 0.0v 829.745n 0.0v 829.755n 0.0v 834.745n 0.0v 834.755n 0.0v 839.745n 0.0v 839.755n 0.95v 844.745n 0.95v 844.755n 0.95v 849.745n 0.95v 849.755n 0.0v 854.745n 0.0v 854.755n 0.95v 859.745n 0.95v 859.755n 0.95v 864.745n 0.95v 864.755n 0.95v 869.745n 0.95v 869.755n 0.95v 874.745n 0.95v 874.755n 0.95v 879.745n 0.95v 879.755n 0.95v 884.745n 0.95v 884.755n 0.0v 889.745n 0.0v 889.755n 0.95v 894.745n 0.95v 894.755n 0.95v 899.745n 0.95v 899.755n 0.95v 904.745n 0.95v 904.755n 0.0v 909.745n 0.0v 909.755n 0.95v 914.745n 0.95v 914.755n 0.95v 919.745n 0.95v 919.755n 0.0v 924.745n 0.0v 924.755n 0.95v 929.745n 0.95v 929.755n 0.95v 934.745n 0.95v 934.755n 0.95v 939.745n 0.95v 939.755n 0.95v 944.745n 0.95v 944.755n 0.95v 949.745n 0.95v 949.755n 0.0v 954.745n 0.0v 954.755n 0.95v 959.745n 0.95v 959.755n 0.95v 964.745n 0.95v 964.755n 0.95v 969.745n 0.95v 969.755n 0.0v 974.745n 0.0v 974.755n 0.0v 979.745n 0.0v 979.755n 0.0v 984.745n 0.0v 984.755n 0.95v 989.745n 0.95v 989.755n 0.95v 994.745n 0.95v 994.755n 0.95v 999.745n 0.95v 999.755n 0.95v 1004.745n 0.95v 1004.755n 0.95v 1009.745n 0.95v 1009.755n 0.95v 1014.745n 0.95v 1014.755n 0.95v 1019.745n 0.95v 1019.755n 0.95v 1024.745n 0.95v 1024.755n 0.95v )
* (time, data): [(0, 0), (5, 0), (10, 1), (15, 0), (20, 0), (25, 0), (30, 1), (35, 0), (40, 0), (45, 1), (50, 1), (55, 1), (60, 0), (65, 0), (70, 0), (75, 1), (80, 0), (85, 1), (90, 1), (95, 1), (100, 1), (105, 1), (110, 1), (115, 1), (120, 1), (125, 0), (130, 1), (135, 1), (140, 1), (145, 1), (150, 1), (155, 1), (160, 1), (165, 1), (170, 1), (175, 1), (180, 0), (185, 0), (190, 0), (195, 0), (200, 0), (205, 0), (210, 0), (215, 0), (220, 0), (225, 0), (230, 0), (235, 0), (240, 0), (245, 0), (250, 0), (255, 0), (260, 0), (265, 0), (270, 1), (275, 1), (280, 1), (285, 1), (290, 1), (295, 1), (300, 1), (305, 1), (310, 1), (315, 1), (320, 1), (325, 1), (330, 1), (335, 1), (340, 1), (345, 0), (350, 0), (355, 0), (360, 1), (365, 1), (370, 1), (375, 1), (380, 1), (385, 1), (390, 1), (395, 1), (400, 1), (405, 1), (410, 0), (415, 0), (420, 0), (425, 1), (430, 1), (435, 1), (440, 0), (445, 0), (450, 0), (455, 0), (460, 0), (465, 1), (470, 1), (475, 1), (480, 0), (485, 1), (490, 0), (495, 0), (500, 1), (505, 1), (510, 1), (515, 1), (520, 0), (525, 0), (530, 0), (535, 1), (540, 1), (545, 1), (550, 1), (555, 0), (560, 0), (565, 0), (570, 0), (575, 0), (580, 0), (585, 0), (590, 0), (595, 0), (600, 0), (605, 0), (610, 0), (615, 0), (620, 0), (625, 0), (630, 0), (635, 0), (640, 0), (645, 1), (650, 1), (655, 1), (660, 1), (665, 1), (670, 0), (675, 0), (680, 0), (685, 1), (690, 1), (695, 1), (700, 1), (705, 1), (710, 1), (715, 1), (720, 0), (725, 0), (730, 1), (735, 1), (740, 1), (745, 1), (750, 1), (755, 1), (760, 1), (765, 1), (770, 1), (775, 1), (780, 1), (785, 1), (790, 1), (795, 1), (800, 0), (805, 0), (810, 0), (815, 0), (820, 0), (825, 0), (830, 0), (835, 0), (840, 1), (845, 0), (850, 1), (855, 0), (860, 0), (865, 0), (870, 1), (875, 1), (880, 1), (885, 0), (890, 0), (895, 0), (900, 0), (905, 0), (910, 0), (915, 0), (920, 0), (925, 1), (930, 1), (935, 0), (940, 0), (945, 0), (950, 1), (955, 1), (960, 1), (965, 1), (970, 1), (975, 1), (980, 0), (985, 1), (990, 1), (995, 1), (1000, 1), (1005, 0), (1010, 0), (1015, 0), (1020, 0), (1025, 0)]
Vdin0_20  din0_20  0 PWL (0n 0.0v 4.745n 0.0v 4.755n 0.0v 9.745n 0.0v 9.755n 0.95v 14.745n 0.95v 14.755n 0.0v 19.745n 0.0v 19.755n 0.0v 24.745n 0.0v 24.755n 0.0v 29.745n 0.0v 29.755n 0.95v 34.745n 0.95v 34.755n 0.0v 39.745n 0.0v 39.755n 0.0v 44.745n 0.0v 44.755n 0.95v 49.745n 0.95v 49.755n 0.95v 54.745n 0.95v 54.755n 0.95v 59.745n 0.95v 59.755n 0.0v 64.745n 0.0v 64.755n 0.0v 69.745n 0.0v 69.755n 0.0v 74.745n 0.0v 74.755n 0.95v 79.745n 0.95v 79.755n 0.0v 84.745n 0.0v 84.755n 0.95v 89.745n 0.95v 89.755n 0.95v 94.745n 0.95v 94.755n 0.95v 99.745n 0.95v 99.755n 0.95v 104.745n 0.95v 104.755n 0.95v 109.745n 0.95v 109.755n 0.95v 114.745n 0.95v 114.755n 0.95v 119.745n 0.95v 119.755n 0.95v 124.745n 0.95v 124.755n 0.0v 129.745n 0.0v 129.755n 0.95v 134.745n 0.95v 134.755n 0.95v 139.745n 0.95v 139.755n 0.95v 144.745n 0.95v 144.755n 0.95v 149.745n 0.95v 149.755n 0.95v 154.745n 0.95v 154.755n 0.95v 159.745n 0.95v 159.755n 0.95v 164.745n 0.95v 164.755n 0.95v 169.745n 0.95v 169.755n 0.95v 174.745n 0.95v 174.755n 0.95v 179.745n 0.95v 179.755n 0.0v 184.745n 0.0v 184.755n 0.0v 189.745n 0.0v 189.755n 0.0v 194.745n 0.0v 194.755n 0.0v 199.745n 0.0v 199.755n 0.0v 204.745n 0.0v 204.755n 0.0v 209.745n 0.0v 209.755n 0.0v 214.745n 0.0v 214.755n 0.0v 219.745n 0.0v 219.755n 0.0v 224.745n 0.0v 224.755n 0.0v 229.745n 0.0v 229.755n 0.0v 234.745n 0.0v 234.755n 0.0v 239.745n 0.0v 239.755n 0.0v 244.745n 0.0v 244.755n 0.0v 249.745n 0.0v 249.755n 0.0v 254.745n 0.0v 254.755n 0.0v 259.745n 0.0v 259.755n 0.0v 264.745n 0.0v 264.755n 0.0v 269.745n 0.0v 269.755n 0.95v 274.745n 0.95v 274.755n 0.95v 279.745n 0.95v 279.755n 0.95v 284.745n 0.95v 284.755n 0.95v 289.745n 0.95v 289.755n 0.95v 294.745n 0.95v 294.755n 0.95v 299.745n 0.95v 299.755n 0.95v 304.745n 0.95v 304.755n 0.95v 309.745n 0.95v 309.755n 0.95v 314.745n 0.95v 314.755n 0.95v 319.745n 0.95v 319.755n 0.95v 324.745n 0.95v 324.755n 0.95v 329.745n 0.95v 329.755n 0.95v 334.745n 0.95v 334.755n 0.95v 339.745n 0.95v 339.755n 0.95v 344.745n 0.95v 344.755n 0.0v 349.745n 0.0v 349.755n 0.0v 354.745n 0.0v 354.755n 0.0v 359.745n 0.0v 359.755n 0.95v 364.745n 0.95v 364.755n 0.95v 369.745n 0.95v 369.755n 0.95v 374.745n 0.95v 374.755n 0.95v 379.745n 0.95v 379.755n 0.95v 384.745n 0.95v 384.755n 0.95v 389.745n 0.95v 389.755n 0.95v 394.745n 0.95v 394.755n 0.95v 399.745n 0.95v 399.755n 0.95v 404.745n 0.95v 404.755n 0.95v 409.745n 0.95v 409.755n 0.0v 414.745n 0.0v 414.755n 0.0v 419.745n 0.0v 419.755n 0.0v 424.745n 0.0v 424.755n 0.95v 429.745n 0.95v 429.755n 0.95v 434.745n 0.95v 434.755n 0.95v 439.745n 0.95v 439.755n 0.0v 444.745n 0.0v 444.755n 0.0v 449.745n 0.0v 449.755n 0.0v 454.745n 0.0v 454.755n 0.0v 459.745n 0.0v 459.755n 0.0v 464.745n 0.0v 464.755n 0.95v 469.745n 0.95v 469.755n 0.95v 474.745n 0.95v 474.755n 0.95v 479.745n 0.95v 479.755n 0.0v 484.745n 0.0v 484.755n 0.95v 489.745n 0.95v 489.755n 0.0v 494.745n 0.0v 494.755n 0.0v 499.745n 0.0v 499.755n 0.95v 504.745n 0.95v 504.755n 0.95v 509.745n 0.95v 509.755n 0.95v 514.745n 0.95v 514.755n 0.95v 519.745n 0.95v 519.755n 0.0v 524.745n 0.0v 524.755n 0.0v 529.745n 0.0v 529.755n 0.0v 534.745n 0.0v 534.755n 0.95v 539.745n 0.95v 539.755n 0.95v 544.745n 0.95v 544.755n 0.95v 549.745n 0.95v 549.755n 0.95v 554.745n 0.95v 554.755n 0.0v 559.745n 0.0v 559.755n 0.0v 564.745n 0.0v 564.755n 0.0v 569.745n 0.0v 569.755n 0.0v 574.745n 0.0v 574.755n 0.0v 579.745n 0.0v 579.755n 0.0v 584.745n 0.0v 584.755n 0.0v 589.745n 0.0v 589.755n 0.0v 594.745n 0.0v 594.755n 0.0v 599.745n 0.0v 599.755n 0.0v 604.745n 0.0v 604.755n 0.0v 609.745n 0.0v 609.755n 0.0v 614.745n 0.0v 614.755n 0.0v 619.745n 0.0v 619.755n 0.0v 624.745n 0.0v 624.755n 0.0v 629.745n 0.0v 629.755n 0.0v 634.745n 0.0v 634.755n 0.0v 639.745n 0.0v 639.755n 0.0v 644.745n 0.0v 644.755n 0.95v 649.745n 0.95v 649.755n 0.95v 654.745n 0.95v 654.755n 0.95v 659.745n 0.95v 659.755n 0.95v 664.745n 0.95v 664.755n 0.95v 669.745n 0.95v 669.755n 0.0v 674.745n 0.0v 674.755n 0.0v 679.745n 0.0v 679.755n 0.0v 684.745n 0.0v 684.755n 0.95v 689.745n 0.95v 689.755n 0.95v 694.745n 0.95v 694.755n 0.95v 699.745n 0.95v 699.755n 0.95v 704.745n 0.95v 704.755n 0.95v 709.745n 0.95v 709.755n 0.95v 714.745n 0.95v 714.755n 0.95v 719.745n 0.95v 719.755n 0.0v 724.745n 0.0v 724.755n 0.0v 729.745n 0.0v 729.755n 0.95v 734.745n 0.95v 734.755n 0.95v 739.745n 0.95v 739.755n 0.95v 744.745n 0.95v 744.755n 0.95v 749.745n 0.95v 749.755n 0.95v 754.745n 0.95v 754.755n 0.95v 759.745n 0.95v 759.755n 0.95v 764.745n 0.95v 764.755n 0.95v 769.745n 0.95v 769.755n 0.95v 774.745n 0.95v 774.755n 0.95v 779.745n 0.95v 779.755n 0.95v 784.745n 0.95v 784.755n 0.95v 789.745n 0.95v 789.755n 0.95v 794.745n 0.95v 794.755n 0.95v 799.745n 0.95v 799.755n 0.0v 804.745n 0.0v 804.755n 0.0v 809.745n 0.0v 809.755n 0.0v 814.745n 0.0v 814.755n 0.0v 819.745n 0.0v 819.755n 0.0v 824.745n 0.0v 824.755n 0.0v 829.745n 0.0v 829.755n 0.0v 834.745n 0.0v 834.755n 0.0v 839.745n 0.0v 839.755n 0.95v 844.745n 0.95v 844.755n 0.0v 849.745n 0.0v 849.755n 0.95v 854.745n 0.95v 854.755n 0.0v 859.745n 0.0v 859.755n 0.0v 864.745n 0.0v 864.755n 0.0v 869.745n 0.0v 869.755n 0.95v 874.745n 0.95v 874.755n 0.95v 879.745n 0.95v 879.755n 0.95v 884.745n 0.95v 884.755n 0.0v 889.745n 0.0v 889.755n 0.0v 894.745n 0.0v 894.755n 0.0v 899.745n 0.0v 899.755n 0.0v 904.745n 0.0v 904.755n 0.0v 909.745n 0.0v 909.755n 0.0v 914.745n 0.0v 914.755n 0.0v 919.745n 0.0v 919.755n 0.0v 924.745n 0.0v 924.755n 0.95v 929.745n 0.95v 929.755n 0.95v 934.745n 0.95v 934.755n 0.0v 939.745n 0.0v 939.755n 0.0v 944.745n 0.0v 944.755n 0.0v 949.745n 0.0v 949.755n 0.95v 954.745n 0.95v 954.755n 0.95v 959.745n 0.95v 959.755n 0.95v 964.745n 0.95v 964.755n 0.95v 969.745n 0.95v 969.755n 0.95v 974.745n 0.95v 974.755n 0.95v 979.745n 0.95v 979.755n 0.0v 984.745n 0.0v 984.755n 0.95v 989.745n 0.95v 989.755n 0.95v 994.745n 0.95v 994.755n 0.95v 999.745n 0.95v 999.755n 0.95v 1004.745n 0.95v 1004.755n 0.0v 1009.745n 0.0v 1009.755n 0.0v 1014.745n 0.0v 1014.755n 0.0v 1019.745n 0.0v 1019.755n 0.0v 1024.745n 0.0v 1024.755n 0.0v )
* (time, data): [(0, 0), (5, 0), (10, 1), (15, 0), (20, 0), (25, 0), (30, 1), (35, 0), (40, 1), (45, 1), (50, 0), (55, 0), (60, 1), (65, 0), (70, 0), (75, 0), (80, 1), (85, 0), (90, 0), (95, 0), (100, 0), (105, 1), (110, 1), (115, 1), (120, 1), (125, 1), (130, 0), (135, 0), (140, 0), (145, 0), (150, 0), (155, 0), (160, 0), (165, 0), (170, 0), (175, 0), (180, 1), (185, 0), (190, 0), (195, 0), (200, 0), (205, 0), (210, 0), (215, 0), (220, 0), (225, 0), (230, 1), (235, 1), (240, 1), (245, 0), (250, 0), (255, 0), (260, 0), (265, 0), (270, 1), (275, 1), (280, 1), (285, 0), (290, 0), (295, 0), (300, 0), (305, 0), (310, 0), (315, 0), (320, 0), (325, 0), (330, 0), (335, 0), (340, 0), (345, 1), (350, 1), (355, 1), (360, 1), (365, 1), (370, 1), (375, 1), (380, 1), (385, 1), (390, 0), (395, 0), (400, 0), (405, 0), (410, 0), (415, 0), (420, 0), (425, 0), (430, 0), (435, 1), (440, 1), (445, 0), (450, 0), (455, 0), (460, 1), (465, 0), (470, 0), (475, 0), (480, 1), (485, 0), (490, 0), (495, 0), (500, 1), (505, 1), (510, 1), (515, 1), (520, 1), (525, 1), (530, 1), (535, 0), (540, 1), (545, 1), (550, 1), (555, 0), (560, 1), (565, 1), (570, 1), (575, 1), (580, 1), (585, 1), (590, 1), (595, 0), (600, 0), (605, 0), (610, 0), (615, 0), (620, 0), (625, 0), (630, 0), (635, 0), (640, 1), (645, 0), (650, 0), (655, 0), (660, 0), (665, 0), (670, 1), (675, 0), (680, 0), (685, 1), (690, 1), (695, 1), (700, 1), (705, 1), (710, 1), (715, 1), (720, 0), (725, 0), (730, 1), (735, 0), (740, 0), (745, 1), (750, 1), (755, 1), (760, 1), (765, 1), (770, 1), (775, 1), (780, 1), (785, 1), (790, 1), (795, 1), (800, 1), (805, 1), (810, 1), (815, 1), (820, 1), (825, 1), (830, 1), (835, 1), (840, 1), (845, 1), (850, 1), (855, 1), (860, 1), (865, 0), (870, 1), (875, 1), (880, 1), (885, 0), (890, 0), (895, 0), (900, 0), (905, 0), (910, 0), (915, 0), (920, 0), (925, 0), (930, 0), (935, 1), (940, 1), (945, 1), (950, 0), (955, 1), (960, 1), (965, 1), (970, 0), (975, 0), (980, 1), (985, 0), (990, 1), (995, 1), (1000, 1), (1005, 0), (1010, 0), (1015, 0), (1020, 0), (1025, 0)]
Vdin0_21  din0_21  0 PWL (0n 0.0v 4.745n 0.0v 4.755n 0.0v 9.745n 0.0v 9.755n 0.95v 14.745n 0.95v 14.755n 0.0v 19.745n 0.0v 19.755n 0.0v 24.745n 0.0v 24.755n 0.0v 29.745n 0.0v 29.755n 0.95v 34.745n 0.95v 34.755n 0.0v 39.745n 0.0v 39.755n 0.95v 44.745n 0.95v 44.755n 0.95v 49.745n 0.95v 49.755n 0.0v 54.745n 0.0v 54.755n 0.0v 59.745n 0.0v 59.755n 0.95v 64.745n 0.95v 64.755n 0.0v 69.745n 0.0v 69.755n 0.0v 74.745n 0.0v 74.755n 0.0v 79.745n 0.0v 79.755n 0.95v 84.745n 0.95v 84.755n 0.0v 89.745n 0.0v 89.755n 0.0v 94.745n 0.0v 94.755n 0.0v 99.745n 0.0v 99.755n 0.0v 104.745n 0.0v 104.755n 0.95v 109.745n 0.95v 109.755n 0.95v 114.745n 0.95v 114.755n 0.95v 119.745n 0.95v 119.755n 0.95v 124.745n 0.95v 124.755n 0.95v 129.745n 0.95v 129.755n 0.0v 134.745n 0.0v 134.755n 0.0v 139.745n 0.0v 139.755n 0.0v 144.745n 0.0v 144.755n 0.0v 149.745n 0.0v 149.755n 0.0v 154.745n 0.0v 154.755n 0.0v 159.745n 0.0v 159.755n 0.0v 164.745n 0.0v 164.755n 0.0v 169.745n 0.0v 169.755n 0.0v 174.745n 0.0v 174.755n 0.0v 179.745n 0.0v 179.755n 0.95v 184.745n 0.95v 184.755n 0.0v 189.745n 0.0v 189.755n 0.0v 194.745n 0.0v 194.755n 0.0v 199.745n 0.0v 199.755n 0.0v 204.745n 0.0v 204.755n 0.0v 209.745n 0.0v 209.755n 0.0v 214.745n 0.0v 214.755n 0.0v 219.745n 0.0v 219.755n 0.0v 224.745n 0.0v 224.755n 0.0v 229.745n 0.0v 229.755n 0.95v 234.745n 0.95v 234.755n 0.95v 239.745n 0.95v 239.755n 0.95v 244.745n 0.95v 244.755n 0.0v 249.745n 0.0v 249.755n 0.0v 254.745n 0.0v 254.755n 0.0v 259.745n 0.0v 259.755n 0.0v 264.745n 0.0v 264.755n 0.0v 269.745n 0.0v 269.755n 0.95v 274.745n 0.95v 274.755n 0.95v 279.745n 0.95v 279.755n 0.95v 284.745n 0.95v 284.755n 0.0v 289.745n 0.0v 289.755n 0.0v 294.745n 0.0v 294.755n 0.0v 299.745n 0.0v 299.755n 0.0v 304.745n 0.0v 304.755n 0.0v 309.745n 0.0v 309.755n 0.0v 314.745n 0.0v 314.755n 0.0v 319.745n 0.0v 319.755n 0.0v 324.745n 0.0v 324.755n 0.0v 329.745n 0.0v 329.755n 0.0v 334.745n 0.0v 334.755n 0.0v 339.745n 0.0v 339.755n 0.0v 344.745n 0.0v 344.755n 0.95v 349.745n 0.95v 349.755n 0.95v 354.745n 0.95v 354.755n 0.95v 359.745n 0.95v 359.755n 0.95v 364.745n 0.95v 364.755n 0.95v 369.745n 0.95v 369.755n 0.95v 374.745n 0.95v 374.755n 0.95v 379.745n 0.95v 379.755n 0.95v 384.745n 0.95v 384.755n 0.95v 389.745n 0.95v 389.755n 0.0v 394.745n 0.0v 394.755n 0.0v 399.745n 0.0v 399.755n 0.0v 404.745n 0.0v 404.755n 0.0v 409.745n 0.0v 409.755n 0.0v 414.745n 0.0v 414.755n 0.0v 419.745n 0.0v 419.755n 0.0v 424.745n 0.0v 424.755n 0.0v 429.745n 0.0v 429.755n 0.0v 434.745n 0.0v 434.755n 0.95v 439.745n 0.95v 439.755n 0.95v 444.745n 0.95v 444.755n 0.0v 449.745n 0.0v 449.755n 0.0v 454.745n 0.0v 454.755n 0.0v 459.745n 0.0v 459.755n 0.95v 464.745n 0.95v 464.755n 0.0v 469.745n 0.0v 469.755n 0.0v 474.745n 0.0v 474.755n 0.0v 479.745n 0.0v 479.755n 0.95v 484.745n 0.95v 484.755n 0.0v 489.745n 0.0v 489.755n 0.0v 494.745n 0.0v 494.755n 0.0v 499.745n 0.0v 499.755n 0.95v 504.745n 0.95v 504.755n 0.95v 509.745n 0.95v 509.755n 0.95v 514.745n 0.95v 514.755n 0.95v 519.745n 0.95v 519.755n 0.95v 524.745n 0.95v 524.755n 0.95v 529.745n 0.95v 529.755n 0.95v 534.745n 0.95v 534.755n 0.0v 539.745n 0.0v 539.755n 0.95v 544.745n 0.95v 544.755n 0.95v 549.745n 0.95v 549.755n 0.95v 554.745n 0.95v 554.755n 0.0v 559.745n 0.0v 559.755n 0.95v 564.745n 0.95v 564.755n 0.95v 569.745n 0.95v 569.755n 0.95v 574.745n 0.95v 574.755n 0.95v 579.745n 0.95v 579.755n 0.95v 584.745n 0.95v 584.755n 0.95v 589.745n 0.95v 589.755n 0.95v 594.745n 0.95v 594.755n 0.0v 599.745n 0.0v 599.755n 0.0v 604.745n 0.0v 604.755n 0.0v 609.745n 0.0v 609.755n 0.0v 614.745n 0.0v 614.755n 0.0v 619.745n 0.0v 619.755n 0.0v 624.745n 0.0v 624.755n 0.0v 629.745n 0.0v 629.755n 0.0v 634.745n 0.0v 634.755n 0.0v 639.745n 0.0v 639.755n 0.95v 644.745n 0.95v 644.755n 0.0v 649.745n 0.0v 649.755n 0.0v 654.745n 0.0v 654.755n 0.0v 659.745n 0.0v 659.755n 0.0v 664.745n 0.0v 664.755n 0.0v 669.745n 0.0v 669.755n 0.95v 674.745n 0.95v 674.755n 0.0v 679.745n 0.0v 679.755n 0.0v 684.745n 0.0v 684.755n 0.95v 689.745n 0.95v 689.755n 0.95v 694.745n 0.95v 694.755n 0.95v 699.745n 0.95v 699.755n 0.95v 704.745n 0.95v 704.755n 0.95v 709.745n 0.95v 709.755n 0.95v 714.745n 0.95v 714.755n 0.95v 719.745n 0.95v 719.755n 0.0v 724.745n 0.0v 724.755n 0.0v 729.745n 0.0v 729.755n 0.95v 734.745n 0.95v 734.755n 0.0v 739.745n 0.0v 739.755n 0.0v 744.745n 0.0v 744.755n 0.95v 749.745n 0.95v 749.755n 0.95v 754.745n 0.95v 754.755n 0.95v 759.745n 0.95v 759.755n 0.95v 764.745n 0.95v 764.755n 0.95v 769.745n 0.95v 769.755n 0.95v 774.745n 0.95v 774.755n 0.95v 779.745n 0.95v 779.755n 0.95v 784.745n 0.95v 784.755n 0.95v 789.745n 0.95v 789.755n 0.95v 794.745n 0.95v 794.755n 0.95v 799.745n 0.95v 799.755n 0.95v 804.745n 0.95v 804.755n 0.95v 809.745n 0.95v 809.755n 0.95v 814.745n 0.95v 814.755n 0.95v 819.745n 0.95v 819.755n 0.95v 824.745n 0.95v 824.755n 0.95v 829.745n 0.95v 829.755n 0.95v 834.745n 0.95v 834.755n 0.95v 839.745n 0.95v 839.755n 0.95v 844.745n 0.95v 844.755n 0.95v 849.745n 0.95v 849.755n 0.95v 854.745n 0.95v 854.755n 0.95v 859.745n 0.95v 859.755n 0.95v 864.745n 0.95v 864.755n 0.0v 869.745n 0.0v 869.755n 0.95v 874.745n 0.95v 874.755n 0.95v 879.745n 0.95v 879.755n 0.95v 884.745n 0.95v 884.755n 0.0v 889.745n 0.0v 889.755n 0.0v 894.745n 0.0v 894.755n 0.0v 899.745n 0.0v 899.755n 0.0v 904.745n 0.0v 904.755n 0.0v 909.745n 0.0v 909.755n 0.0v 914.745n 0.0v 914.755n 0.0v 919.745n 0.0v 919.755n 0.0v 924.745n 0.0v 924.755n 0.0v 929.745n 0.0v 929.755n 0.0v 934.745n 0.0v 934.755n 0.95v 939.745n 0.95v 939.755n 0.95v 944.745n 0.95v 944.755n 0.95v 949.745n 0.95v 949.755n 0.0v 954.745n 0.0v 954.755n 0.95v 959.745n 0.95v 959.755n 0.95v 964.745n 0.95v 964.755n 0.95v 969.745n 0.95v 969.755n 0.0v 974.745n 0.0v 974.755n 0.0v 979.745n 0.0v 979.755n 0.95v 984.745n 0.95v 984.755n 0.0v 989.745n 0.0v 989.755n 0.95v 994.745n 0.95v 994.755n 0.95v 999.745n 0.95v 999.755n 0.95v 1004.745n 0.95v 1004.755n 0.0v 1009.745n 0.0v 1009.755n 0.0v 1014.745n 0.0v 1014.755n 0.0v 1019.745n 0.0v 1019.755n 0.0v 1024.745n 0.0v 1024.755n 0.0v )
* (time, data): [(0, 0), (5, 0), (10, 0), (15, 1), (20, 1), (25, 1), (30, 1), (35, 0), (40, 1), (45, 1), (50, 1), (55, 1), (60, 0), (65, 0), (70, 0), (75, 0), (80, 0), (85, 1), (90, 1), (95, 1), (100, 1), (105, 0), (110, 0), (115, 0), (120, 0), (125, 0), (130, 0), (135, 0), (140, 0), (145, 0), (150, 0), (155, 0), (160, 0), (165, 0), (170, 0), (175, 0), (180, 1), (185, 0), (190, 0), (195, 0), (200, 1), (205, 1), (210, 1), (215, 1), (220, 1), (225, 1), (230, 1), (235, 1), (240, 1), (245, 1), (250, 1), (255, 1), (260, 1), (265, 0), (270, 1), (275, 1), (280, 1), (285, 1), (290, 1), (295, 1), (300, 1), (305, 1), (310, 1), (315, 1), (320, 1), (325, 1), (330, 1), (335, 1), (340, 1), (345, 1), (350, 1), (355, 1), (360, 1), (365, 1), (370, 1), (375, 1), (380, 1), (385, 1), (390, 1), (395, 1), (400, 1), (405, 1), (410, 0), (415, 0), (420, 0), (425, 0), (430, 0), (435, 0), (440, 1), (445, 1), (450, 1), (455, 1), (460, 0), (465, 1), (470, 1), (475, 1), (480, 0), (485, 1), (490, 0), (495, 0), (500, 1), (505, 1), (510, 1), (515, 1), (520, 0), (525, 0), (530, 1), (535, 1), (540, 1), (545, 1), (550, 1), (555, 1), (560, 1), (565, 1), (570, 1), (575, 1), (580, 1), (585, 1), (590, 1), (595, 0), (600, 0), (605, 0), (610, 0), (615, 0), (620, 0), (625, 0), (630, 0), (635, 0), (640, 0), (645, 0), (650, 0), (655, 0), (660, 0), (665, 0), (670, 0), (675, 0), (680, 0), (685, 0), (690, 0), (695, 0), (700, 0), (705, 0), (710, 0), (715, 0), (720, 0), (725, 0), (730, 1), (735, 1), (740, 1), (745, 0), (750, 0), (755, 0), (760, 0), (765, 1), (770, 1), (775, 1), (780, 1), (785, 1), (790, 1), (795, 1), (800, 1), (805, 1), (810, 1), (815, 1), (820, 1), (825, 1), (830, 1), (835, 1), (840, 0), (845, 0), (850, 1), (855, 0), (860, 0), (865, 1), (870, 0), (875, 0), (880, 0), (885, 0), (890, 1), (895, 1), (900, 1), (905, 0), (910, 1), (915, 1), (920, 0), (925, 1), (930, 1), (935, 0), (940, 0), (945, 0), (950, 0), (955, 1), (960, 1), (965, 1), (970, 0), (975, 0), (980, 0), (985, 1), (990, 0), (995, 0), (1000, 0), (1005, 1), (1010, 1), (1015, 1), (1020, 1), (1025, 1)]
Vdin0_22  din0_22  0 PWL (0n 0.0v 4.745n 0.0v 4.755n 0.0v 9.745n 0.0v 9.755n 0.0v 14.745n 0.0v 14.755n 0.95v 19.745n 0.95v 19.755n 0.95v 24.745n 0.95v 24.755n 0.95v 29.745n 0.95v 29.755n 0.95v 34.745n 0.95v 34.755n 0.0v 39.745n 0.0v 39.755n 0.95v 44.745n 0.95v 44.755n 0.95v 49.745n 0.95v 49.755n 0.95v 54.745n 0.95v 54.755n 0.95v 59.745n 0.95v 59.755n 0.0v 64.745n 0.0v 64.755n 0.0v 69.745n 0.0v 69.755n 0.0v 74.745n 0.0v 74.755n 0.0v 79.745n 0.0v 79.755n 0.0v 84.745n 0.0v 84.755n 0.95v 89.745n 0.95v 89.755n 0.95v 94.745n 0.95v 94.755n 0.95v 99.745n 0.95v 99.755n 0.95v 104.745n 0.95v 104.755n 0.0v 109.745n 0.0v 109.755n 0.0v 114.745n 0.0v 114.755n 0.0v 119.745n 0.0v 119.755n 0.0v 124.745n 0.0v 124.755n 0.0v 129.745n 0.0v 129.755n 0.0v 134.745n 0.0v 134.755n 0.0v 139.745n 0.0v 139.755n 0.0v 144.745n 0.0v 144.755n 0.0v 149.745n 0.0v 149.755n 0.0v 154.745n 0.0v 154.755n 0.0v 159.745n 0.0v 159.755n 0.0v 164.745n 0.0v 164.755n 0.0v 169.745n 0.0v 169.755n 0.0v 174.745n 0.0v 174.755n 0.0v 179.745n 0.0v 179.755n 0.95v 184.745n 0.95v 184.755n 0.0v 189.745n 0.0v 189.755n 0.0v 194.745n 0.0v 194.755n 0.0v 199.745n 0.0v 199.755n 0.95v 204.745n 0.95v 204.755n 0.95v 209.745n 0.95v 209.755n 0.95v 214.745n 0.95v 214.755n 0.95v 219.745n 0.95v 219.755n 0.95v 224.745n 0.95v 224.755n 0.95v 229.745n 0.95v 229.755n 0.95v 234.745n 0.95v 234.755n 0.95v 239.745n 0.95v 239.755n 0.95v 244.745n 0.95v 244.755n 0.95v 249.745n 0.95v 249.755n 0.95v 254.745n 0.95v 254.755n 0.95v 259.745n 0.95v 259.755n 0.95v 264.745n 0.95v 264.755n 0.0v 269.745n 0.0v 269.755n 0.95v 274.745n 0.95v 274.755n 0.95v 279.745n 0.95v 279.755n 0.95v 284.745n 0.95v 284.755n 0.95v 289.745n 0.95v 289.755n 0.95v 294.745n 0.95v 294.755n 0.95v 299.745n 0.95v 299.755n 0.95v 304.745n 0.95v 304.755n 0.95v 309.745n 0.95v 309.755n 0.95v 314.745n 0.95v 314.755n 0.95v 319.745n 0.95v 319.755n 0.95v 324.745n 0.95v 324.755n 0.95v 329.745n 0.95v 329.755n 0.95v 334.745n 0.95v 334.755n 0.95v 339.745n 0.95v 339.755n 0.95v 344.745n 0.95v 344.755n 0.95v 349.745n 0.95v 349.755n 0.95v 354.745n 0.95v 354.755n 0.95v 359.745n 0.95v 359.755n 0.95v 364.745n 0.95v 364.755n 0.95v 369.745n 0.95v 369.755n 0.95v 374.745n 0.95v 374.755n 0.95v 379.745n 0.95v 379.755n 0.95v 384.745n 0.95v 384.755n 0.95v 389.745n 0.95v 389.755n 0.95v 394.745n 0.95v 394.755n 0.95v 399.745n 0.95v 399.755n 0.95v 404.745n 0.95v 404.755n 0.95v 409.745n 0.95v 409.755n 0.0v 414.745n 0.0v 414.755n 0.0v 419.745n 0.0v 419.755n 0.0v 424.745n 0.0v 424.755n 0.0v 429.745n 0.0v 429.755n 0.0v 434.745n 0.0v 434.755n 0.0v 439.745n 0.0v 439.755n 0.95v 444.745n 0.95v 444.755n 0.95v 449.745n 0.95v 449.755n 0.95v 454.745n 0.95v 454.755n 0.95v 459.745n 0.95v 459.755n 0.0v 464.745n 0.0v 464.755n 0.95v 469.745n 0.95v 469.755n 0.95v 474.745n 0.95v 474.755n 0.95v 479.745n 0.95v 479.755n 0.0v 484.745n 0.0v 484.755n 0.95v 489.745n 0.95v 489.755n 0.0v 494.745n 0.0v 494.755n 0.0v 499.745n 0.0v 499.755n 0.95v 504.745n 0.95v 504.755n 0.95v 509.745n 0.95v 509.755n 0.95v 514.745n 0.95v 514.755n 0.95v 519.745n 0.95v 519.755n 0.0v 524.745n 0.0v 524.755n 0.0v 529.745n 0.0v 529.755n 0.95v 534.745n 0.95v 534.755n 0.95v 539.745n 0.95v 539.755n 0.95v 544.745n 0.95v 544.755n 0.95v 549.745n 0.95v 549.755n 0.95v 554.745n 0.95v 554.755n 0.95v 559.745n 0.95v 559.755n 0.95v 564.745n 0.95v 564.755n 0.95v 569.745n 0.95v 569.755n 0.95v 574.745n 0.95v 574.755n 0.95v 579.745n 0.95v 579.755n 0.95v 584.745n 0.95v 584.755n 0.95v 589.745n 0.95v 589.755n 0.95v 594.745n 0.95v 594.755n 0.0v 599.745n 0.0v 599.755n 0.0v 604.745n 0.0v 604.755n 0.0v 609.745n 0.0v 609.755n 0.0v 614.745n 0.0v 614.755n 0.0v 619.745n 0.0v 619.755n 0.0v 624.745n 0.0v 624.755n 0.0v 629.745n 0.0v 629.755n 0.0v 634.745n 0.0v 634.755n 0.0v 639.745n 0.0v 639.755n 0.0v 644.745n 0.0v 644.755n 0.0v 649.745n 0.0v 649.755n 0.0v 654.745n 0.0v 654.755n 0.0v 659.745n 0.0v 659.755n 0.0v 664.745n 0.0v 664.755n 0.0v 669.745n 0.0v 669.755n 0.0v 674.745n 0.0v 674.755n 0.0v 679.745n 0.0v 679.755n 0.0v 684.745n 0.0v 684.755n 0.0v 689.745n 0.0v 689.755n 0.0v 694.745n 0.0v 694.755n 0.0v 699.745n 0.0v 699.755n 0.0v 704.745n 0.0v 704.755n 0.0v 709.745n 0.0v 709.755n 0.0v 714.745n 0.0v 714.755n 0.0v 719.745n 0.0v 719.755n 0.0v 724.745n 0.0v 724.755n 0.0v 729.745n 0.0v 729.755n 0.95v 734.745n 0.95v 734.755n 0.95v 739.745n 0.95v 739.755n 0.95v 744.745n 0.95v 744.755n 0.0v 749.745n 0.0v 749.755n 0.0v 754.745n 0.0v 754.755n 0.0v 759.745n 0.0v 759.755n 0.0v 764.745n 0.0v 764.755n 0.95v 769.745n 0.95v 769.755n 0.95v 774.745n 0.95v 774.755n 0.95v 779.745n 0.95v 779.755n 0.95v 784.745n 0.95v 784.755n 0.95v 789.745n 0.95v 789.755n 0.95v 794.745n 0.95v 794.755n 0.95v 799.745n 0.95v 799.755n 0.95v 804.745n 0.95v 804.755n 0.95v 809.745n 0.95v 809.755n 0.95v 814.745n 0.95v 814.755n 0.95v 819.745n 0.95v 819.755n 0.95v 824.745n 0.95v 824.755n 0.95v 829.745n 0.95v 829.755n 0.95v 834.745n 0.95v 834.755n 0.95v 839.745n 0.95v 839.755n 0.0v 844.745n 0.0v 844.755n 0.0v 849.745n 0.0v 849.755n 0.95v 854.745n 0.95v 854.755n 0.0v 859.745n 0.0v 859.755n 0.0v 864.745n 0.0v 864.755n 0.95v 869.745n 0.95v 869.755n 0.0v 874.745n 0.0v 874.755n 0.0v 879.745n 0.0v 879.755n 0.0v 884.745n 0.0v 884.755n 0.0v 889.745n 0.0v 889.755n 0.95v 894.745n 0.95v 894.755n 0.95v 899.745n 0.95v 899.755n 0.95v 904.745n 0.95v 904.755n 0.0v 909.745n 0.0v 909.755n 0.95v 914.745n 0.95v 914.755n 0.95v 919.745n 0.95v 919.755n 0.0v 924.745n 0.0v 924.755n 0.95v 929.745n 0.95v 929.755n 0.95v 934.745n 0.95v 934.755n 0.0v 939.745n 0.0v 939.755n 0.0v 944.745n 0.0v 944.755n 0.0v 949.745n 0.0v 949.755n 0.0v 954.745n 0.0v 954.755n 0.95v 959.745n 0.95v 959.755n 0.95v 964.745n 0.95v 964.755n 0.95v 969.745n 0.95v 969.755n 0.0v 974.745n 0.0v 974.755n 0.0v 979.745n 0.0v 979.755n 0.0v 984.745n 0.0v 984.755n 0.95v 989.745n 0.95v 989.755n 0.0v 994.745n 0.0v 994.755n 0.0v 999.745n 0.0v 999.755n 0.0v 1004.745n 0.0v 1004.755n 0.95v 1009.745n 0.95v 1009.755n 0.95v 1014.745n 0.95v 1014.755n 0.95v 1019.745n 0.95v 1019.755n 0.95v 1024.745n 0.95v 1024.755n 0.95v )
* (time, data): [(0, 0), (5, 0), (10, 1), (15, 0), (20, 0), (25, 1), (30, 0), (35, 0), (40, 1), (45, 0), (50, 1), (55, 1), (60, 1), (65, 1), (70, 1), (75, 1), (80, 1), (85, 1), (90, 1), (95, 1), (100, 1), (105, 0), (110, 0), (115, 1), (120, 1), (125, 0), (130, 1), (135, 1), (140, 1), (145, 1), (150, 1), (155, 1), (160, 1), (165, 1), (170, 1), (175, 1), (180, 1), (185, 1), (190, 1), (195, 1), (200, 0), (205, 0), (210, 0), (215, 0), (220, 0), (225, 0), (230, 1), (235, 1), (240, 1), (245, 1), (250, 1), (255, 1), (260, 1), (265, 1), (270, 1), (275, 1), (280, 1), (285, 0), (290, 0), (295, 0), (300, 1), (305, 1), (310, 1), (315, 1), (320, 1), (325, 1), (330, 1), (335, 1), (340, 1), (345, 0), (350, 0), (355, 0), (360, 0), (365, 1), (370, 1), (375, 1), (380, 1), (385, 1), (390, 1), (395, 1), (400, 1), (405, 1), (410, 0), (415, 0), (420, 0), (425, 1), (430, 1), (435, 1), (440, 0), (445, 0), (450, 0), (455, 0), (460, 0), (465, 1), (470, 1), (475, 0), (480, 0), (485, 1), (490, 0), (495, 0), (500, 0), (505, 0), (510, 0), (515, 0), (520, 0), (525, 0), (530, 1), (535, 1), (540, 0), (545, 0), (550, 0), (555, 0), (560, 1), (565, 1), (570, 1), (575, 1), (580, 1), (585, 1), (590, 1), (595, 0), (600, 0), (605, 0), (610, 0), (615, 0), (620, 0), (625, 0), (630, 0), (635, 0), (640, 1), (645, 0), (650, 0), (655, 0), (660, 0), (665, 0), (670, 1), (675, 1), (680, 1), (685, 1), (690, 1), (695, 1), (700, 1), (705, 1), (710, 1), (715, 1), (720, 1), (725, 1), (730, 0), (735, 0), (740, 0), (745, 1), (750, 1), (755, 1), (760, 1), (765, 0), (770, 0), (775, 0), (780, 0), (785, 0), (790, 0), (795, 0), (800, 0), (805, 0), (810, 0), (815, 0), (820, 0), (825, 0), (830, 0), (835, 0), (840, 0), (845, 0), (850, 1), (855, 1), (860, 1), (865, 1), (870, 0), (875, 0), (880, 0), (885, 1), (890, 1), (895, 1), (900, 1), (905, 1), (910, 1), (915, 1), (920, 0), (925, 0), (930, 0), (935, 1), (940, 1), (945, 1), (950, 0), (955, 1), (960, 1), (965, 1), (970, 1), (975, 1), (980, 0), (985, 1), (990, 1), (995, 1), (1000, 1), (1005, 1), (1010, 1), (1015, 1), (1020, 1), (1025, 1)]
Vdin0_23  din0_23  0 PWL (0n 0.0v 4.745n 0.0v 4.755n 0.0v 9.745n 0.0v 9.755n 0.95v 14.745n 0.95v 14.755n 0.0v 19.745n 0.0v 19.755n 0.0v 24.745n 0.0v 24.755n 0.95v 29.745n 0.95v 29.755n 0.0v 34.745n 0.0v 34.755n 0.0v 39.745n 0.0v 39.755n 0.95v 44.745n 0.95v 44.755n 0.0v 49.745n 0.0v 49.755n 0.95v 54.745n 0.95v 54.755n 0.95v 59.745n 0.95v 59.755n 0.95v 64.745n 0.95v 64.755n 0.95v 69.745n 0.95v 69.755n 0.95v 74.745n 0.95v 74.755n 0.95v 79.745n 0.95v 79.755n 0.95v 84.745n 0.95v 84.755n 0.95v 89.745n 0.95v 89.755n 0.95v 94.745n 0.95v 94.755n 0.95v 99.745n 0.95v 99.755n 0.95v 104.745n 0.95v 104.755n 0.0v 109.745n 0.0v 109.755n 0.0v 114.745n 0.0v 114.755n 0.95v 119.745n 0.95v 119.755n 0.95v 124.745n 0.95v 124.755n 0.0v 129.745n 0.0v 129.755n 0.95v 134.745n 0.95v 134.755n 0.95v 139.745n 0.95v 139.755n 0.95v 144.745n 0.95v 144.755n 0.95v 149.745n 0.95v 149.755n 0.95v 154.745n 0.95v 154.755n 0.95v 159.745n 0.95v 159.755n 0.95v 164.745n 0.95v 164.755n 0.95v 169.745n 0.95v 169.755n 0.95v 174.745n 0.95v 174.755n 0.95v 179.745n 0.95v 179.755n 0.95v 184.745n 0.95v 184.755n 0.95v 189.745n 0.95v 189.755n 0.95v 194.745n 0.95v 194.755n 0.95v 199.745n 0.95v 199.755n 0.0v 204.745n 0.0v 204.755n 0.0v 209.745n 0.0v 209.755n 0.0v 214.745n 0.0v 214.755n 0.0v 219.745n 0.0v 219.755n 0.0v 224.745n 0.0v 224.755n 0.0v 229.745n 0.0v 229.755n 0.95v 234.745n 0.95v 234.755n 0.95v 239.745n 0.95v 239.755n 0.95v 244.745n 0.95v 244.755n 0.95v 249.745n 0.95v 249.755n 0.95v 254.745n 0.95v 254.755n 0.95v 259.745n 0.95v 259.755n 0.95v 264.745n 0.95v 264.755n 0.95v 269.745n 0.95v 269.755n 0.95v 274.745n 0.95v 274.755n 0.95v 279.745n 0.95v 279.755n 0.95v 284.745n 0.95v 284.755n 0.0v 289.745n 0.0v 289.755n 0.0v 294.745n 0.0v 294.755n 0.0v 299.745n 0.0v 299.755n 0.95v 304.745n 0.95v 304.755n 0.95v 309.745n 0.95v 309.755n 0.95v 314.745n 0.95v 314.755n 0.95v 319.745n 0.95v 319.755n 0.95v 324.745n 0.95v 324.755n 0.95v 329.745n 0.95v 329.755n 0.95v 334.745n 0.95v 334.755n 0.95v 339.745n 0.95v 339.755n 0.95v 344.745n 0.95v 344.755n 0.0v 349.745n 0.0v 349.755n 0.0v 354.745n 0.0v 354.755n 0.0v 359.745n 0.0v 359.755n 0.0v 364.745n 0.0v 364.755n 0.95v 369.745n 0.95v 369.755n 0.95v 374.745n 0.95v 374.755n 0.95v 379.745n 0.95v 379.755n 0.95v 384.745n 0.95v 384.755n 0.95v 389.745n 0.95v 389.755n 0.95v 394.745n 0.95v 394.755n 0.95v 399.745n 0.95v 399.755n 0.95v 404.745n 0.95v 404.755n 0.95v 409.745n 0.95v 409.755n 0.0v 414.745n 0.0v 414.755n 0.0v 419.745n 0.0v 419.755n 0.0v 424.745n 0.0v 424.755n 0.95v 429.745n 0.95v 429.755n 0.95v 434.745n 0.95v 434.755n 0.95v 439.745n 0.95v 439.755n 0.0v 444.745n 0.0v 444.755n 0.0v 449.745n 0.0v 449.755n 0.0v 454.745n 0.0v 454.755n 0.0v 459.745n 0.0v 459.755n 0.0v 464.745n 0.0v 464.755n 0.95v 469.745n 0.95v 469.755n 0.95v 474.745n 0.95v 474.755n 0.0v 479.745n 0.0v 479.755n 0.0v 484.745n 0.0v 484.755n 0.95v 489.745n 0.95v 489.755n 0.0v 494.745n 0.0v 494.755n 0.0v 499.745n 0.0v 499.755n 0.0v 504.745n 0.0v 504.755n 0.0v 509.745n 0.0v 509.755n 0.0v 514.745n 0.0v 514.755n 0.0v 519.745n 0.0v 519.755n 0.0v 524.745n 0.0v 524.755n 0.0v 529.745n 0.0v 529.755n 0.95v 534.745n 0.95v 534.755n 0.95v 539.745n 0.95v 539.755n 0.0v 544.745n 0.0v 544.755n 0.0v 549.745n 0.0v 549.755n 0.0v 554.745n 0.0v 554.755n 0.0v 559.745n 0.0v 559.755n 0.95v 564.745n 0.95v 564.755n 0.95v 569.745n 0.95v 569.755n 0.95v 574.745n 0.95v 574.755n 0.95v 579.745n 0.95v 579.755n 0.95v 584.745n 0.95v 584.755n 0.95v 589.745n 0.95v 589.755n 0.95v 594.745n 0.95v 594.755n 0.0v 599.745n 0.0v 599.755n 0.0v 604.745n 0.0v 604.755n 0.0v 609.745n 0.0v 609.755n 0.0v 614.745n 0.0v 614.755n 0.0v 619.745n 0.0v 619.755n 0.0v 624.745n 0.0v 624.755n 0.0v 629.745n 0.0v 629.755n 0.0v 634.745n 0.0v 634.755n 0.0v 639.745n 0.0v 639.755n 0.95v 644.745n 0.95v 644.755n 0.0v 649.745n 0.0v 649.755n 0.0v 654.745n 0.0v 654.755n 0.0v 659.745n 0.0v 659.755n 0.0v 664.745n 0.0v 664.755n 0.0v 669.745n 0.0v 669.755n 0.95v 674.745n 0.95v 674.755n 0.95v 679.745n 0.95v 679.755n 0.95v 684.745n 0.95v 684.755n 0.95v 689.745n 0.95v 689.755n 0.95v 694.745n 0.95v 694.755n 0.95v 699.745n 0.95v 699.755n 0.95v 704.745n 0.95v 704.755n 0.95v 709.745n 0.95v 709.755n 0.95v 714.745n 0.95v 714.755n 0.95v 719.745n 0.95v 719.755n 0.95v 724.745n 0.95v 724.755n 0.95v 729.745n 0.95v 729.755n 0.0v 734.745n 0.0v 734.755n 0.0v 739.745n 0.0v 739.755n 0.0v 744.745n 0.0v 744.755n 0.95v 749.745n 0.95v 749.755n 0.95v 754.745n 0.95v 754.755n 0.95v 759.745n 0.95v 759.755n 0.95v 764.745n 0.95v 764.755n 0.0v 769.745n 0.0v 769.755n 0.0v 774.745n 0.0v 774.755n 0.0v 779.745n 0.0v 779.755n 0.0v 784.745n 0.0v 784.755n 0.0v 789.745n 0.0v 789.755n 0.0v 794.745n 0.0v 794.755n 0.0v 799.745n 0.0v 799.755n 0.0v 804.745n 0.0v 804.755n 0.0v 809.745n 0.0v 809.755n 0.0v 814.745n 0.0v 814.755n 0.0v 819.745n 0.0v 819.755n 0.0v 824.745n 0.0v 824.755n 0.0v 829.745n 0.0v 829.755n 0.0v 834.745n 0.0v 834.755n 0.0v 839.745n 0.0v 839.755n 0.0v 844.745n 0.0v 844.755n 0.0v 849.745n 0.0v 849.755n 0.95v 854.745n 0.95v 854.755n 0.95v 859.745n 0.95v 859.755n 0.95v 864.745n 0.95v 864.755n 0.95v 869.745n 0.95v 869.755n 0.0v 874.745n 0.0v 874.755n 0.0v 879.745n 0.0v 879.755n 0.0v 884.745n 0.0v 884.755n 0.95v 889.745n 0.95v 889.755n 0.95v 894.745n 0.95v 894.755n 0.95v 899.745n 0.95v 899.755n 0.95v 904.745n 0.95v 904.755n 0.95v 909.745n 0.95v 909.755n 0.95v 914.745n 0.95v 914.755n 0.95v 919.745n 0.95v 919.755n 0.0v 924.745n 0.0v 924.755n 0.0v 929.745n 0.0v 929.755n 0.0v 934.745n 0.0v 934.755n 0.95v 939.745n 0.95v 939.755n 0.95v 944.745n 0.95v 944.755n 0.95v 949.745n 0.95v 949.755n 0.0v 954.745n 0.0v 954.755n 0.95v 959.745n 0.95v 959.755n 0.95v 964.745n 0.95v 964.755n 0.95v 969.745n 0.95v 969.755n 0.95v 974.745n 0.95v 974.755n 0.95v 979.745n 0.95v 979.755n 0.0v 984.745n 0.0v 984.755n 0.95v 989.745n 0.95v 989.755n 0.95v 994.745n 0.95v 994.755n 0.95v 999.745n 0.95v 999.755n 0.95v 1004.745n 0.95v 1004.755n 0.95v 1009.745n 0.95v 1009.755n 0.95v 1014.745n 0.95v 1014.755n 0.95v 1019.745n 0.95v 1019.755n 0.95v 1024.745n 0.95v 1024.755n 0.95v )
* (time, data): [(0, 0), (5, 0), (10, 0), (15, 0), (20, 0), (25, 0), (30, 1), (35, 1), (40, 0), (45, 0), (50, 1), (55, 1), (60, 0), (65, 1), (70, 1), (75, 0), (80, 1), (85, 1), (90, 1), (95, 0), (100, 0), (105, 1), (110, 1), (115, 1), (120, 1), (125, 1), (130, 1), (135, 1), (140, 1), (145, 1), (150, 1), (155, 1), (160, 1), (165, 0), (170, 0), (175, 0), (180, 0), (185, 1), (190, 1), (195, 1), (200, 0), (205, 0), (210, 0), (215, 0), (220, 0), (225, 0), (230, 0), (235, 0), (240, 0), (245, 1), (250, 1), (255, 1), (260, 1), (265, 1), (270, 1), (275, 1), (280, 1), (285, 1), (290, 1), (295, 1), (300, 0), (305, 0), (310, 0), (315, 0), (320, 0), (325, 0), (330, 0), (335, 0), (340, 0), (345, 1), (350, 1), (355, 1), (360, 0), (365, 1), (370, 1), (375, 1), (380, 1), (385, 1), (390, 0), (395, 0), (400, 0), (405, 0), (410, 1), (415, 1), (420, 1), (425, 1), (430, 1), (435, 0), (440, 1), (445, 0), (450, 0), (455, 0), (460, 0), (465, 0), (470, 0), (475, 1), (480, 0), (485, 0), (490, 1), (495, 1), (500, 0), (505, 0), (510, 0), (515, 0), (520, 1), (525, 1), (530, 1), (535, 0), (540, 1), (545, 1), (550, 1), (555, 0), (560, 1), (565, 1), (570, 1), (575, 1), (580, 1), (585, 1), (590, 1), (595, 0), (600, 0), (605, 0), (610, 0), (615, 0), (620, 0), (625, 0), (630, 0), (635, 0), (640, 1), (645, 0), (650, 0), (655, 0), (660, 0), (665, 0), (670, 1), (675, 1), (680, 1), (685, 0), (690, 0), (695, 0), (700, 0), (705, 0), (710, 0), (715, 0), (720, 0), (725, 0), (730, 1), (735, 1), (740, 1), (745, 0), (750, 0), (755, 0), (760, 0), (765, 1), (770, 1), (775, 1), (780, 1), (785, 1), (790, 1), (795, 1), (800, 1), (805, 1), (810, 1), (815, 1), (820, 1), (825, 1), (830, 1), (835, 1), (840, 0), (845, 1), (850, 0), (855, 1), (860, 1), (865, 1), (870, 0), (875, 0), (880, 0), (885, 0), (890, 0), (895, 0), (900, 0), (905, 1), (910, 0), (915, 0), (920, 0), (925, 0), (930, 0), (935, 1), (940, 1), (945, 1), (950, 0), (955, 1), (960, 1), (965, 1), (970, 0), (975, 0), (980, 1), (985, 1), (990, 1), (995, 1), (1000, 1), (1005, 1), (1010, 1), (1015, 1), (1020, 1), (1025, 1)]
Vdin0_24  din0_24  0 PWL (0n 0.0v 4.745n 0.0v 4.755n 0.0v 9.745n 0.0v 9.755n 0.0v 14.745n 0.0v 14.755n 0.0v 19.745n 0.0v 19.755n 0.0v 24.745n 0.0v 24.755n 0.0v 29.745n 0.0v 29.755n 0.95v 34.745n 0.95v 34.755n 0.95v 39.745n 0.95v 39.755n 0.0v 44.745n 0.0v 44.755n 0.0v 49.745n 0.0v 49.755n 0.95v 54.745n 0.95v 54.755n 0.95v 59.745n 0.95v 59.755n 0.0v 64.745n 0.0v 64.755n 0.95v 69.745n 0.95v 69.755n 0.95v 74.745n 0.95v 74.755n 0.0v 79.745n 0.0v 79.755n 0.95v 84.745n 0.95v 84.755n 0.95v 89.745n 0.95v 89.755n 0.95v 94.745n 0.95v 94.755n 0.0v 99.745n 0.0v 99.755n 0.0v 104.745n 0.0v 104.755n 0.95v 109.745n 0.95v 109.755n 0.95v 114.745n 0.95v 114.755n 0.95v 119.745n 0.95v 119.755n 0.95v 124.745n 0.95v 124.755n 0.95v 129.745n 0.95v 129.755n 0.95v 134.745n 0.95v 134.755n 0.95v 139.745n 0.95v 139.755n 0.95v 144.745n 0.95v 144.755n 0.95v 149.745n 0.95v 149.755n 0.95v 154.745n 0.95v 154.755n 0.95v 159.745n 0.95v 159.755n 0.95v 164.745n 0.95v 164.755n 0.0v 169.745n 0.0v 169.755n 0.0v 174.745n 0.0v 174.755n 0.0v 179.745n 0.0v 179.755n 0.0v 184.745n 0.0v 184.755n 0.95v 189.745n 0.95v 189.755n 0.95v 194.745n 0.95v 194.755n 0.95v 199.745n 0.95v 199.755n 0.0v 204.745n 0.0v 204.755n 0.0v 209.745n 0.0v 209.755n 0.0v 214.745n 0.0v 214.755n 0.0v 219.745n 0.0v 219.755n 0.0v 224.745n 0.0v 224.755n 0.0v 229.745n 0.0v 229.755n 0.0v 234.745n 0.0v 234.755n 0.0v 239.745n 0.0v 239.755n 0.0v 244.745n 0.0v 244.755n 0.95v 249.745n 0.95v 249.755n 0.95v 254.745n 0.95v 254.755n 0.95v 259.745n 0.95v 259.755n 0.95v 264.745n 0.95v 264.755n 0.95v 269.745n 0.95v 269.755n 0.95v 274.745n 0.95v 274.755n 0.95v 279.745n 0.95v 279.755n 0.95v 284.745n 0.95v 284.755n 0.95v 289.745n 0.95v 289.755n 0.95v 294.745n 0.95v 294.755n 0.95v 299.745n 0.95v 299.755n 0.0v 304.745n 0.0v 304.755n 0.0v 309.745n 0.0v 309.755n 0.0v 314.745n 0.0v 314.755n 0.0v 319.745n 0.0v 319.755n 0.0v 324.745n 0.0v 324.755n 0.0v 329.745n 0.0v 329.755n 0.0v 334.745n 0.0v 334.755n 0.0v 339.745n 0.0v 339.755n 0.0v 344.745n 0.0v 344.755n 0.95v 349.745n 0.95v 349.755n 0.95v 354.745n 0.95v 354.755n 0.95v 359.745n 0.95v 359.755n 0.0v 364.745n 0.0v 364.755n 0.95v 369.745n 0.95v 369.755n 0.95v 374.745n 0.95v 374.755n 0.95v 379.745n 0.95v 379.755n 0.95v 384.745n 0.95v 384.755n 0.95v 389.745n 0.95v 389.755n 0.0v 394.745n 0.0v 394.755n 0.0v 399.745n 0.0v 399.755n 0.0v 404.745n 0.0v 404.755n 0.0v 409.745n 0.0v 409.755n 0.95v 414.745n 0.95v 414.755n 0.95v 419.745n 0.95v 419.755n 0.95v 424.745n 0.95v 424.755n 0.95v 429.745n 0.95v 429.755n 0.95v 434.745n 0.95v 434.755n 0.0v 439.745n 0.0v 439.755n 0.95v 444.745n 0.95v 444.755n 0.0v 449.745n 0.0v 449.755n 0.0v 454.745n 0.0v 454.755n 0.0v 459.745n 0.0v 459.755n 0.0v 464.745n 0.0v 464.755n 0.0v 469.745n 0.0v 469.755n 0.0v 474.745n 0.0v 474.755n 0.95v 479.745n 0.95v 479.755n 0.0v 484.745n 0.0v 484.755n 0.0v 489.745n 0.0v 489.755n 0.95v 494.745n 0.95v 494.755n 0.95v 499.745n 0.95v 499.755n 0.0v 504.745n 0.0v 504.755n 0.0v 509.745n 0.0v 509.755n 0.0v 514.745n 0.0v 514.755n 0.0v 519.745n 0.0v 519.755n 0.95v 524.745n 0.95v 524.755n 0.95v 529.745n 0.95v 529.755n 0.95v 534.745n 0.95v 534.755n 0.0v 539.745n 0.0v 539.755n 0.95v 544.745n 0.95v 544.755n 0.95v 549.745n 0.95v 549.755n 0.95v 554.745n 0.95v 554.755n 0.0v 559.745n 0.0v 559.755n 0.95v 564.745n 0.95v 564.755n 0.95v 569.745n 0.95v 569.755n 0.95v 574.745n 0.95v 574.755n 0.95v 579.745n 0.95v 579.755n 0.95v 584.745n 0.95v 584.755n 0.95v 589.745n 0.95v 589.755n 0.95v 594.745n 0.95v 594.755n 0.0v 599.745n 0.0v 599.755n 0.0v 604.745n 0.0v 604.755n 0.0v 609.745n 0.0v 609.755n 0.0v 614.745n 0.0v 614.755n 0.0v 619.745n 0.0v 619.755n 0.0v 624.745n 0.0v 624.755n 0.0v 629.745n 0.0v 629.755n 0.0v 634.745n 0.0v 634.755n 0.0v 639.745n 0.0v 639.755n 0.95v 644.745n 0.95v 644.755n 0.0v 649.745n 0.0v 649.755n 0.0v 654.745n 0.0v 654.755n 0.0v 659.745n 0.0v 659.755n 0.0v 664.745n 0.0v 664.755n 0.0v 669.745n 0.0v 669.755n 0.95v 674.745n 0.95v 674.755n 0.95v 679.745n 0.95v 679.755n 0.95v 684.745n 0.95v 684.755n 0.0v 689.745n 0.0v 689.755n 0.0v 694.745n 0.0v 694.755n 0.0v 699.745n 0.0v 699.755n 0.0v 704.745n 0.0v 704.755n 0.0v 709.745n 0.0v 709.755n 0.0v 714.745n 0.0v 714.755n 0.0v 719.745n 0.0v 719.755n 0.0v 724.745n 0.0v 724.755n 0.0v 729.745n 0.0v 729.755n 0.95v 734.745n 0.95v 734.755n 0.95v 739.745n 0.95v 739.755n 0.95v 744.745n 0.95v 744.755n 0.0v 749.745n 0.0v 749.755n 0.0v 754.745n 0.0v 754.755n 0.0v 759.745n 0.0v 759.755n 0.0v 764.745n 0.0v 764.755n 0.95v 769.745n 0.95v 769.755n 0.95v 774.745n 0.95v 774.755n 0.95v 779.745n 0.95v 779.755n 0.95v 784.745n 0.95v 784.755n 0.95v 789.745n 0.95v 789.755n 0.95v 794.745n 0.95v 794.755n 0.95v 799.745n 0.95v 799.755n 0.95v 804.745n 0.95v 804.755n 0.95v 809.745n 0.95v 809.755n 0.95v 814.745n 0.95v 814.755n 0.95v 819.745n 0.95v 819.755n 0.95v 824.745n 0.95v 824.755n 0.95v 829.745n 0.95v 829.755n 0.95v 834.745n 0.95v 834.755n 0.95v 839.745n 0.95v 839.755n 0.0v 844.745n 0.0v 844.755n 0.95v 849.745n 0.95v 849.755n 0.0v 854.745n 0.0v 854.755n 0.95v 859.745n 0.95v 859.755n 0.95v 864.745n 0.95v 864.755n 0.95v 869.745n 0.95v 869.755n 0.0v 874.745n 0.0v 874.755n 0.0v 879.745n 0.0v 879.755n 0.0v 884.745n 0.0v 884.755n 0.0v 889.745n 0.0v 889.755n 0.0v 894.745n 0.0v 894.755n 0.0v 899.745n 0.0v 899.755n 0.0v 904.745n 0.0v 904.755n 0.95v 909.745n 0.95v 909.755n 0.0v 914.745n 0.0v 914.755n 0.0v 919.745n 0.0v 919.755n 0.0v 924.745n 0.0v 924.755n 0.0v 929.745n 0.0v 929.755n 0.0v 934.745n 0.0v 934.755n 0.95v 939.745n 0.95v 939.755n 0.95v 944.745n 0.95v 944.755n 0.95v 949.745n 0.95v 949.755n 0.0v 954.745n 0.0v 954.755n 0.95v 959.745n 0.95v 959.755n 0.95v 964.745n 0.95v 964.755n 0.95v 969.745n 0.95v 969.755n 0.0v 974.745n 0.0v 974.755n 0.0v 979.745n 0.0v 979.755n 0.95v 984.745n 0.95v 984.755n 0.95v 989.745n 0.95v 989.755n 0.95v 994.745n 0.95v 994.755n 0.95v 999.745n 0.95v 999.755n 0.95v 1004.745n 0.95v 1004.755n 0.95v 1009.745n 0.95v 1009.755n 0.95v 1014.745n 0.95v 1014.755n 0.95v 1019.745n 0.95v 1019.755n 0.95v 1024.745n 0.95v 1024.755n 0.95v )
* (time, data): [(0, 0), (5, 0), (10, 0), (15, 0), (20, 0), (25, 0), (30, 1), (35, 0), (40, 0), (45, 1), (50, 1), (55, 1), (60, 1), (65, 1), (70, 1), (75, 0), (80, 1), (85, 0), (90, 0), (95, 0), (100, 0), (105, 0), (110, 0), (115, 0), (120, 0), (125, 0), (130, 0), (135, 0), (140, 0), (145, 0), (150, 0), (155, 0), (160, 0), (165, 0), (170, 0), (175, 0), (180, 1), (185, 0), (190, 0), (195, 0), (200, 1), (205, 1), (210, 1), (215, 1), (220, 1), (225, 1), (230, 1), (235, 1), (240, 1), (245, 1), (250, 1), (255, 1), (260, 1), (265, 1), (270, 0), (275, 0), (280, 0), (285, 0), (290, 0), (295, 0), (300, 1), (305, 1), (310, 1), (315, 0), (320, 0), (325, 0), (330, 0), (335, 0), (340, 0), (345, 1), (350, 1), (355, 1), (360, 1), (365, 1), (370, 1), (375, 1), (380, 1), (385, 1), (390, 1), (395, 1), (400, 1), (405, 1), (410, 1), (415, 1), (420, 1), (425, 1), (430, 1), (435, 0), (440, 1), (445, 0), (450, 0), (455, 0), (460, 1), (465, 0), (470, 0), (475, 0), (480, 1), (485, 0), (490, 1), (495, 1), (500, 1), (505, 1), (510, 1), (515, 1), (520, 1), (525, 1), (530, 0), (535, 1), (540, 0), (545, 0), (550, 0), (555, 1), (560, 0), (565, 0), (570, 0), (575, 0), (580, 0), (585, 0), (590, 0), (595, 0), (600, 0), (605, 0), (610, 0), (615, 0), (620, 0), (625, 0), (630, 0), (635, 0), (640, 0), (645, 1), (650, 1), (655, 1), (660, 1), (665, 1), (670, 0), (675, 0), (680, 0), (685, 1), (690, 1), (695, 1), (700, 1), (705, 1), (710, 1), (715, 1), (720, 0), (725, 0), (730, 1), (735, 1), (740, 1), (745, 1), (750, 1), (755, 1), (760, 1), (765, 0), (770, 0), (775, 0), (780, 0), (785, 0), (790, 0), (795, 0), (800, 0), (805, 0), (810, 0), (815, 0), (820, 0), (825, 0), (830, 0), (835, 0), (840, 0), (845, 1), (850, 1), (855, 1), (860, 1), (865, 1), (870, 0), (875, 0), (880, 0), (885, 0), (890, 0), (895, 0), (900, 0), (905, 0), (910, 1), (915, 1), (920, 0), (925, 0), (930, 0), (935, 1), (940, 1), (945, 1), (950, 1), (955, 0), (960, 0), (965, 0), (970, 0), (975, 0), (980, 0), (985, 0), (990, 0), (995, 0), (1000, 0), (1005, 0), (1010, 0), (1015, 0), (1020, 0), (1025, 0)]
Vdin0_25  din0_25  0 PWL (0n 0.0v 4.745n 0.0v 4.755n 0.0v 9.745n 0.0v 9.755n 0.0v 14.745n 0.0v 14.755n 0.0v 19.745n 0.0v 19.755n 0.0v 24.745n 0.0v 24.755n 0.0v 29.745n 0.0v 29.755n 0.95v 34.745n 0.95v 34.755n 0.0v 39.745n 0.0v 39.755n 0.0v 44.745n 0.0v 44.755n 0.95v 49.745n 0.95v 49.755n 0.95v 54.745n 0.95v 54.755n 0.95v 59.745n 0.95v 59.755n 0.95v 64.745n 0.95v 64.755n 0.95v 69.745n 0.95v 69.755n 0.95v 74.745n 0.95v 74.755n 0.0v 79.745n 0.0v 79.755n 0.95v 84.745n 0.95v 84.755n 0.0v 89.745n 0.0v 89.755n 0.0v 94.745n 0.0v 94.755n 0.0v 99.745n 0.0v 99.755n 0.0v 104.745n 0.0v 104.755n 0.0v 109.745n 0.0v 109.755n 0.0v 114.745n 0.0v 114.755n 0.0v 119.745n 0.0v 119.755n 0.0v 124.745n 0.0v 124.755n 0.0v 129.745n 0.0v 129.755n 0.0v 134.745n 0.0v 134.755n 0.0v 139.745n 0.0v 139.755n 0.0v 144.745n 0.0v 144.755n 0.0v 149.745n 0.0v 149.755n 0.0v 154.745n 0.0v 154.755n 0.0v 159.745n 0.0v 159.755n 0.0v 164.745n 0.0v 164.755n 0.0v 169.745n 0.0v 169.755n 0.0v 174.745n 0.0v 174.755n 0.0v 179.745n 0.0v 179.755n 0.95v 184.745n 0.95v 184.755n 0.0v 189.745n 0.0v 189.755n 0.0v 194.745n 0.0v 194.755n 0.0v 199.745n 0.0v 199.755n 0.95v 204.745n 0.95v 204.755n 0.95v 209.745n 0.95v 209.755n 0.95v 214.745n 0.95v 214.755n 0.95v 219.745n 0.95v 219.755n 0.95v 224.745n 0.95v 224.755n 0.95v 229.745n 0.95v 229.755n 0.95v 234.745n 0.95v 234.755n 0.95v 239.745n 0.95v 239.755n 0.95v 244.745n 0.95v 244.755n 0.95v 249.745n 0.95v 249.755n 0.95v 254.745n 0.95v 254.755n 0.95v 259.745n 0.95v 259.755n 0.95v 264.745n 0.95v 264.755n 0.95v 269.745n 0.95v 269.755n 0.0v 274.745n 0.0v 274.755n 0.0v 279.745n 0.0v 279.755n 0.0v 284.745n 0.0v 284.755n 0.0v 289.745n 0.0v 289.755n 0.0v 294.745n 0.0v 294.755n 0.0v 299.745n 0.0v 299.755n 0.95v 304.745n 0.95v 304.755n 0.95v 309.745n 0.95v 309.755n 0.95v 314.745n 0.95v 314.755n 0.0v 319.745n 0.0v 319.755n 0.0v 324.745n 0.0v 324.755n 0.0v 329.745n 0.0v 329.755n 0.0v 334.745n 0.0v 334.755n 0.0v 339.745n 0.0v 339.755n 0.0v 344.745n 0.0v 344.755n 0.95v 349.745n 0.95v 349.755n 0.95v 354.745n 0.95v 354.755n 0.95v 359.745n 0.95v 359.755n 0.95v 364.745n 0.95v 364.755n 0.95v 369.745n 0.95v 369.755n 0.95v 374.745n 0.95v 374.755n 0.95v 379.745n 0.95v 379.755n 0.95v 384.745n 0.95v 384.755n 0.95v 389.745n 0.95v 389.755n 0.95v 394.745n 0.95v 394.755n 0.95v 399.745n 0.95v 399.755n 0.95v 404.745n 0.95v 404.755n 0.95v 409.745n 0.95v 409.755n 0.95v 414.745n 0.95v 414.755n 0.95v 419.745n 0.95v 419.755n 0.95v 424.745n 0.95v 424.755n 0.95v 429.745n 0.95v 429.755n 0.95v 434.745n 0.95v 434.755n 0.0v 439.745n 0.0v 439.755n 0.95v 444.745n 0.95v 444.755n 0.0v 449.745n 0.0v 449.755n 0.0v 454.745n 0.0v 454.755n 0.0v 459.745n 0.0v 459.755n 0.95v 464.745n 0.95v 464.755n 0.0v 469.745n 0.0v 469.755n 0.0v 474.745n 0.0v 474.755n 0.0v 479.745n 0.0v 479.755n 0.95v 484.745n 0.95v 484.755n 0.0v 489.745n 0.0v 489.755n 0.95v 494.745n 0.95v 494.755n 0.95v 499.745n 0.95v 499.755n 0.95v 504.745n 0.95v 504.755n 0.95v 509.745n 0.95v 509.755n 0.95v 514.745n 0.95v 514.755n 0.95v 519.745n 0.95v 519.755n 0.95v 524.745n 0.95v 524.755n 0.95v 529.745n 0.95v 529.755n 0.0v 534.745n 0.0v 534.755n 0.95v 539.745n 0.95v 539.755n 0.0v 544.745n 0.0v 544.755n 0.0v 549.745n 0.0v 549.755n 0.0v 554.745n 0.0v 554.755n 0.95v 559.745n 0.95v 559.755n 0.0v 564.745n 0.0v 564.755n 0.0v 569.745n 0.0v 569.755n 0.0v 574.745n 0.0v 574.755n 0.0v 579.745n 0.0v 579.755n 0.0v 584.745n 0.0v 584.755n 0.0v 589.745n 0.0v 589.755n 0.0v 594.745n 0.0v 594.755n 0.0v 599.745n 0.0v 599.755n 0.0v 604.745n 0.0v 604.755n 0.0v 609.745n 0.0v 609.755n 0.0v 614.745n 0.0v 614.755n 0.0v 619.745n 0.0v 619.755n 0.0v 624.745n 0.0v 624.755n 0.0v 629.745n 0.0v 629.755n 0.0v 634.745n 0.0v 634.755n 0.0v 639.745n 0.0v 639.755n 0.0v 644.745n 0.0v 644.755n 0.95v 649.745n 0.95v 649.755n 0.95v 654.745n 0.95v 654.755n 0.95v 659.745n 0.95v 659.755n 0.95v 664.745n 0.95v 664.755n 0.95v 669.745n 0.95v 669.755n 0.0v 674.745n 0.0v 674.755n 0.0v 679.745n 0.0v 679.755n 0.0v 684.745n 0.0v 684.755n 0.95v 689.745n 0.95v 689.755n 0.95v 694.745n 0.95v 694.755n 0.95v 699.745n 0.95v 699.755n 0.95v 704.745n 0.95v 704.755n 0.95v 709.745n 0.95v 709.755n 0.95v 714.745n 0.95v 714.755n 0.95v 719.745n 0.95v 719.755n 0.0v 724.745n 0.0v 724.755n 0.0v 729.745n 0.0v 729.755n 0.95v 734.745n 0.95v 734.755n 0.95v 739.745n 0.95v 739.755n 0.95v 744.745n 0.95v 744.755n 0.95v 749.745n 0.95v 749.755n 0.95v 754.745n 0.95v 754.755n 0.95v 759.745n 0.95v 759.755n 0.95v 764.745n 0.95v 764.755n 0.0v 769.745n 0.0v 769.755n 0.0v 774.745n 0.0v 774.755n 0.0v 779.745n 0.0v 779.755n 0.0v 784.745n 0.0v 784.755n 0.0v 789.745n 0.0v 789.755n 0.0v 794.745n 0.0v 794.755n 0.0v 799.745n 0.0v 799.755n 0.0v 804.745n 0.0v 804.755n 0.0v 809.745n 0.0v 809.755n 0.0v 814.745n 0.0v 814.755n 0.0v 819.745n 0.0v 819.755n 0.0v 824.745n 0.0v 824.755n 0.0v 829.745n 0.0v 829.755n 0.0v 834.745n 0.0v 834.755n 0.0v 839.745n 0.0v 839.755n 0.0v 844.745n 0.0v 844.755n 0.95v 849.745n 0.95v 849.755n 0.95v 854.745n 0.95v 854.755n 0.95v 859.745n 0.95v 859.755n 0.95v 864.745n 0.95v 864.755n 0.95v 869.745n 0.95v 869.755n 0.0v 874.745n 0.0v 874.755n 0.0v 879.745n 0.0v 879.755n 0.0v 884.745n 0.0v 884.755n 0.0v 889.745n 0.0v 889.755n 0.0v 894.745n 0.0v 894.755n 0.0v 899.745n 0.0v 899.755n 0.0v 904.745n 0.0v 904.755n 0.0v 909.745n 0.0v 909.755n 0.95v 914.745n 0.95v 914.755n 0.95v 919.745n 0.95v 919.755n 0.0v 924.745n 0.0v 924.755n 0.0v 929.745n 0.0v 929.755n 0.0v 934.745n 0.0v 934.755n 0.95v 939.745n 0.95v 939.755n 0.95v 944.745n 0.95v 944.755n 0.95v 949.745n 0.95v 949.755n 0.95v 954.745n 0.95v 954.755n 0.0v 959.745n 0.0v 959.755n 0.0v 964.745n 0.0v 964.755n 0.0v 969.745n 0.0v 969.755n 0.0v 974.745n 0.0v 974.755n 0.0v 979.745n 0.0v 979.755n 0.0v 984.745n 0.0v 984.755n 0.0v 989.745n 0.0v 989.755n 0.0v 994.745n 0.0v 994.755n 0.0v 999.745n 0.0v 999.755n 0.0v 1004.745n 0.0v 1004.755n 0.0v 1009.745n 0.0v 1009.755n 0.0v 1014.745n 0.0v 1014.755n 0.0v 1019.745n 0.0v 1019.755n 0.0v 1024.745n 0.0v 1024.755n 0.0v )
* (time, data): [(0, 0), (5, 1), (10, 0), (15, 0), (20, 0), (25, 1), (30, 1), (35, 1), (40, 0), (45, 0), (50, 0), (55, 0), (60, 0), (65, 1), (70, 1), (75, 1), (80, 1), (85, 0), (90, 0), (95, 0), (100, 0), (105, 1), (110, 1), (115, 0), (120, 0), (125, 0), (130, 1), (135, 1), (140, 1), (145, 1), (150, 1), (155, 1), (160, 1), (165, 0), (170, 0), (175, 0), (180, 0), (185, 0), (190, 0), (195, 0), (200, 0), (205, 0), (210, 0), (215, 0), (220, 0), (225, 0), (230, 0), (235, 0), (240, 0), (245, 0), (250, 0), (255, 0), (260, 0), (265, 1), (270, 1), (275, 1), (280, 1), (285, 0), (290, 0), (295, 0), (300, 1), (305, 1), (310, 1), (315, 0), (320, 0), (325, 0), (330, 0), (335, 0), (340, 0), (345, 1), (350, 1), (355, 1), (360, 0), (365, 0), (370, 0), (375, 0), (380, 0), (385, 0), (390, 0), (395, 0), (400, 0), (405, 0), (410, 0), (415, 0), (420, 0), (425, 0), (430, 0), (435, 0), (440, 0), (445, 0), (450, 0), (455, 0), (460, 1), (465, 0), (470, 0), (475, 0), (480, 0), (485, 1), (490, 1), (495, 1), (500, 1), (505, 1), (510, 1), (515, 1), (520, 0), (525, 0), (530, 1), (535, 0), (540, 0), (545, 0), (550, 0), (555, 1), (560, 0), (565, 0), (570, 0), (575, 0), (580, 0), (585, 0), (590, 0), (595, 0), (600, 0), (605, 0), (610, 0), (615, 0), (620, 0), (625, 0), (630, 0), (635, 0), (640, 0), (645, 1), (650, 1), (655, 1), (660, 1), (665, 1), (670, 1), (675, 0), (680, 0), (685, 0), (690, 0), (695, 0), (700, 0), (705, 0), (710, 0), (715, 0), (720, 0), (725, 0), (730, 0), (735, 1), (740, 1), (745, 0), (750, 0), (755, 0), (760, 0), (765, 1), (770, 1), (775, 1), (780, 1), (785, 1), (790, 1), (795, 1), (800, 1), (805, 1), (810, 1), (815, 1), (820, 1), (825, 1), (830, 1), (835, 1), (840, 0), (845, 0), (850, 0), (855, 1), (860, 1), (865, 0), (870, 0), (875, 0), (880, 0), (885, 1), (890, 1), (895, 1), (900, 1), (905, 0), (910, 0), (915, 0), (920, 1), (925, 0), (930, 0), (935, 1), (940, 1), (945, 1), (950, 0), (955, 1), (960, 1), (965, 1), (970, 1), (975, 1), (980, 0), (985, 1), (990, 0), (995, 0), (1000, 0), (1005, 1), (1010, 1), (1015, 1), (1020, 1), (1025, 1)]
Vdin0_26  din0_26  0 PWL (0n 0.0v 4.745n 0.0v 4.755n 0.95v 9.745n 0.95v 9.755n 0.0v 14.745n 0.0v 14.755n 0.0v 19.745n 0.0v 19.755n 0.0v 24.745n 0.0v 24.755n 0.95v 29.745n 0.95v 29.755n 0.95v 34.745n 0.95v 34.755n 0.95v 39.745n 0.95v 39.755n 0.0v 44.745n 0.0v 44.755n 0.0v 49.745n 0.0v 49.755n 0.0v 54.745n 0.0v 54.755n 0.0v 59.745n 0.0v 59.755n 0.0v 64.745n 0.0v 64.755n 0.95v 69.745n 0.95v 69.755n 0.95v 74.745n 0.95v 74.755n 0.95v 79.745n 0.95v 79.755n 0.95v 84.745n 0.95v 84.755n 0.0v 89.745n 0.0v 89.755n 0.0v 94.745n 0.0v 94.755n 0.0v 99.745n 0.0v 99.755n 0.0v 104.745n 0.0v 104.755n 0.95v 109.745n 0.95v 109.755n 0.95v 114.745n 0.95v 114.755n 0.0v 119.745n 0.0v 119.755n 0.0v 124.745n 0.0v 124.755n 0.0v 129.745n 0.0v 129.755n 0.95v 134.745n 0.95v 134.755n 0.95v 139.745n 0.95v 139.755n 0.95v 144.745n 0.95v 144.755n 0.95v 149.745n 0.95v 149.755n 0.95v 154.745n 0.95v 154.755n 0.95v 159.745n 0.95v 159.755n 0.95v 164.745n 0.95v 164.755n 0.0v 169.745n 0.0v 169.755n 0.0v 174.745n 0.0v 174.755n 0.0v 179.745n 0.0v 179.755n 0.0v 184.745n 0.0v 184.755n 0.0v 189.745n 0.0v 189.755n 0.0v 194.745n 0.0v 194.755n 0.0v 199.745n 0.0v 199.755n 0.0v 204.745n 0.0v 204.755n 0.0v 209.745n 0.0v 209.755n 0.0v 214.745n 0.0v 214.755n 0.0v 219.745n 0.0v 219.755n 0.0v 224.745n 0.0v 224.755n 0.0v 229.745n 0.0v 229.755n 0.0v 234.745n 0.0v 234.755n 0.0v 239.745n 0.0v 239.755n 0.0v 244.745n 0.0v 244.755n 0.0v 249.745n 0.0v 249.755n 0.0v 254.745n 0.0v 254.755n 0.0v 259.745n 0.0v 259.755n 0.0v 264.745n 0.0v 264.755n 0.95v 269.745n 0.95v 269.755n 0.95v 274.745n 0.95v 274.755n 0.95v 279.745n 0.95v 279.755n 0.95v 284.745n 0.95v 284.755n 0.0v 289.745n 0.0v 289.755n 0.0v 294.745n 0.0v 294.755n 0.0v 299.745n 0.0v 299.755n 0.95v 304.745n 0.95v 304.755n 0.95v 309.745n 0.95v 309.755n 0.95v 314.745n 0.95v 314.755n 0.0v 319.745n 0.0v 319.755n 0.0v 324.745n 0.0v 324.755n 0.0v 329.745n 0.0v 329.755n 0.0v 334.745n 0.0v 334.755n 0.0v 339.745n 0.0v 339.755n 0.0v 344.745n 0.0v 344.755n 0.95v 349.745n 0.95v 349.755n 0.95v 354.745n 0.95v 354.755n 0.95v 359.745n 0.95v 359.755n 0.0v 364.745n 0.0v 364.755n 0.0v 369.745n 0.0v 369.755n 0.0v 374.745n 0.0v 374.755n 0.0v 379.745n 0.0v 379.755n 0.0v 384.745n 0.0v 384.755n 0.0v 389.745n 0.0v 389.755n 0.0v 394.745n 0.0v 394.755n 0.0v 399.745n 0.0v 399.755n 0.0v 404.745n 0.0v 404.755n 0.0v 409.745n 0.0v 409.755n 0.0v 414.745n 0.0v 414.755n 0.0v 419.745n 0.0v 419.755n 0.0v 424.745n 0.0v 424.755n 0.0v 429.745n 0.0v 429.755n 0.0v 434.745n 0.0v 434.755n 0.0v 439.745n 0.0v 439.755n 0.0v 444.745n 0.0v 444.755n 0.0v 449.745n 0.0v 449.755n 0.0v 454.745n 0.0v 454.755n 0.0v 459.745n 0.0v 459.755n 0.95v 464.745n 0.95v 464.755n 0.0v 469.745n 0.0v 469.755n 0.0v 474.745n 0.0v 474.755n 0.0v 479.745n 0.0v 479.755n 0.0v 484.745n 0.0v 484.755n 0.95v 489.745n 0.95v 489.755n 0.95v 494.745n 0.95v 494.755n 0.95v 499.745n 0.95v 499.755n 0.95v 504.745n 0.95v 504.755n 0.95v 509.745n 0.95v 509.755n 0.95v 514.745n 0.95v 514.755n 0.95v 519.745n 0.95v 519.755n 0.0v 524.745n 0.0v 524.755n 0.0v 529.745n 0.0v 529.755n 0.95v 534.745n 0.95v 534.755n 0.0v 539.745n 0.0v 539.755n 0.0v 544.745n 0.0v 544.755n 0.0v 549.745n 0.0v 549.755n 0.0v 554.745n 0.0v 554.755n 0.95v 559.745n 0.95v 559.755n 0.0v 564.745n 0.0v 564.755n 0.0v 569.745n 0.0v 569.755n 0.0v 574.745n 0.0v 574.755n 0.0v 579.745n 0.0v 579.755n 0.0v 584.745n 0.0v 584.755n 0.0v 589.745n 0.0v 589.755n 0.0v 594.745n 0.0v 594.755n 0.0v 599.745n 0.0v 599.755n 0.0v 604.745n 0.0v 604.755n 0.0v 609.745n 0.0v 609.755n 0.0v 614.745n 0.0v 614.755n 0.0v 619.745n 0.0v 619.755n 0.0v 624.745n 0.0v 624.755n 0.0v 629.745n 0.0v 629.755n 0.0v 634.745n 0.0v 634.755n 0.0v 639.745n 0.0v 639.755n 0.0v 644.745n 0.0v 644.755n 0.95v 649.745n 0.95v 649.755n 0.95v 654.745n 0.95v 654.755n 0.95v 659.745n 0.95v 659.755n 0.95v 664.745n 0.95v 664.755n 0.95v 669.745n 0.95v 669.755n 0.95v 674.745n 0.95v 674.755n 0.0v 679.745n 0.0v 679.755n 0.0v 684.745n 0.0v 684.755n 0.0v 689.745n 0.0v 689.755n 0.0v 694.745n 0.0v 694.755n 0.0v 699.745n 0.0v 699.755n 0.0v 704.745n 0.0v 704.755n 0.0v 709.745n 0.0v 709.755n 0.0v 714.745n 0.0v 714.755n 0.0v 719.745n 0.0v 719.755n 0.0v 724.745n 0.0v 724.755n 0.0v 729.745n 0.0v 729.755n 0.0v 734.745n 0.0v 734.755n 0.95v 739.745n 0.95v 739.755n 0.95v 744.745n 0.95v 744.755n 0.0v 749.745n 0.0v 749.755n 0.0v 754.745n 0.0v 754.755n 0.0v 759.745n 0.0v 759.755n 0.0v 764.745n 0.0v 764.755n 0.95v 769.745n 0.95v 769.755n 0.95v 774.745n 0.95v 774.755n 0.95v 779.745n 0.95v 779.755n 0.95v 784.745n 0.95v 784.755n 0.95v 789.745n 0.95v 789.755n 0.95v 794.745n 0.95v 794.755n 0.95v 799.745n 0.95v 799.755n 0.95v 804.745n 0.95v 804.755n 0.95v 809.745n 0.95v 809.755n 0.95v 814.745n 0.95v 814.755n 0.95v 819.745n 0.95v 819.755n 0.95v 824.745n 0.95v 824.755n 0.95v 829.745n 0.95v 829.755n 0.95v 834.745n 0.95v 834.755n 0.95v 839.745n 0.95v 839.755n 0.0v 844.745n 0.0v 844.755n 0.0v 849.745n 0.0v 849.755n 0.0v 854.745n 0.0v 854.755n 0.95v 859.745n 0.95v 859.755n 0.95v 864.745n 0.95v 864.755n 0.0v 869.745n 0.0v 869.755n 0.0v 874.745n 0.0v 874.755n 0.0v 879.745n 0.0v 879.755n 0.0v 884.745n 0.0v 884.755n 0.95v 889.745n 0.95v 889.755n 0.95v 894.745n 0.95v 894.755n 0.95v 899.745n 0.95v 899.755n 0.95v 904.745n 0.95v 904.755n 0.0v 909.745n 0.0v 909.755n 0.0v 914.745n 0.0v 914.755n 0.0v 919.745n 0.0v 919.755n 0.95v 924.745n 0.95v 924.755n 0.0v 929.745n 0.0v 929.755n 0.0v 934.745n 0.0v 934.755n 0.95v 939.745n 0.95v 939.755n 0.95v 944.745n 0.95v 944.755n 0.95v 949.745n 0.95v 949.755n 0.0v 954.745n 0.0v 954.755n 0.95v 959.745n 0.95v 959.755n 0.95v 964.745n 0.95v 964.755n 0.95v 969.745n 0.95v 969.755n 0.95v 974.745n 0.95v 974.755n 0.95v 979.745n 0.95v 979.755n 0.0v 984.745n 0.0v 984.755n 0.95v 989.745n 0.95v 989.755n 0.0v 994.745n 0.0v 994.755n 0.0v 999.745n 0.0v 999.755n 0.0v 1004.745n 0.0v 1004.755n 0.95v 1009.745n 0.95v 1009.755n 0.95v 1014.745n 0.95v 1014.755n 0.95v 1019.745n 0.95v 1019.755n 0.95v 1024.745n 0.95v 1024.755n 0.95v )
* (time, data): [(0, 0), (5, 0), (10, 1), (15, 1), (20, 1), (25, 1), (30, 1), (35, 1), (40, 1), (45, 1), (50, 1), (55, 1), (60, 0), (65, 0), (70, 0), (75, 1), (80, 1), (85, 0), (90, 0), (95, 1), (100, 1), (105, 0), (110, 0), (115, 0), (120, 0), (125, 1), (130, 1), (135, 1), (140, 1), (145, 1), (150, 1), (155, 1), (160, 1), (165, 1), (170, 1), (175, 1), (180, 0), (185, 0), (190, 0), (195, 0), (200, 1), (205, 1), (210, 1), (215, 1), (220, 1), (225, 1), (230, 0), (235, 0), (240, 0), (245, 1), (250, 1), (255, 1), (260, 1), (265, 0), (270, 1), (275, 1), (280, 1), (285, 0), (290, 0), (295, 0), (300, 1), (305, 1), (310, 1), (315, 0), (320, 0), (325, 0), (330, 0), (335, 0), (340, 0), (345, 1), (350, 1), (355, 1), (360, 1), (365, 0), (370, 0), (375, 0), (380, 0), (385, 0), (390, 0), (395, 0), (400, 0), (405, 0), (410, 1), (415, 1), (420, 1), (425, 1), (430, 1), (435, 0), (440, 0), (445, 0), (450, 0), (455, 0), (460, 1), (465, 1), (470, 1), (475, 0), (480, 1), (485, 1), (490, 1), (495, 1), (500, 1), (505, 1), (510, 1), (515, 1), (520, 0), (525, 0), (530, 1), (535, 1), (540, 1), (545, 1), (550, 1), (555, 1), (560, 0), (565, 0), (570, 0), (575, 0), (580, 0), (585, 0), (590, 0), (595, 0), (600, 0), (605, 0), (610, 0), (615, 0), (620, 0), (625, 0), (630, 0), (635, 0), (640, 0), (645, 1), (650, 1), (655, 1), (660, 1), (665, 1), (670, 0), (675, 0), (680, 0), (685, 1), (690, 1), (695, 1), (700, 1), (705, 1), (710, 1), (715, 1), (720, 1), (725, 1), (730, 0), (735, 0), (740, 0), (745, 0), (750, 0), (755, 0), (760, 0), (765, 0), (770, 0), (775, 0), (780, 0), (785, 0), (790, 0), (795, 0), (800, 0), (805, 0), (810, 0), (815, 0), (820, 0), (825, 0), (830, 0), (835, 0), (840, 1), (845, 0), (850, 0), (855, 1), (860, 1), (865, 1), (870, 0), (875, 0), (880, 0), (885, 1), (890, 1), (895, 1), (900, 1), (905, 0), (910, 0), (915, 0), (920, 1), (925, 1), (930, 1), (935, 1), (940, 1), (945, 1), (950, 0), (955, 1), (960, 1), (965, 1), (970, 0), (975, 0), (980, 0), (985, 0), (990, 1), (995, 1), (1000, 1), (1005, 1), (1010, 1), (1015, 1), (1020, 1), (1025, 1)]
Vdin0_27  din0_27  0 PWL (0n 0.0v 4.745n 0.0v 4.755n 0.0v 9.745n 0.0v 9.755n 0.95v 14.745n 0.95v 14.755n 0.95v 19.745n 0.95v 19.755n 0.95v 24.745n 0.95v 24.755n 0.95v 29.745n 0.95v 29.755n 0.95v 34.745n 0.95v 34.755n 0.95v 39.745n 0.95v 39.755n 0.95v 44.745n 0.95v 44.755n 0.95v 49.745n 0.95v 49.755n 0.95v 54.745n 0.95v 54.755n 0.95v 59.745n 0.95v 59.755n 0.0v 64.745n 0.0v 64.755n 0.0v 69.745n 0.0v 69.755n 0.0v 74.745n 0.0v 74.755n 0.95v 79.745n 0.95v 79.755n 0.95v 84.745n 0.95v 84.755n 0.0v 89.745n 0.0v 89.755n 0.0v 94.745n 0.0v 94.755n 0.95v 99.745n 0.95v 99.755n 0.95v 104.745n 0.95v 104.755n 0.0v 109.745n 0.0v 109.755n 0.0v 114.745n 0.0v 114.755n 0.0v 119.745n 0.0v 119.755n 0.0v 124.745n 0.0v 124.755n 0.95v 129.745n 0.95v 129.755n 0.95v 134.745n 0.95v 134.755n 0.95v 139.745n 0.95v 139.755n 0.95v 144.745n 0.95v 144.755n 0.95v 149.745n 0.95v 149.755n 0.95v 154.745n 0.95v 154.755n 0.95v 159.745n 0.95v 159.755n 0.95v 164.745n 0.95v 164.755n 0.95v 169.745n 0.95v 169.755n 0.95v 174.745n 0.95v 174.755n 0.95v 179.745n 0.95v 179.755n 0.0v 184.745n 0.0v 184.755n 0.0v 189.745n 0.0v 189.755n 0.0v 194.745n 0.0v 194.755n 0.0v 199.745n 0.0v 199.755n 0.95v 204.745n 0.95v 204.755n 0.95v 209.745n 0.95v 209.755n 0.95v 214.745n 0.95v 214.755n 0.95v 219.745n 0.95v 219.755n 0.95v 224.745n 0.95v 224.755n 0.95v 229.745n 0.95v 229.755n 0.0v 234.745n 0.0v 234.755n 0.0v 239.745n 0.0v 239.755n 0.0v 244.745n 0.0v 244.755n 0.95v 249.745n 0.95v 249.755n 0.95v 254.745n 0.95v 254.755n 0.95v 259.745n 0.95v 259.755n 0.95v 264.745n 0.95v 264.755n 0.0v 269.745n 0.0v 269.755n 0.95v 274.745n 0.95v 274.755n 0.95v 279.745n 0.95v 279.755n 0.95v 284.745n 0.95v 284.755n 0.0v 289.745n 0.0v 289.755n 0.0v 294.745n 0.0v 294.755n 0.0v 299.745n 0.0v 299.755n 0.95v 304.745n 0.95v 304.755n 0.95v 309.745n 0.95v 309.755n 0.95v 314.745n 0.95v 314.755n 0.0v 319.745n 0.0v 319.755n 0.0v 324.745n 0.0v 324.755n 0.0v 329.745n 0.0v 329.755n 0.0v 334.745n 0.0v 334.755n 0.0v 339.745n 0.0v 339.755n 0.0v 344.745n 0.0v 344.755n 0.95v 349.745n 0.95v 349.755n 0.95v 354.745n 0.95v 354.755n 0.95v 359.745n 0.95v 359.755n 0.95v 364.745n 0.95v 364.755n 0.0v 369.745n 0.0v 369.755n 0.0v 374.745n 0.0v 374.755n 0.0v 379.745n 0.0v 379.755n 0.0v 384.745n 0.0v 384.755n 0.0v 389.745n 0.0v 389.755n 0.0v 394.745n 0.0v 394.755n 0.0v 399.745n 0.0v 399.755n 0.0v 404.745n 0.0v 404.755n 0.0v 409.745n 0.0v 409.755n 0.95v 414.745n 0.95v 414.755n 0.95v 419.745n 0.95v 419.755n 0.95v 424.745n 0.95v 424.755n 0.95v 429.745n 0.95v 429.755n 0.95v 434.745n 0.95v 434.755n 0.0v 439.745n 0.0v 439.755n 0.0v 444.745n 0.0v 444.755n 0.0v 449.745n 0.0v 449.755n 0.0v 454.745n 0.0v 454.755n 0.0v 459.745n 0.0v 459.755n 0.95v 464.745n 0.95v 464.755n 0.95v 469.745n 0.95v 469.755n 0.95v 474.745n 0.95v 474.755n 0.0v 479.745n 0.0v 479.755n 0.95v 484.745n 0.95v 484.755n 0.95v 489.745n 0.95v 489.755n 0.95v 494.745n 0.95v 494.755n 0.95v 499.745n 0.95v 499.755n 0.95v 504.745n 0.95v 504.755n 0.95v 509.745n 0.95v 509.755n 0.95v 514.745n 0.95v 514.755n 0.95v 519.745n 0.95v 519.755n 0.0v 524.745n 0.0v 524.755n 0.0v 529.745n 0.0v 529.755n 0.95v 534.745n 0.95v 534.755n 0.95v 539.745n 0.95v 539.755n 0.95v 544.745n 0.95v 544.755n 0.95v 549.745n 0.95v 549.755n 0.95v 554.745n 0.95v 554.755n 0.95v 559.745n 0.95v 559.755n 0.0v 564.745n 0.0v 564.755n 0.0v 569.745n 0.0v 569.755n 0.0v 574.745n 0.0v 574.755n 0.0v 579.745n 0.0v 579.755n 0.0v 584.745n 0.0v 584.755n 0.0v 589.745n 0.0v 589.755n 0.0v 594.745n 0.0v 594.755n 0.0v 599.745n 0.0v 599.755n 0.0v 604.745n 0.0v 604.755n 0.0v 609.745n 0.0v 609.755n 0.0v 614.745n 0.0v 614.755n 0.0v 619.745n 0.0v 619.755n 0.0v 624.745n 0.0v 624.755n 0.0v 629.745n 0.0v 629.755n 0.0v 634.745n 0.0v 634.755n 0.0v 639.745n 0.0v 639.755n 0.0v 644.745n 0.0v 644.755n 0.95v 649.745n 0.95v 649.755n 0.95v 654.745n 0.95v 654.755n 0.95v 659.745n 0.95v 659.755n 0.95v 664.745n 0.95v 664.755n 0.95v 669.745n 0.95v 669.755n 0.0v 674.745n 0.0v 674.755n 0.0v 679.745n 0.0v 679.755n 0.0v 684.745n 0.0v 684.755n 0.95v 689.745n 0.95v 689.755n 0.95v 694.745n 0.95v 694.755n 0.95v 699.745n 0.95v 699.755n 0.95v 704.745n 0.95v 704.755n 0.95v 709.745n 0.95v 709.755n 0.95v 714.745n 0.95v 714.755n 0.95v 719.745n 0.95v 719.755n 0.95v 724.745n 0.95v 724.755n 0.95v 729.745n 0.95v 729.755n 0.0v 734.745n 0.0v 734.755n 0.0v 739.745n 0.0v 739.755n 0.0v 744.745n 0.0v 744.755n 0.0v 749.745n 0.0v 749.755n 0.0v 754.745n 0.0v 754.755n 0.0v 759.745n 0.0v 759.755n 0.0v 764.745n 0.0v 764.755n 0.0v 769.745n 0.0v 769.755n 0.0v 774.745n 0.0v 774.755n 0.0v 779.745n 0.0v 779.755n 0.0v 784.745n 0.0v 784.755n 0.0v 789.745n 0.0v 789.755n 0.0v 794.745n 0.0v 794.755n 0.0v 799.745n 0.0v 799.755n 0.0v 804.745n 0.0v 804.755n 0.0v 809.745n 0.0v 809.755n 0.0v 814.745n 0.0v 814.755n 0.0v 819.745n 0.0v 819.755n 0.0v 824.745n 0.0v 824.755n 0.0v 829.745n 0.0v 829.755n 0.0v 834.745n 0.0v 834.755n 0.0v 839.745n 0.0v 839.755n 0.95v 844.745n 0.95v 844.755n 0.0v 849.745n 0.0v 849.755n 0.0v 854.745n 0.0v 854.755n 0.95v 859.745n 0.95v 859.755n 0.95v 864.745n 0.95v 864.755n 0.95v 869.745n 0.95v 869.755n 0.0v 874.745n 0.0v 874.755n 0.0v 879.745n 0.0v 879.755n 0.0v 884.745n 0.0v 884.755n 0.95v 889.745n 0.95v 889.755n 0.95v 894.745n 0.95v 894.755n 0.95v 899.745n 0.95v 899.755n 0.95v 904.745n 0.95v 904.755n 0.0v 909.745n 0.0v 909.755n 0.0v 914.745n 0.0v 914.755n 0.0v 919.745n 0.0v 919.755n 0.95v 924.745n 0.95v 924.755n 0.95v 929.745n 0.95v 929.755n 0.95v 934.745n 0.95v 934.755n 0.95v 939.745n 0.95v 939.755n 0.95v 944.745n 0.95v 944.755n 0.95v 949.745n 0.95v 949.755n 0.0v 954.745n 0.0v 954.755n 0.95v 959.745n 0.95v 959.755n 0.95v 964.745n 0.95v 964.755n 0.95v 969.745n 0.95v 969.755n 0.0v 974.745n 0.0v 974.755n 0.0v 979.745n 0.0v 979.755n 0.0v 984.745n 0.0v 984.755n 0.0v 989.745n 0.0v 989.755n 0.95v 994.745n 0.95v 994.755n 0.95v 999.745n 0.95v 999.755n 0.95v 1004.745n 0.95v 1004.755n 0.95v 1009.745n 0.95v 1009.755n 0.95v 1014.745n 0.95v 1014.755n 0.95v 1019.745n 0.95v 1019.755n 0.95v 1024.745n 0.95v 1024.755n 0.95v )
* (time, data): [(0, 0), (5, 0), (10, 0), (15, 0), (20, 0), (25, 1), (30, 1), (35, 0), (40, 1), (45, 0), (50, 0), (55, 0), (60, 1), (65, 0), (70, 0), (75, 1), (80, 1), (85, 1), (90, 1), (95, 0), (100, 0), (105, 1), (110, 1), (115, 1), (120, 1), (125, 1), (130, 1), (135, 1), (140, 1), (145, 1), (150, 1), (155, 1), (160, 1), (165, 1), (170, 1), (175, 1), (180, 1), (185, 0), (190, 0), (195, 0), (200, 0), (205, 0), (210, 0), (215, 0), (220, 0), (225, 0), (230, 0), (235, 0), (240, 0), (245, 1), (250, 1), (255, 1), (260, 1), (265, 0), (270, 0), (275, 0), (280, 0), (285, 1), (290, 1), (295, 1), (300, 0), (305, 0), (310, 0), (315, 0), (320, 0), (325, 0), (330, 0), (335, 0), (340, 0), (345, 1), (350, 1), (355, 1), (360, 1), (365, 0), (370, 0), (375, 0), (380, 0), (385, 0), (390, 1), (395, 1), (400, 1), (405, 1), (410, 0), (415, 0), (420, 0), (425, 0), (430, 0), (435, 0), (440, 1), (445, 0), (450, 0), (455, 0), (460, 0), (465, 1), (470, 1), (475, 0), (480, 0), (485, 1), (490, 0), (495, 0), (500, 0), (505, 0), (510, 0), (515, 0), (520, 1), (525, 1), (530, 0), (535, 1), (540, 0), (545, 0), (550, 0), (555, 1), (560, 1), (565, 1), (570, 1), (575, 1), (580, 1), (585, 1), (590, 1), (595, 0), (600, 0), (605, 0), (610, 0), (615, 0), (620, 0), (625, 0), (630, 0), (635, 0), (640, 0), (645, 0), (650, 0), (655, 0), (660, 0), (665, 0), (670, 0), (675, 0), (680, 0), (685, 0), (690, 0), (695, 0), (700, 0), (705, 0), (710, 0), (715, 0), (720, 0), (725, 0), (730, 1), (735, 1), (740, 1), (745, 1), (750, 1), (755, 1), (760, 1), (765, 1), (770, 1), (775, 1), (780, 1), (785, 1), (790, 1), (795, 1), (800, 1), (805, 1), (810, 1), (815, 1), (820, 1), (825, 1), (830, 1), (835, 1), (840, 0), (845, 0), (850, 0), (855, 1), (860, 1), (865, 1), (870, 1), (875, 1), (880, 1), (885, 0), (890, 0), (895, 0), (900, 0), (905, 0), (910, 1), (915, 1), (920, 1), (925, 0), (930, 0), (935, 0), (940, 0), (945, 0), (950, 0), (955, 1), (960, 1), (965, 1), (970, 0), (975, 0), (980, 0), (985, 0), (990, 1), (995, 1), (1000, 1), (1005, 0), (1010, 0), (1015, 0), (1020, 0), (1025, 0)]
Vdin0_28  din0_28  0 PWL (0n 0.0v 4.745n 0.0v 4.755n 0.0v 9.745n 0.0v 9.755n 0.0v 14.745n 0.0v 14.755n 0.0v 19.745n 0.0v 19.755n 0.0v 24.745n 0.0v 24.755n 0.95v 29.745n 0.95v 29.755n 0.95v 34.745n 0.95v 34.755n 0.0v 39.745n 0.0v 39.755n 0.95v 44.745n 0.95v 44.755n 0.0v 49.745n 0.0v 49.755n 0.0v 54.745n 0.0v 54.755n 0.0v 59.745n 0.0v 59.755n 0.95v 64.745n 0.95v 64.755n 0.0v 69.745n 0.0v 69.755n 0.0v 74.745n 0.0v 74.755n 0.95v 79.745n 0.95v 79.755n 0.95v 84.745n 0.95v 84.755n 0.95v 89.745n 0.95v 89.755n 0.95v 94.745n 0.95v 94.755n 0.0v 99.745n 0.0v 99.755n 0.0v 104.745n 0.0v 104.755n 0.95v 109.745n 0.95v 109.755n 0.95v 114.745n 0.95v 114.755n 0.95v 119.745n 0.95v 119.755n 0.95v 124.745n 0.95v 124.755n 0.95v 129.745n 0.95v 129.755n 0.95v 134.745n 0.95v 134.755n 0.95v 139.745n 0.95v 139.755n 0.95v 144.745n 0.95v 144.755n 0.95v 149.745n 0.95v 149.755n 0.95v 154.745n 0.95v 154.755n 0.95v 159.745n 0.95v 159.755n 0.95v 164.745n 0.95v 164.755n 0.95v 169.745n 0.95v 169.755n 0.95v 174.745n 0.95v 174.755n 0.95v 179.745n 0.95v 179.755n 0.95v 184.745n 0.95v 184.755n 0.0v 189.745n 0.0v 189.755n 0.0v 194.745n 0.0v 194.755n 0.0v 199.745n 0.0v 199.755n 0.0v 204.745n 0.0v 204.755n 0.0v 209.745n 0.0v 209.755n 0.0v 214.745n 0.0v 214.755n 0.0v 219.745n 0.0v 219.755n 0.0v 224.745n 0.0v 224.755n 0.0v 229.745n 0.0v 229.755n 0.0v 234.745n 0.0v 234.755n 0.0v 239.745n 0.0v 239.755n 0.0v 244.745n 0.0v 244.755n 0.95v 249.745n 0.95v 249.755n 0.95v 254.745n 0.95v 254.755n 0.95v 259.745n 0.95v 259.755n 0.95v 264.745n 0.95v 264.755n 0.0v 269.745n 0.0v 269.755n 0.0v 274.745n 0.0v 274.755n 0.0v 279.745n 0.0v 279.755n 0.0v 284.745n 0.0v 284.755n 0.95v 289.745n 0.95v 289.755n 0.95v 294.745n 0.95v 294.755n 0.95v 299.745n 0.95v 299.755n 0.0v 304.745n 0.0v 304.755n 0.0v 309.745n 0.0v 309.755n 0.0v 314.745n 0.0v 314.755n 0.0v 319.745n 0.0v 319.755n 0.0v 324.745n 0.0v 324.755n 0.0v 329.745n 0.0v 329.755n 0.0v 334.745n 0.0v 334.755n 0.0v 339.745n 0.0v 339.755n 0.0v 344.745n 0.0v 344.755n 0.95v 349.745n 0.95v 349.755n 0.95v 354.745n 0.95v 354.755n 0.95v 359.745n 0.95v 359.755n 0.95v 364.745n 0.95v 364.755n 0.0v 369.745n 0.0v 369.755n 0.0v 374.745n 0.0v 374.755n 0.0v 379.745n 0.0v 379.755n 0.0v 384.745n 0.0v 384.755n 0.0v 389.745n 0.0v 389.755n 0.95v 394.745n 0.95v 394.755n 0.95v 399.745n 0.95v 399.755n 0.95v 404.745n 0.95v 404.755n 0.95v 409.745n 0.95v 409.755n 0.0v 414.745n 0.0v 414.755n 0.0v 419.745n 0.0v 419.755n 0.0v 424.745n 0.0v 424.755n 0.0v 429.745n 0.0v 429.755n 0.0v 434.745n 0.0v 434.755n 0.0v 439.745n 0.0v 439.755n 0.95v 444.745n 0.95v 444.755n 0.0v 449.745n 0.0v 449.755n 0.0v 454.745n 0.0v 454.755n 0.0v 459.745n 0.0v 459.755n 0.0v 464.745n 0.0v 464.755n 0.95v 469.745n 0.95v 469.755n 0.95v 474.745n 0.95v 474.755n 0.0v 479.745n 0.0v 479.755n 0.0v 484.745n 0.0v 484.755n 0.95v 489.745n 0.95v 489.755n 0.0v 494.745n 0.0v 494.755n 0.0v 499.745n 0.0v 499.755n 0.0v 504.745n 0.0v 504.755n 0.0v 509.745n 0.0v 509.755n 0.0v 514.745n 0.0v 514.755n 0.0v 519.745n 0.0v 519.755n 0.95v 524.745n 0.95v 524.755n 0.95v 529.745n 0.95v 529.755n 0.0v 534.745n 0.0v 534.755n 0.95v 539.745n 0.95v 539.755n 0.0v 544.745n 0.0v 544.755n 0.0v 549.745n 0.0v 549.755n 0.0v 554.745n 0.0v 554.755n 0.95v 559.745n 0.95v 559.755n 0.95v 564.745n 0.95v 564.755n 0.95v 569.745n 0.95v 569.755n 0.95v 574.745n 0.95v 574.755n 0.95v 579.745n 0.95v 579.755n 0.95v 584.745n 0.95v 584.755n 0.95v 589.745n 0.95v 589.755n 0.95v 594.745n 0.95v 594.755n 0.0v 599.745n 0.0v 599.755n 0.0v 604.745n 0.0v 604.755n 0.0v 609.745n 0.0v 609.755n 0.0v 614.745n 0.0v 614.755n 0.0v 619.745n 0.0v 619.755n 0.0v 624.745n 0.0v 624.755n 0.0v 629.745n 0.0v 629.755n 0.0v 634.745n 0.0v 634.755n 0.0v 639.745n 0.0v 639.755n 0.0v 644.745n 0.0v 644.755n 0.0v 649.745n 0.0v 649.755n 0.0v 654.745n 0.0v 654.755n 0.0v 659.745n 0.0v 659.755n 0.0v 664.745n 0.0v 664.755n 0.0v 669.745n 0.0v 669.755n 0.0v 674.745n 0.0v 674.755n 0.0v 679.745n 0.0v 679.755n 0.0v 684.745n 0.0v 684.755n 0.0v 689.745n 0.0v 689.755n 0.0v 694.745n 0.0v 694.755n 0.0v 699.745n 0.0v 699.755n 0.0v 704.745n 0.0v 704.755n 0.0v 709.745n 0.0v 709.755n 0.0v 714.745n 0.0v 714.755n 0.0v 719.745n 0.0v 719.755n 0.0v 724.745n 0.0v 724.755n 0.0v 729.745n 0.0v 729.755n 0.95v 734.745n 0.95v 734.755n 0.95v 739.745n 0.95v 739.755n 0.95v 744.745n 0.95v 744.755n 0.95v 749.745n 0.95v 749.755n 0.95v 754.745n 0.95v 754.755n 0.95v 759.745n 0.95v 759.755n 0.95v 764.745n 0.95v 764.755n 0.95v 769.745n 0.95v 769.755n 0.95v 774.745n 0.95v 774.755n 0.95v 779.745n 0.95v 779.755n 0.95v 784.745n 0.95v 784.755n 0.95v 789.745n 0.95v 789.755n 0.95v 794.745n 0.95v 794.755n 0.95v 799.745n 0.95v 799.755n 0.95v 804.745n 0.95v 804.755n 0.95v 809.745n 0.95v 809.755n 0.95v 814.745n 0.95v 814.755n 0.95v 819.745n 0.95v 819.755n 0.95v 824.745n 0.95v 824.755n 0.95v 829.745n 0.95v 829.755n 0.95v 834.745n 0.95v 834.755n 0.95v 839.745n 0.95v 839.755n 0.0v 844.745n 0.0v 844.755n 0.0v 849.745n 0.0v 849.755n 0.0v 854.745n 0.0v 854.755n 0.95v 859.745n 0.95v 859.755n 0.95v 864.745n 0.95v 864.755n 0.95v 869.745n 0.95v 869.755n 0.95v 874.745n 0.95v 874.755n 0.95v 879.745n 0.95v 879.755n 0.95v 884.745n 0.95v 884.755n 0.0v 889.745n 0.0v 889.755n 0.0v 894.745n 0.0v 894.755n 0.0v 899.745n 0.0v 899.755n 0.0v 904.745n 0.0v 904.755n 0.0v 909.745n 0.0v 909.755n 0.95v 914.745n 0.95v 914.755n 0.95v 919.745n 0.95v 919.755n 0.95v 924.745n 0.95v 924.755n 0.0v 929.745n 0.0v 929.755n 0.0v 934.745n 0.0v 934.755n 0.0v 939.745n 0.0v 939.755n 0.0v 944.745n 0.0v 944.755n 0.0v 949.745n 0.0v 949.755n 0.0v 954.745n 0.0v 954.755n 0.95v 959.745n 0.95v 959.755n 0.95v 964.745n 0.95v 964.755n 0.95v 969.745n 0.95v 969.755n 0.0v 974.745n 0.0v 974.755n 0.0v 979.745n 0.0v 979.755n 0.0v 984.745n 0.0v 984.755n 0.0v 989.745n 0.0v 989.755n 0.95v 994.745n 0.95v 994.755n 0.95v 999.745n 0.95v 999.755n 0.95v 1004.745n 0.95v 1004.755n 0.0v 1009.745n 0.0v 1009.755n 0.0v 1014.745n 0.0v 1014.755n 0.0v 1019.745n 0.0v 1019.755n 0.0v 1024.745n 0.0v 1024.755n 0.0v )
* (time, data): [(0, 0), (5, 0), (10, 1), (15, 1), (20, 1), (25, 1), (30, 1), (35, 1), (40, 1), (45, 1), (50, 1), (55, 1), (60, 1), (65, 1), (70, 1), (75, 1), (80, 1), (85, 0), (90, 0), (95, 1), (100, 1), (105, 1), (110, 1), (115, 1), (120, 1), (125, 1), (130, 1), (135, 1), (140, 1), (145, 1), (150, 1), (155, 1), (160, 1), (165, 1), (170, 1), (175, 1), (180, 1), (185, 1), (190, 1), (195, 1), (200, 1), (205, 1), (210, 1), (215, 1), (220, 1), (225, 1), (230, 1), (235, 1), (240, 1), (245, 0), (250, 0), (255, 0), (260, 0), (265, 0), (270, 1), (275, 1), (280, 1), (285, 0), (290, 0), (295, 0), (300, 1), (305, 1), (310, 1), (315, 1), (320, 1), (325, 1), (330, 1), (335, 1), (340, 1), (345, 1), (350, 1), (355, 1), (360, 1), (365, 1), (370, 1), (375, 1), (380, 1), (385, 1), (390, 1), (395, 1), (400, 1), (405, 1), (410, 1), (415, 1), (420, 1), (425, 0), (430, 0), (435, 1), (440, 1), (445, 1), (450, 1), (455, 1), (460, 0), (465, 1), (470, 1), (475, 1), (480, 0), (485, 1), (490, 0), (495, 0), (500, 1), (505, 1), (510, 1), (515, 1), (520, 1), (525, 1), (530, 0), (535, 1), (540, 0), (545, 0), (550, 0), (555, 1), (560, 1), (565, 1), (570, 1), (575, 1), (580, 1), (585, 1), (590, 1), (595, 1), (600, 1), (605, 1), (610, 1), (615, 1), (620, 1), (625, 1), (630, 1), (635, 1), (640, 1), (645, 0), (650, 0), (655, 0), (660, 0), (665, 0), (670, 1), (675, 1), (680, 1), (685, 1), (690, 1), (695, 1), (700, 1), (705, 1), (710, 1), (715, 1), (720, 1), (725, 1), (730, 0), (735, 0), (740, 0), (745, 1), (750, 1), (755, 1), (760, 1), (765, 0), (770, 0), (775, 0), (780, 0), (785, 0), (790, 0), (795, 0), (800, 0), (805, 0), (810, 0), (815, 0), (820, 0), (825, 0), (830, 0), (835, 0), (840, 1), (845, 0), (850, 0), (855, 0), (860, 0), (865, 0), (870, 0), (875, 0), (880, 0), (885, 1), (890, 0), (895, 0), (900, 0), (905, 0), (910, 1), (915, 1), (920, 1), (925, 0), (930, 0), (935, 1), (940, 1), (945, 1), (950, 0), (955, 0), (960, 0), (965, 0), (970, 0), (975, 0), (980, 1), (985, 0), (990, 0), (995, 0), (1000, 0), (1005, 1), (1010, 1), (1015, 1), (1020, 1), (1025, 1)]
Vdin0_29  din0_29  0 PWL (0n 0.0v 4.745n 0.0v 4.755n 0.0v 9.745n 0.0v 9.755n 0.95v 14.745n 0.95v 14.755n 0.95v 19.745n 0.95v 19.755n 0.95v 24.745n 0.95v 24.755n 0.95v 29.745n 0.95v 29.755n 0.95v 34.745n 0.95v 34.755n 0.95v 39.745n 0.95v 39.755n 0.95v 44.745n 0.95v 44.755n 0.95v 49.745n 0.95v 49.755n 0.95v 54.745n 0.95v 54.755n 0.95v 59.745n 0.95v 59.755n 0.95v 64.745n 0.95v 64.755n 0.95v 69.745n 0.95v 69.755n 0.95v 74.745n 0.95v 74.755n 0.95v 79.745n 0.95v 79.755n 0.95v 84.745n 0.95v 84.755n 0.0v 89.745n 0.0v 89.755n 0.0v 94.745n 0.0v 94.755n 0.95v 99.745n 0.95v 99.755n 0.95v 104.745n 0.95v 104.755n 0.95v 109.745n 0.95v 109.755n 0.95v 114.745n 0.95v 114.755n 0.95v 119.745n 0.95v 119.755n 0.95v 124.745n 0.95v 124.755n 0.95v 129.745n 0.95v 129.755n 0.95v 134.745n 0.95v 134.755n 0.95v 139.745n 0.95v 139.755n 0.95v 144.745n 0.95v 144.755n 0.95v 149.745n 0.95v 149.755n 0.95v 154.745n 0.95v 154.755n 0.95v 159.745n 0.95v 159.755n 0.95v 164.745n 0.95v 164.755n 0.95v 169.745n 0.95v 169.755n 0.95v 174.745n 0.95v 174.755n 0.95v 179.745n 0.95v 179.755n 0.95v 184.745n 0.95v 184.755n 0.95v 189.745n 0.95v 189.755n 0.95v 194.745n 0.95v 194.755n 0.95v 199.745n 0.95v 199.755n 0.95v 204.745n 0.95v 204.755n 0.95v 209.745n 0.95v 209.755n 0.95v 214.745n 0.95v 214.755n 0.95v 219.745n 0.95v 219.755n 0.95v 224.745n 0.95v 224.755n 0.95v 229.745n 0.95v 229.755n 0.95v 234.745n 0.95v 234.755n 0.95v 239.745n 0.95v 239.755n 0.95v 244.745n 0.95v 244.755n 0.0v 249.745n 0.0v 249.755n 0.0v 254.745n 0.0v 254.755n 0.0v 259.745n 0.0v 259.755n 0.0v 264.745n 0.0v 264.755n 0.0v 269.745n 0.0v 269.755n 0.95v 274.745n 0.95v 274.755n 0.95v 279.745n 0.95v 279.755n 0.95v 284.745n 0.95v 284.755n 0.0v 289.745n 0.0v 289.755n 0.0v 294.745n 0.0v 294.755n 0.0v 299.745n 0.0v 299.755n 0.95v 304.745n 0.95v 304.755n 0.95v 309.745n 0.95v 309.755n 0.95v 314.745n 0.95v 314.755n 0.95v 319.745n 0.95v 319.755n 0.95v 324.745n 0.95v 324.755n 0.95v 329.745n 0.95v 329.755n 0.95v 334.745n 0.95v 334.755n 0.95v 339.745n 0.95v 339.755n 0.95v 344.745n 0.95v 344.755n 0.95v 349.745n 0.95v 349.755n 0.95v 354.745n 0.95v 354.755n 0.95v 359.745n 0.95v 359.755n 0.95v 364.745n 0.95v 364.755n 0.95v 369.745n 0.95v 369.755n 0.95v 374.745n 0.95v 374.755n 0.95v 379.745n 0.95v 379.755n 0.95v 384.745n 0.95v 384.755n 0.95v 389.745n 0.95v 389.755n 0.95v 394.745n 0.95v 394.755n 0.95v 399.745n 0.95v 399.755n 0.95v 404.745n 0.95v 404.755n 0.95v 409.745n 0.95v 409.755n 0.95v 414.745n 0.95v 414.755n 0.95v 419.745n 0.95v 419.755n 0.95v 424.745n 0.95v 424.755n 0.0v 429.745n 0.0v 429.755n 0.0v 434.745n 0.0v 434.755n 0.95v 439.745n 0.95v 439.755n 0.95v 444.745n 0.95v 444.755n 0.95v 449.745n 0.95v 449.755n 0.95v 454.745n 0.95v 454.755n 0.95v 459.745n 0.95v 459.755n 0.0v 464.745n 0.0v 464.755n 0.95v 469.745n 0.95v 469.755n 0.95v 474.745n 0.95v 474.755n 0.95v 479.745n 0.95v 479.755n 0.0v 484.745n 0.0v 484.755n 0.95v 489.745n 0.95v 489.755n 0.0v 494.745n 0.0v 494.755n 0.0v 499.745n 0.0v 499.755n 0.95v 504.745n 0.95v 504.755n 0.95v 509.745n 0.95v 509.755n 0.95v 514.745n 0.95v 514.755n 0.95v 519.745n 0.95v 519.755n 0.95v 524.745n 0.95v 524.755n 0.95v 529.745n 0.95v 529.755n 0.0v 534.745n 0.0v 534.755n 0.95v 539.745n 0.95v 539.755n 0.0v 544.745n 0.0v 544.755n 0.0v 549.745n 0.0v 549.755n 0.0v 554.745n 0.0v 554.755n 0.95v 559.745n 0.95v 559.755n 0.95v 564.745n 0.95v 564.755n 0.95v 569.745n 0.95v 569.755n 0.95v 574.745n 0.95v 574.755n 0.95v 579.745n 0.95v 579.755n 0.95v 584.745n 0.95v 584.755n 0.95v 589.745n 0.95v 589.755n 0.95v 594.745n 0.95v 594.755n 0.95v 599.745n 0.95v 599.755n 0.95v 604.745n 0.95v 604.755n 0.95v 609.745n 0.95v 609.755n 0.95v 614.745n 0.95v 614.755n 0.95v 619.745n 0.95v 619.755n 0.95v 624.745n 0.95v 624.755n 0.95v 629.745n 0.95v 629.755n 0.95v 634.745n 0.95v 634.755n 0.95v 639.745n 0.95v 639.755n 0.95v 644.745n 0.95v 644.755n 0.0v 649.745n 0.0v 649.755n 0.0v 654.745n 0.0v 654.755n 0.0v 659.745n 0.0v 659.755n 0.0v 664.745n 0.0v 664.755n 0.0v 669.745n 0.0v 669.755n 0.95v 674.745n 0.95v 674.755n 0.95v 679.745n 0.95v 679.755n 0.95v 684.745n 0.95v 684.755n 0.95v 689.745n 0.95v 689.755n 0.95v 694.745n 0.95v 694.755n 0.95v 699.745n 0.95v 699.755n 0.95v 704.745n 0.95v 704.755n 0.95v 709.745n 0.95v 709.755n 0.95v 714.745n 0.95v 714.755n 0.95v 719.745n 0.95v 719.755n 0.95v 724.745n 0.95v 724.755n 0.95v 729.745n 0.95v 729.755n 0.0v 734.745n 0.0v 734.755n 0.0v 739.745n 0.0v 739.755n 0.0v 744.745n 0.0v 744.755n 0.95v 749.745n 0.95v 749.755n 0.95v 754.745n 0.95v 754.755n 0.95v 759.745n 0.95v 759.755n 0.95v 764.745n 0.95v 764.755n 0.0v 769.745n 0.0v 769.755n 0.0v 774.745n 0.0v 774.755n 0.0v 779.745n 0.0v 779.755n 0.0v 784.745n 0.0v 784.755n 0.0v 789.745n 0.0v 789.755n 0.0v 794.745n 0.0v 794.755n 0.0v 799.745n 0.0v 799.755n 0.0v 804.745n 0.0v 804.755n 0.0v 809.745n 0.0v 809.755n 0.0v 814.745n 0.0v 814.755n 0.0v 819.745n 0.0v 819.755n 0.0v 824.745n 0.0v 824.755n 0.0v 829.745n 0.0v 829.755n 0.0v 834.745n 0.0v 834.755n 0.0v 839.745n 0.0v 839.755n 0.95v 844.745n 0.95v 844.755n 0.0v 849.745n 0.0v 849.755n 0.0v 854.745n 0.0v 854.755n 0.0v 859.745n 0.0v 859.755n 0.0v 864.745n 0.0v 864.755n 0.0v 869.745n 0.0v 869.755n 0.0v 874.745n 0.0v 874.755n 0.0v 879.745n 0.0v 879.755n 0.0v 884.745n 0.0v 884.755n 0.95v 889.745n 0.95v 889.755n 0.0v 894.745n 0.0v 894.755n 0.0v 899.745n 0.0v 899.755n 0.0v 904.745n 0.0v 904.755n 0.0v 909.745n 0.0v 909.755n 0.95v 914.745n 0.95v 914.755n 0.95v 919.745n 0.95v 919.755n 0.95v 924.745n 0.95v 924.755n 0.0v 929.745n 0.0v 929.755n 0.0v 934.745n 0.0v 934.755n 0.95v 939.745n 0.95v 939.755n 0.95v 944.745n 0.95v 944.755n 0.95v 949.745n 0.95v 949.755n 0.0v 954.745n 0.0v 954.755n 0.0v 959.745n 0.0v 959.755n 0.0v 964.745n 0.0v 964.755n 0.0v 969.745n 0.0v 969.755n 0.0v 974.745n 0.0v 974.755n 0.0v 979.745n 0.0v 979.755n 0.95v 984.745n 0.95v 984.755n 0.0v 989.745n 0.0v 989.755n 0.0v 994.745n 0.0v 994.755n 0.0v 999.745n 0.0v 999.755n 0.0v 1004.745n 0.0v 1004.755n 0.95v 1009.745n 0.95v 1009.755n 0.95v 1014.745n 0.95v 1014.755n 0.95v 1019.745n 0.95v 1019.755n 0.95v 1024.745n 0.95v 1024.755n 0.95v )
* (time, data): [(0, 0), (5, 1), (10, 1), (15, 1), (20, 1), (25, 1), (30, 0), (35, 1), (40, 0), (45, 1), (50, 1), (55, 1), (60, 0), (65, 1), (70, 1), (75, 0), (80, 0), (85, 1), (90, 1), (95, 0), (100, 0), (105, 0), (110, 0), (115, 1), (120, 1), (125, 1), (130, 0), (135, 0), (140, 0), (145, 0), (150, 0), (155, 0), (160, 0), (165, 0), (170, 0), (175, 0), (180, 0), (185, 0), (190, 0), (195, 0), (200, 0), (205, 0), (210, 0), (215, 0), (220, 0), (225, 0), (230, 1), (235, 1), (240, 1), (245, 0), (250, 0), (255, 0), (260, 0), (265, 0), (270, 0), (275, 0), (280, 0), (285, 0), (290, 0), (295, 0), (300, 0), (305, 0), (310, 0), (315, 1), (320, 1), (325, 1), (330, 1), (335, 1), (340, 1), (345, 1), (350, 1), (355, 1), (360, 0), (365, 0), (370, 0), (375, 0), (380, 0), (385, 0), (390, 0), (395, 0), (400, 0), (405, 0), (410, 0), (415, 0), (420, 0), (425, 1), (430, 1), (435, 0), (440, 1), (445, 1), (450, 1), (455, 1), (460, 1), (465, 0), (470, 0), (475, 0), (480, 0), (485, 0), (490, 0), (495, 0), (500, 1), (505, 1), (510, 1), (515, 1), (520, 0), (525, 0), (530, 0), (535, 1), (540, 1), (545, 1), (550, 1), (555, 0), (560, 1), (565, 1), (570, 1), (575, 1), (580, 1), (585, 1), (590, 1), (595, 1), (600, 1), (605, 1), (610, 1), (615, 1), (620, 1), (625, 1), (630, 1), (635, 1), (640, 1), (645, 1), (650, 1), (655, 1), (660, 1), (665, 1), (670, 1), (675, 1), (680, 1), (685, 1), (690, 1), (695, 1), (700, 1), (705, 1), (710, 1), (715, 1), (720, 1), (725, 1), (730, 1), (735, 1), (740, 1), (745, 0), (750, 0), (755, 0), (760, 0), (765, 1), (770, 1), (775, 1), (780, 1), (785, 1), (790, 1), (795, 1), (800, 1), (805, 1), (810, 1), (815, 1), (820, 1), (825, 1), (830, 1), (835, 1), (840, 0), (845, 0), (850, 1), (855, 0), (860, 0), (865, 0), (870, 1), (875, 1), (880, 1), (885, 1), (890, 0), (895, 0), (900, 0), (905, 0), (910, 1), (915, 1), (920, 0), (925, 1), (930, 1), (935, 1), (940, 1), (945, 1), (950, 0), (955, 1), (960, 1), (965, 1), (970, 0), (975, 0), (980, 0), (985, 1), (990, 1), (995, 1), (1000, 1), (1005, 1), (1010, 1), (1015, 1), (1020, 1), (1025, 1)]
Vdin0_30  din0_30  0 PWL (0n 0.0v 4.745n 0.0v 4.755n 0.95v 9.745n 0.95v 9.755n 0.95v 14.745n 0.95v 14.755n 0.95v 19.745n 0.95v 19.755n 0.95v 24.745n 0.95v 24.755n 0.95v 29.745n 0.95v 29.755n 0.0v 34.745n 0.0v 34.755n 0.95v 39.745n 0.95v 39.755n 0.0v 44.745n 0.0v 44.755n 0.95v 49.745n 0.95v 49.755n 0.95v 54.745n 0.95v 54.755n 0.95v 59.745n 0.95v 59.755n 0.0v 64.745n 0.0v 64.755n 0.95v 69.745n 0.95v 69.755n 0.95v 74.745n 0.95v 74.755n 0.0v 79.745n 0.0v 79.755n 0.0v 84.745n 0.0v 84.755n 0.95v 89.745n 0.95v 89.755n 0.95v 94.745n 0.95v 94.755n 0.0v 99.745n 0.0v 99.755n 0.0v 104.745n 0.0v 104.755n 0.0v 109.745n 0.0v 109.755n 0.0v 114.745n 0.0v 114.755n 0.95v 119.745n 0.95v 119.755n 0.95v 124.745n 0.95v 124.755n 0.95v 129.745n 0.95v 129.755n 0.0v 134.745n 0.0v 134.755n 0.0v 139.745n 0.0v 139.755n 0.0v 144.745n 0.0v 144.755n 0.0v 149.745n 0.0v 149.755n 0.0v 154.745n 0.0v 154.755n 0.0v 159.745n 0.0v 159.755n 0.0v 164.745n 0.0v 164.755n 0.0v 169.745n 0.0v 169.755n 0.0v 174.745n 0.0v 174.755n 0.0v 179.745n 0.0v 179.755n 0.0v 184.745n 0.0v 184.755n 0.0v 189.745n 0.0v 189.755n 0.0v 194.745n 0.0v 194.755n 0.0v 199.745n 0.0v 199.755n 0.0v 204.745n 0.0v 204.755n 0.0v 209.745n 0.0v 209.755n 0.0v 214.745n 0.0v 214.755n 0.0v 219.745n 0.0v 219.755n 0.0v 224.745n 0.0v 224.755n 0.0v 229.745n 0.0v 229.755n 0.95v 234.745n 0.95v 234.755n 0.95v 239.745n 0.95v 239.755n 0.95v 244.745n 0.95v 244.755n 0.0v 249.745n 0.0v 249.755n 0.0v 254.745n 0.0v 254.755n 0.0v 259.745n 0.0v 259.755n 0.0v 264.745n 0.0v 264.755n 0.0v 269.745n 0.0v 269.755n 0.0v 274.745n 0.0v 274.755n 0.0v 279.745n 0.0v 279.755n 0.0v 284.745n 0.0v 284.755n 0.0v 289.745n 0.0v 289.755n 0.0v 294.745n 0.0v 294.755n 0.0v 299.745n 0.0v 299.755n 0.0v 304.745n 0.0v 304.755n 0.0v 309.745n 0.0v 309.755n 0.0v 314.745n 0.0v 314.755n 0.95v 319.745n 0.95v 319.755n 0.95v 324.745n 0.95v 324.755n 0.95v 329.745n 0.95v 329.755n 0.95v 334.745n 0.95v 334.755n 0.95v 339.745n 0.95v 339.755n 0.95v 344.745n 0.95v 344.755n 0.95v 349.745n 0.95v 349.755n 0.95v 354.745n 0.95v 354.755n 0.95v 359.745n 0.95v 359.755n 0.0v 364.745n 0.0v 364.755n 0.0v 369.745n 0.0v 369.755n 0.0v 374.745n 0.0v 374.755n 0.0v 379.745n 0.0v 379.755n 0.0v 384.745n 0.0v 384.755n 0.0v 389.745n 0.0v 389.755n 0.0v 394.745n 0.0v 394.755n 0.0v 399.745n 0.0v 399.755n 0.0v 404.745n 0.0v 404.755n 0.0v 409.745n 0.0v 409.755n 0.0v 414.745n 0.0v 414.755n 0.0v 419.745n 0.0v 419.755n 0.0v 424.745n 0.0v 424.755n 0.95v 429.745n 0.95v 429.755n 0.95v 434.745n 0.95v 434.755n 0.0v 439.745n 0.0v 439.755n 0.95v 444.745n 0.95v 444.755n 0.95v 449.745n 0.95v 449.755n 0.95v 454.745n 0.95v 454.755n 0.95v 459.745n 0.95v 459.755n 0.95v 464.745n 0.95v 464.755n 0.0v 469.745n 0.0v 469.755n 0.0v 474.745n 0.0v 474.755n 0.0v 479.745n 0.0v 479.755n 0.0v 484.745n 0.0v 484.755n 0.0v 489.745n 0.0v 489.755n 0.0v 494.745n 0.0v 494.755n 0.0v 499.745n 0.0v 499.755n 0.95v 504.745n 0.95v 504.755n 0.95v 509.745n 0.95v 509.755n 0.95v 514.745n 0.95v 514.755n 0.95v 519.745n 0.95v 519.755n 0.0v 524.745n 0.0v 524.755n 0.0v 529.745n 0.0v 529.755n 0.0v 534.745n 0.0v 534.755n 0.95v 539.745n 0.95v 539.755n 0.95v 544.745n 0.95v 544.755n 0.95v 549.745n 0.95v 549.755n 0.95v 554.745n 0.95v 554.755n 0.0v 559.745n 0.0v 559.755n 0.95v 564.745n 0.95v 564.755n 0.95v 569.745n 0.95v 569.755n 0.95v 574.745n 0.95v 574.755n 0.95v 579.745n 0.95v 579.755n 0.95v 584.745n 0.95v 584.755n 0.95v 589.745n 0.95v 589.755n 0.95v 594.745n 0.95v 594.755n 0.95v 599.745n 0.95v 599.755n 0.95v 604.745n 0.95v 604.755n 0.95v 609.745n 0.95v 609.755n 0.95v 614.745n 0.95v 614.755n 0.95v 619.745n 0.95v 619.755n 0.95v 624.745n 0.95v 624.755n 0.95v 629.745n 0.95v 629.755n 0.95v 634.745n 0.95v 634.755n 0.95v 639.745n 0.95v 639.755n 0.95v 644.745n 0.95v 644.755n 0.95v 649.745n 0.95v 649.755n 0.95v 654.745n 0.95v 654.755n 0.95v 659.745n 0.95v 659.755n 0.95v 664.745n 0.95v 664.755n 0.95v 669.745n 0.95v 669.755n 0.95v 674.745n 0.95v 674.755n 0.95v 679.745n 0.95v 679.755n 0.95v 684.745n 0.95v 684.755n 0.95v 689.745n 0.95v 689.755n 0.95v 694.745n 0.95v 694.755n 0.95v 699.745n 0.95v 699.755n 0.95v 704.745n 0.95v 704.755n 0.95v 709.745n 0.95v 709.755n 0.95v 714.745n 0.95v 714.755n 0.95v 719.745n 0.95v 719.755n 0.95v 724.745n 0.95v 724.755n 0.95v 729.745n 0.95v 729.755n 0.95v 734.745n 0.95v 734.755n 0.95v 739.745n 0.95v 739.755n 0.95v 744.745n 0.95v 744.755n 0.0v 749.745n 0.0v 749.755n 0.0v 754.745n 0.0v 754.755n 0.0v 759.745n 0.0v 759.755n 0.0v 764.745n 0.0v 764.755n 0.95v 769.745n 0.95v 769.755n 0.95v 774.745n 0.95v 774.755n 0.95v 779.745n 0.95v 779.755n 0.95v 784.745n 0.95v 784.755n 0.95v 789.745n 0.95v 789.755n 0.95v 794.745n 0.95v 794.755n 0.95v 799.745n 0.95v 799.755n 0.95v 804.745n 0.95v 804.755n 0.95v 809.745n 0.95v 809.755n 0.95v 814.745n 0.95v 814.755n 0.95v 819.745n 0.95v 819.755n 0.95v 824.745n 0.95v 824.755n 0.95v 829.745n 0.95v 829.755n 0.95v 834.745n 0.95v 834.755n 0.95v 839.745n 0.95v 839.755n 0.0v 844.745n 0.0v 844.755n 0.0v 849.745n 0.0v 849.755n 0.95v 854.745n 0.95v 854.755n 0.0v 859.745n 0.0v 859.755n 0.0v 864.745n 0.0v 864.755n 0.0v 869.745n 0.0v 869.755n 0.95v 874.745n 0.95v 874.755n 0.95v 879.745n 0.95v 879.755n 0.95v 884.745n 0.95v 884.755n 0.95v 889.745n 0.95v 889.755n 0.0v 894.745n 0.0v 894.755n 0.0v 899.745n 0.0v 899.755n 0.0v 904.745n 0.0v 904.755n 0.0v 909.745n 0.0v 909.755n 0.95v 914.745n 0.95v 914.755n 0.95v 919.745n 0.95v 919.755n 0.0v 924.745n 0.0v 924.755n 0.95v 929.745n 0.95v 929.755n 0.95v 934.745n 0.95v 934.755n 0.95v 939.745n 0.95v 939.755n 0.95v 944.745n 0.95v 944.755n 0.95v 949.745n 0.95v 949.755n 0.0v 954.745n 0.0v 954.755n 0.95v 959.745n 0.95v 959.755n 0.95v 964.745n 0.95v 964.755n 0.95v 969.745n 0.95v 969.755n 0.0v 974.745n 0.0v 974.755n 0.0v 979.745n 0.0v 979.755n 0.0v 984.745n 0.0v 984.755n 0.95v 989.745n 0.95v 989.755n 0.95v 994.745n 0.95v 994.755n 0.95v 999.745n 0.95v 999.755n 0.95v 1004.745n 0.95v 1004.755n 0.95v 1009.745n 0.95v 1009.755n 0.95v 1014.745n 0.95v 1014.755n 0.95v 1019.745n 0.95v 1019.755n 0.95v 1024.745n 0.95v 1024.755n 0.95v )
* (time, data): [(0, 0), (5, 0), (10, 0), (15, 0), (20, 0), (25, 1), (30, 1), (35, 1), (40, 1), (45, 0), (50, 0), (55, 0), (60, 1), (65, 0), (70, 0), (75, 0), (80, 0), (85, 0), (90, 0), (95, 0), (100, 0), (105, 1), (110, 1), (115, 1), (120, 1), (125, 1), (130, 0), (135, 0), (140, 0), (145, 0), (150, 0), (155, 0), (160, 0), (165, 1), (170, 1), (175, 1), (180, 1), (185, 1), (190, 1), (195, 1), (200, 0), (205, 0), (210, 0), (215, 0), (220, 0), (225, 0), (230, 1), (235, 1), (240, 1), (245, 1), (250, 1), (255, 1), (260, 1), (265, 1), (270, 0), (275, 0), (280, 0), (285, 1), (290, 1), (295, 1), (300, 1), (305, 1), (310, 1), (315, 0), (320, 0), (325, 0), (330, 0), (335, 0), (340, 0), (345, 0), (350, 0), (355, 0), (360, 1), (365, 0), (370, 0), (375, 0), (380, 0), (385, 0), (390, 1), (395, 1), (400, 1), (405, 1), (410, 0), (415, 0), (420, 0), (425, 1), (430, 1), (435, 1), (440, 0), (445, 1), (450, 1), (455, 1), (460, 0), (465, 0), (470, 0), (475, 1), (480, 0), (485, 0), (490, 0), (495, 0), (500, 1), (505, 1), (510, 1), (515, 1), (520, 0), (525, 0), (530, 1), (535, 0), (540, 1), (545, 1), (550, 1), (555, 1), (560, 1), (565, 1), (570, 1), (575, 1), (580, 1), (585, 1), (590, 1), (595, 0), (600, 0), (605, 0), (610, 0), (615, 0), (620, 0), (625, 0), (630, 0), (635, 0), (640, 1), (645, 1), (650, 1), (655, 1), (660, 1), (665, 1), (670, 0), (675, 0), (680, 0), (685, 0), (690, 0), (695, 0), (700, 0), (705, 0), (710, 0), (715, 0), (720, 0), (725, 0), (730, 1), (735, 0), (740, 0), (745, 1), (750, 1), (755, 1), (760, 1), (765, 0), (770, 0), (775, 0), (780, 0), (785, 0), (790, 0), (795, 0), (800, 0), (805, 0), (810, 0), (815, 0), (820, 0), (825, 0), (830, 0), (835, 0), (840, 1), (845, 0), (850, 0), (855, 1), (860, 1), (865, 1), (870, 0), (875, 0), (880, 0), (885, 0), (890, 1), (895, 1), (900, 1), (905, 0), (910, 1), (915, 1), (920, 0), (925, 1), (930, 1), (935, 1), (940, 1), (945, 1), (950, 1), (955, 0), (960, 0), (965, 0), (970, 0), (975, 0), (980, 1), (985, 1), (990, 1), (995, 1), (1000, 1), (1005, 1), (1010, 1), (1015, 1), (1020, 1), (1025, 1)]
Vdin0_31  din0_31  0 PWL (0n 0.0v 4.745n 0.0v 4.755n 0.0v 9.745n 0.0v 9.755n 0.0v 14.745n 0.0v 14.755n 0.0v 19.745n 0.0v 19.755n 0.0v 24.745n 0.0v 24.755n 0.95v 29.745n 0.95v 29.755n 0.95v 34.745n 0.95v 34.755n 0.95v 39.745n 0.95v 39.755n 0.95v 44.745n 0.95v 44.755n 0.0v 49.745n 0.0v 49.755n 0.0v 54.745n 0.0v 54.755n 0.0v 59.745n 0.0v 59.755n 0.95v 64.745n 0.95v 64.755n 0.0v 69.745n 0.0v 69.755n 0.0v 74.745n 0.0v 74.755n 0.0v 79.745n 0.0v 79.755n 0.0v 84.745n 0.0v 84.755n 0.0v 89.745n 0.0v 89.755n 0.0v 94.745n 0.0v 94.755n 0.0v 99.745n 0.0v 99.755n 0.0v 104.745n 0.0v 104.755n 0.95v 109.745n 0.95v 109.755n 0.95v 114.745n 0.95v 114.755n 0.95v 119.745n 0.95v 119.755n 0.95v 124.745n 0.95v 124.755n 0.95v 129.745n 0.95v 129.755n 0.0v 134.745n 0.0v 134.755n 0.0v 139.745n 0.0v 139.755n 0.0v 144.745n 0.0v 144.755n 0.0v 149.745n 0.0v 149.755n 0.0v 154.745n 0.0v 154.755n 0.0v 159.745n 0.0v 159.755n 0.0v 164.745n 0.0v 164.755n 0.95v 169.745n 0.95v 169.755n 0.95v 174.745n 0.95v 174.755n 0.95v 179.745n 0.95v 179.755n 0.95v 184.745n 0.95v 184.755n 0.95v 189.745n 0.95v 189.755n 0.95v 194.745n 0.95v 194.755n 0.95v 199.745n 0.95v 199.755n 0.0v 204.745n 0.0v 204.755n 0.0v 209.745n 0.0v 209.755n 0.0v 214.745n 0.0v 214.755n 0.0v 219.745n 0.0v 219.755n 0.0v 224.745n 0.0v 224.755n 0.0v 229.745n 0.0v 229.755n 0.95v 234.745n 0.95v 234.755n 0.95v 239.745n 0.95v 239.755n 0.95v 244.745n 0.95v 244.755n 0.95v 249.745n 0.95v 249.755n 0.95v 254.745n 0.95v 254.755n 0.95v 259.745n 0.95v 259.755n 0.95v 264.745n 0.95v 264.755n 0.95v 269.745n 0.95v 269.755n 0.0v 274.745n 0.0v 274.755n 0.0v 279.745n 0.0v 279.755n 0.0v 284.745n 0.0v 284.755n 0.95v 289.745n 0.95v 289.755n 0.95v 294.745n 0.95v 294.755n 0.95v 299.745n 0.95v 299.755n 0.95v 304.745n 0.95v 304.755n 0.95v 309.745n 0.95v 309.755n 0.95v 314.745n 0.95v 314.755n 0.0v 319.745n 0.0v 319.755n 0.0v 324.745n 0.0v 324.755n 0.0v 329.745n 0.0v 329.755n 0.0v 334.745n 0.0v 334.755n 0.0v 339.745n 0.0v 339.755n 0.0v 344.745n 0.0v 344.755n 0.0v 349.745n 0.0v 349.755n 0.0v 354.745n 0.0v 354.755n 0.0v 359.745n 0.0v 359.755n 0.95v 364.745n 0.95v 364.755n 0.0v 369.745n 0.0v 369.755n 0.0v 374.745n 0.0v 374.755n 0.0v 379.745n 0.0v 379.755n 0.0v 384.745n 0.0v 384.755n 0.0v 389.745n 0.0v 389.755n 0.95v 394.745n 0.95v 394.755n 0.95v 399.745n 0.95v 399.755n 0.95v 404.745n 0.95v 404.755n 0.95v 409.745n 0.95v 409.755n 0.0v 414.745n 0.0v 414.755n 0.0v 419.745n 0.0v 419.755n 0.0v 424.745n 0.0v 424.755n 0.95v 429.745n 0.95v 429.755n 0.95v 434.745n 0.95v 434.755n 0.95v 439.745n 0.95v 439.755n 0.0v 444.745n 0.0v 444.755n 0.95v 449.745n 0.95v 449.755n 0.95v 454.745n 0.95v 454.755n 0.95v 459.745n 0.95v 459.755n 0.0v 464.745n 0.0v 464.755n 0.0v 469.745n 0.0v 469.755n 0.0v 474.745n 0.0v 474.755n 0.95v 479.745n 0.95v 479.755n 0.0v 484.745n 0.0v 484.755n 0.0v 489.745n 0.0v 489.755n 0.0v 494.745n 0.0v 494.755n 0.0v 499.745n 0.0v 499.755n 0.95v 504.745n 0.95v 504.755n 0.95v 509.745n 0.95v 509.755n 0.95v 514.745n 0.95v 514.755n 0.95v 519.745n 0.95v 519.755n 0.0v 524.745n 0.0v 524.755n 0.0v 529.745n 0.0v 529.755n 0.95v 534.745n 0.95v 534.755n 0.0v 539.745n 0.0v 539.755n 0.95v 544.745n 0.95v 544.755n 0.95v 549.745n 0.95v 549.755n 0.95v 554.745n 0.95v 554.755n 0.95v 559.745n 0.95v 559.755n 0.95v 564.745n 0.95v 564.755n 0.95v 569.745n 0.95v 569.755n 0.95v 574.745n 0.95v 574.755n 0.95v 579.745n 0.95v 579.755n 0.95v 584.745n 0.95v 584.755n 0.95v 589.745n 0.95v 589.755n 0.95v 594.745n 0.95v 594.755n 0.0v 599.745n 0.0v 599.755n 0.0v 604.745n 0.0v 604.755n 0.0v 609.745n 0.0v 609.755n 0.0v 614.745n 0.0v 614.755n 0.0v 619.745n 0.0v 619.755n 0.0v 624.745n 0.0v 624.755n 0.0v 629.745n 0.0v 629.755n 0.0v 634.745n 0.0v 634.755n 0.0v 639.745n 0.0v 639.755n 0.95v 644.745n 0.95v 644.755n 0.95v 649.745n 0.95v 649.755n 0.95v 654.745n 0.95v 654.755n 0.95v 659.745n 0.95v 659.755n 0.95v 664.745n 0.95v 664.755n 0.95v 669.745n 0.95v 669.755n 0.0v 674.745n 0.0v 674.755n 0.0v 679.745n 0.0v 679.755n 0.0v 684.745n 0.0v 684.755n 0.0v 689.745n 0.0v 689.755n 0.0v 694.745n 0.0v 694.755n 0.0v 699.745n 0.0v 699.755n 0.0v 704.745n 0.0v 704.755n 0.0v 709.745n 0.0v 709.755n 0.0v 714.745n 0.0v 714.755n 0.0v 719.745n 0.0v 719.755n 0.0v 724.745n 0.0v 724.755n 0.0v 729.745n 0.0v 729.755n 0.95v 734.745n 0.95v 734.755n 0.0v 739.745n 0.0v 739.755n 0.0v 744.745n 0.0v 744.755n 0.95v 749.745n 0.95v 749.755n 0.95v 754.745n 0.95v 754.755n 0.95v 759.745n 0.95v 759.755n 0.95v 764.745n 0.95v 764.755n 0.0v 769.745n 0.0v 769.755n 0.0v 774.745n 0.0v 774.755n 0.0v 779.745n 0.0v 779.755n 0.0v 784.745n 0.0v 784.755n 0.0v 789.745n 0.0v 789.755n 0.0v 794.745n 0.0v 794.755n 0.0v 799.745n 0.0v 799.755n 0.0v 804.745n 0.0v 804.755n 0.0v 809.745n 0.0v 809.755n 0.0v 814.745n 0.0v 814.755n 0.0v 819.745n 0.0v 819.755n 0.0v 824.745n 0.0v 824.755n 0.0v 829.745n 0.0v 829.755n 0.0v 834.745n 0.0v 834.755n 0.0v 839.745n 0.0v 839.755n 0.95v 844.745n 0.95v 844.755n 0.0v 849.745n 0.0v 849.755n 0.0v 854.745n 0.0v 854.755n 0.95v 859.745n 0.95v 859.755n 0.95v 864.745n 0.95v 864.755n 0.95v 869.745n 0.95v 869.755n 0.0v 874.745n 0.0v 874.755n 0.0v 879.745n 0.0v 879.755n 0.0v 884.745n 0.0v 884.755n 0.0v 889.745n 0.0v 889.755n 0.95v 894.745n 0.95v 894.755n 0.95v 899.745n 0.95v 899.755n 0.95v 904.745n 0.95v 904.755n 0.0v 909.745n 0.0v 909.755n 0.95v 914.745n 0.95v 914.755n 0.95v 919.745n 0.95v 919.755n 0.0v 924.745n 0.0v 924.755n 0.95v 929.745n 0.95v 929.755n 0.95v 934.745n 0.95v 934.755n 0.95v 939.745n 0.95v 939.755n 0.95v 944.745n 0.95v 944.755n 0.95v 949.745n 0.95v 949.755n 0.95v 954.745n 0.95v 954.755n 0.0v 959.745n 0.0v 959.755n 0.0v 964.745n 0.0v 964.755n 0.0v 969.745n 0.0v 969.755n 0.0v 974.745n 0.0v 974.755n 0.0v 979.745n 0.0v 979.755n 0.95v 984.745n 0.95v 984.755n 0.95v 989.745n 0.95v 989.755n 0.95v 994.745n 0.95v 994.755n 0.95v 999.745n 0.95v 999.755n 0.95v 1004.745n 0.95v 1004.755n 0.95v 1009.745n 0.95v 1009.755n 0.95v 1014.745n 0.95v 1014.755n 0.95v 1019.745n 0.95v 1019.755n 0.95v 1024.745n 0.95v 1024.755n 0.95v )
* (time, data): [(0, 0), (5, 1), (10, 0), (15, 0), (20, 0), (25, 0), (30, 0), (35, 1), (40, 1), (45, 1), (50, 0), (55, 0), (60, 0), (65, 1), (70, 1), (75, 0), (80, 1), (85, 1), (90, 0), (95, 0), (100, 0), (105, 1), (110, 1), (115, 1), (120, 0), (125, 1), (130, 1), (135, 1), (140, 1), (145, 1), (150, 1), (155, 0), (160, 0), (165, 0), (170, 0), (175, 0), (180, 1), (185, 1), (190, 1), (195, 1), (200, 0), (205, 0), (210, 0), (215, 0), (220, 1), (225, 1), (230, 1), (235, 1), (240, 1), (245, 1), (250, 1), (255, 0), (260, 0), (265, 0), (270, 0), (275, 0), (280, 1), (285, 1), (290, 1), (295, 1), (300, 0), (305, 0), (310, 0), (315, 0), (320, 0), (325, 0), (330, 1), (335, 0), (340, 0), (345, 0), (350, 1), (355, 1), (360, 0), (365, 1), (370, 1), (375, 0), (380, 0), (385, 0), (390, 1), (395, 1), (400, 1), (405, 1), (410, 1), (415, 1), (420, 1), (425, 1), (430, 0), (435, 1), (440, 1), (445, 0), (450, 0), (455, 1), (460, 1), (465, 1), (470, 0), (475, 1), (480, 0), (485, 0), (490, 0), (495, 1), (500, 0), (505, 0), (510, 0), (515, 1), (520, 1), (525, 0), (530, 1), (535, 0), (540, 1), (545, 1), (550, 1), (555, 0), (560, 1), (565, 0), (570, 0), (575, 0), (580, 1), (585, 1), (590, 1), (595, 0), (600, 0), (605, 1), (610, 1), (615, 1), (620, 1), (625, 1), (630, 1), (635, 1), (640, 0), (645, 0), (650, 1), (655, 1), (660, 1), (665, 1), (670, 1), (675, 0), (680, 0), (685, 0), (690, 0), (695, 1), (700, 1), (705, 1), (710, 1), (715, 1), (720, 0), (725, 1), (730, 0), (735, 0), (740, 0), (745, 0), (750, 0), (755, 1), (760, 1), (765, 1), (770, 0), (775, 1), (780, 0), (785, 1), (790, 1), (795, 1), (800, 1), (805, 1), (810, 1), (815, 1), (820, 0), (825, 0), (830, 0), (835, 0), (840, 0), (845, 1), (850, 0), (855, 0), (860, 1), (865, 0), (870, 1), (875, 0), (880, 0), (885, 1), (890, 0), (895, 0), (900, 0), (905, 1), (910, 1), (915, 0), (920, 0), (925, 1), (930, 1), (935, 1), (940, 1), (945, 1), (950, 1), (955, 0), (960, 1), (965, 1), (970, 0), (975, 0), (980, 0), (985, 0), (990, 0), (995, 1), (1000, 1), (1005, 0), (1010, 0), (1015, 0), (1020, 0), (1025, 0)]
Va0_0  a0_0  0 PWL (0n 0.0v 4.745n 0.0v 4.755n 0.95v 9.745n 0.95v 9.755n 0.0v 14.745n 0.0v 14.755n 0.0v 19.745n 0.0v 19.755n 0.0v 24.745n 0.0v 24.755n 0.0v 29.745n 0.0v 29.755n 0.0v 34.745n 0.0v 34.755n 0.95v 39.745n 0.95v 39.755n 0.95v 44.745n 0.95v 44.755n 0.95v 49.745n 0.95v 49.755n 0.0v 54.745n 0.0v 54.755n 0.0v 59.745n 0.0v 59.755n 0.0v 64.745n 0.0v 64.755n 0.95v 69.745n 0.95v 69.755n 0.95v 74.745n 0.95v 74.755n 0.0v 79.745n 0.0v 79.755n 0.95v 84.745n 0.95v 84.755n 0.95v 89.745n 0.95v 89.755n 0.0v 94.745n 0.0v 94.755n 0.0v 99.745n 0.0v 99.755n 0.0v 104.745n 0.0v 104.755n 0.95v 109.745n 0.95v 109.755n 0.95v 114.745n 0.95v 114.755n 0.95v 119.745n 0.95v 119.755n 0.0v 124.745n 0.0v 124.755n 0.95v 129.745n 0.95v 129.755n 0.95v 134.745n 0.95v 134.755n 0.95v 139.745n 0.95v 139.755n 0.95v 144.745n 0.95v 144.755n 0.95v 149.745n 0.95v 149.755n 0.95v 154.745n 0.95v 154.755n 0.0v 159.745n 0.0v 159.755n 0.0v 164.745n 0.0v 164.755n 0.0v 169.745n 0.0v 169.755n 0.0v 174.745n 0.0v 174.755n 0.0v 179.745n 0.0v 179.755n 0.95v 184.745n 0.95v 184.755n 0.95v 189.745n 0.95v 189.755n 0.95v 194.745n 0.95v 194.755n 0.95v 199.745n 0.95v 199.755n 0.0v 204.745n 0.0v 204.755n 0.0v 209.745n 0.0v 209.755n 0.0v 214.745n 0.0v 214.755n 0.0v 219.745n 0.0v 219.755n 0.95v 224.745n 0.95v 224.755n 0.95v 229.745n 0.95v 229.755n 0.95v 234.745n 0.95v 234.755n 0.95v 239.745n 0.95v 239.755n 0.95v 244.745n 0.95v 244.755n 0.95v 249.745n 0.95v 249.755n 0.95v 254.745n 0.95v 254.755n 0.0v 259.745n 0.0v 259.755n 0.0v 264.745n 0.0v 264.755n 0.0v 269.745n 0.0v 269.755n 0.0v 274.745n 0.0v 274.755n 0.0v 279.745n 0.0v 279.755n 0.95v 284.745n 0.95v 284.755n 0.95v 289.745n 0.95v 289.755n 0.95v 294.745n 0.95v 294.755n 0.95v 299.745n 0.95v 299.755n 0.0v 304.745n 0.0v 304.755n 0.0v 309.745n 0.0v 309.755n 0.0v 314.745n 0.0v 314.755n 0.0v 319.745n 0.0v 319.755n 0.0v 324.745n 0.0v 324.755n 0.0v 329.745n 0.0v 329.755n 0.95v 334.745n 0.95v 334.755n 0.0v 339.745n 0.0v 339.755n 0.0v 344.745n 0.0v 344.755n 0.0v 349.745n 0.0v 349.755n 0.95v 354.745n 0.95v 354.755n 0.95v 359.745n 0.95v 359.755n 0.0v 364.745n 0.0v 364.755n 0.95v 369.745n 0.95v 369.755n 0.95v 374.745n 0.95v 374.755n 0.0v 379.745n 0.0v 379.755n 0.0v 384.745n 0.0v 384.755n 0.0v 389.745n 0.0v 389.755n 0.95v 394.745n 0.95v 394.755n 0.95v 399.745n 0.95v 399.755n 0.95v 404.745n 0.95v 404.755n 0.95v 409.745n 0.95v 409.755n 0.95v 414.745n 0.95v 414.755n 0.95v 419.745n 0.95v 419.755n 0.95v 424.745n 0.95v 424.755n 0.95v 429.745n 0.95v 429.755n 0.0v 434.745n 0.0v 434.755n 0.95v 439.745n 0.95v 439.755n 0.95v 444.745n 0.95v 444.755n 0.0v 449.745n 0.0v 449.755n 0.0v 454.745n 0.0v 454.755n 0.95v 459.745n 0.95v 459.755n 0.95v 464.745n 0.95v 464.755n 0.95v 469.745n 0.95v 469.755n 0.0v 474.745n 0.0v 474.755n 0.95v 479.745n 0.95v 479.755n 0.0v 484.745n 0.0v 484.755n 0.0v 489.745n 0.0v 489.755n 0.0v 494.745n 0.0v 494.755n 0.95v 499.745n 0.95v 499.755n 0.0v 504.745n 0.0v 504.755n 0.0v 509.745n 0.0v 509.755n 0.0v 514.745n 0.0v 514.755n 0.95v 519.745n 0.95v 519.755n 0.95v 524.745n 0.95v 524.755n 0.0v 529.745n 0.0v 529.755n 0.95v 534.745n 0.95v 534.755n 0.0v 539.745n 0.0v 539.755n 0.95v 544.745n 0.95v 544.755n 0.95v 549.745n 0.95v 549.755n 0.95v 554.745n 0.95v 554.755n 0.0v 559.745n 0.0v 559.755n 0.95v 564.745n 0.95v 564.755n 0.0v 569.745n 0.0v 569.755n 0.0v 574.745n 0.0v 574.755n 0.0v 579.745n 0.0v 579.755n 0.95v 584.745n 0.95v 584.755n 0.95v 589.745n 0.95v 589.755n 0.95v 594.745n 0.95v 594.755n 0.0v 599.745n 0.0v 599.755n 0.0v 604.745n 0.0v 604.755n 0.95v 609.745n 0.95v 609.755n 0.95v 614.745n 0.95v 614.755n 0.95v 619.745n 0.95v 619.755n 0.95v 624.745n 0.95v 624.755n 0.95v 629.745n 0.95v 629.755n 0.95v 634.745n 0.95v 634.755n 0.95v 639.745n 0.95v 639.755n 0.0v 644.745n 0.0v 644.755n 0.0v 649.745n 0.0v 649.755n 0.95v 654.745n 0.95v 654.755n 0.95v 659.745n 0.95v 659.755n 0.95v 664.745n 0.95v 664.755n 0.95v 669.745n 0.95v 669.755n 0.95v 674.745n 0.95v 674.755n 0.0v 679.745n 0.0v 679.755n 0.0v 684.745n 0.0v 684.755n 0.0v 689.745n 0.0v 689.755n 0.0v 694.745n 0.0v 694.755n 0.95v 699.745n 0.95v 699.755n 0.95v 704.745n 0.95v 704.755n 0.95v 709.745n 0.95v 709.755n 0.95v 714.745n 0.95v 714.755n 0.95v 719.745n 0.95v 719.755n 0.0v 724.745n 0.0v 724.755n 0.95v 729.745n 0.95v 729.755n 0.0v 734.745n 0.0v 734.755n 0.0v 739.745n 0.0v 739.755n 0.0v 744.745n 0.0v 744.755n 0.0v 749.745n 0.0v 749.755n 0.0v 754.745n 0.0v 754.755n 0.95v 759.745n 0.95v 759.755n 0.95v 764.745n 0.95v 764.755n 0.95v 769.745n 0.95v 769.755n 0.0v 774.745n 0.0v 774.755n 0.95v 779.745n 0.95v 779.755n 0.0v 784.745n 0.0v 784.755n 0.95v 789.745n 0.95v 789.755n 0.95v 794.745n 0.95v 794.755n 0.95v 799.745n 0.95v 799.755n 0.95v 804.745n 0.95v 804.755n 0.95v 809.745n 0.95v 809.755n 0.95v 814.745n 0.95v 814.755n 0.95v 819.745n 0.95v 819.755n 0.0v 824.745n 0.0v 824.755n 0.0v 829.745n 0.0v 829.755n 0.0v 834.745n 0.0v 834.755n 0.0v 839.745n 0.0v 839.755n 0.0v 844.745n 0.0v 844.755n 0.95v 849.745n 0.95v 849.755n 0.0v 854.745n 0.0v 854.755n 0.0v 859.745n 0.0v 859.755n 0.95v 864.745n 0.95v 864.755n 0.0v 869.745n 0.0v 869.755n 0.95v 874.745n 0.95v 874.755n 0.0v 879.745n 0.0v 879.755n 0.0v 884.745n 0.0v 884.755n 0.95v 889.745n 0.95v 889.755n 0.0v 894.745n 0.0v 894.755n 0.0v 899.745n 0.0v 899.755n 0.0v 904.745n 0.0v 904.755n 0.95v 909.745n 0.95v 909.755n 0.95v 914.745n 0.95v 914.755n 0.0v 919.745n 0.0v 919.755n 0.0v 924.745n 0.0v 924.755n 0.95v 929.745n 0.95v 929.755n 0.95v 934.745n 0.95v 934.755n 0.95v 939.745n 0.95v 939.755n 0.95v 944.745n 0.95v 944.755n 0.95v 949.745n 0.95v 949.755n 0.95v 954.745n 0.95v 954.755n 0.0v 959.745n 0.0v 959.755n 0.95v 964.745n 0.95v 964.755n 0.95v 969.745n 0.95v 969.755n 0.0v 974.745n 0.0v 974.755n 0.0v 979.745n 0.0v 979.755n 0.0v 984.745n 0.0v 984.755n 0.0v 989.745n 0.0v 989.755n 0.0v 994.745n 0.0v 994.755n 0.95v 999.745n 0.95v 999.755n 0.95v 1004.745n 0.95v 1004.755n 0.0v 1009.745n 0.0v 1009.755n 0.0v 1014.745n 0.0v 1014.755n 0.0v 1019.745n 0.0v 1019.755n 0.0v 1024.745n 0.0v 1024.755n 0.0v )
* (time, data): [(0, 0), (5, 0), (10, 0), (15, 1), (20, 0), (25, 1), (30, 1), (35, 1), (40, 0), (45, 0), (50, 1), (55, 1), (60, 1), (65, 0), (70, 0), (75, 1), (80, 1), (85, 1), (90, 1), (95, 1), (100, 1), (105, 0), (110, 0), (115, 0), (120, 1), (125, 0), (130, 1), (135, 1), (140, 1), (145, 1), (150, 1), (155, 1), (160, 0), (165, 1), (170, 0), (175, 1), (180, 1), (185, 1), (190, 1), (195, 1), (200, 0), (205, 0), (210, 0), (215, 0), (220, 0), (225, 0), (230, 0), (235, 1), (240, 1), (245, 1), (250, 1), (255, 1), (260, 1), (265, 1), (270, 1), (275, 1), (280, 1), (285, 0), (290, 0), (295, 1), (300, 0), (305, 0), (310, 0), (315, 1), (320, 1), (325, 1), (330, 0), (335, 1), (340, 0), (345, 0), (350, 0), (355, 1), (360, 1), (365, 1), (370, 0), (375, 0), (380, 0), (385, 1), (390, 1), (395, 1), (400, 0), (405, 0), (410, 0), (415, 0), (420, 0), (425, 0), (430, 1), (435, 0), (440, 0), (445, 1), (450, 1), (455, 0), (460, 1), (465, 1), (470, 1), (475, 0), (480, 0), (485, 1), (490, 1), (495, 0), (500, 1), (505, 0), (510, 0), (515, 1), (520, 1), (525, 1), (530, 0), (535, 1), (540, 1), (545, 1), (550, 1), (555, 0), (560, 0), (565, 1), (570, 1), (575, 1), (580, 1), (585, 1), (590, 1), (595, 1), (600, 1), (605, 1), (610, 0), (615, 1), (620, 1), (625, 1), (630, 0), (635, 0), (640, 1), (645, 1), (650, 0), (655, 0), (660, 0), (665, 0), (670, 1), (675, 0), (680, 1), (685, 1), (690, 1), (695, 1), (700, 1), (705, 1), (710, 0), (715, 1), (720, 0), (725, 1), (730, 1), (735, 0), (740, 1), (745, 1), (750, 1), (755, 1), (760, 1), (765, 1), (770, 0), (775, 1), (780, 0), (785, 1), (790, 0), (795, 0), (800, 1), (805, 0), (810, 1), (815, 1), (820, 0), (825, 1), (830, 1), (835, 1), (840, 1), (845, 0), (850, 1), (855, 0), (860, 0), (865, 0), (870, 1), (875, 0), (880, 1), (885, 1), (890, 0), (895, 0), (900, 0), (905, 1), (910, 0), (915, 0), (920, 0), (925, 1), (930, 0), (935, 1), (940, 0), (945, 0), (950, 0), (955, 0), (960, 1), (965, 1), (970, 0), (975, 0), (980, 0), (985, 0), (990, 1), (995, 0), (1000, 0), (1005, 1), (1010, 1), (1015, 1), (1020, 1), (1025, 1)]
Va0_1  a0_1  0 PWL (0n 0.0v 4.745n 0.0v 4.755n 0.0v 9.745n 0.0v 9.755n 0.0v 14.745n 0.0v 14.755n 0.95v 19.745n 0.95v 19.755n 0.0v 24.745n 0.0v 24.755n 0.95v 29.745n 0.95v 29.755n 0.95v 34.745n 0.95v 34.755n 0.95v 39.745n 0.95v 39.755n 0.0v 44.745n 0.0v 44.755n 0.0v 49.745n 0.0v 49.755n 0.95v 54.745n 0.95v 54.755n 0.95v 59.745n 0.95v 59.755n 0.95v 64.745n 0.95v 64.755n 0.0v 69.745n 0.0v 69.755n 0.0v 74.745n 0.0v 74.755n 0.95v 79.745n 0.95v 79.755n 0.95v 84.745n 0.95v 84.755n 0.95v 89.745n 0.95v 89.755n 0.95v 94.745n 0.95v 94.755n 0.95v 99.745n 0.95v 99.755n 0.95v 104.745n 0.95v 104.755n 0.0v 109.745n 0.0v 109.755n 0.0v 114.745n 0.0v 114.755n 0.0v 119.745n 0.0v 119.755n 0.95v 124.745n 0.95v 124.755n 0.0v 129.745n 0.0v 129.755n 0.95v 134.745n 0.95v 134.755n 0.95v 139.745n 0.95v 139.755n 0.95v 144.745n 0.95v 144.755n 0.95v 149.745n 0.95v 149.755n 0.95v 154.745n 0.95v 154.755n 0.95v 159.745n 0.95v 159.755n 0.0v 164.745n 0.0v 164.755n 0.95v 169.745n 0.95v 169.755n 0.0v 174.745n 0.0v 174.755n 0.95v 179.745n 0.95v 179.755n 0.95v 184.745n 0.95v 184.755n 0.95v 189.745n 0.95v 189.755n 0.95v 194.745n 0.95v 194.755n 0.95v 199.745n 0.95v 199.755n 0.0v 204.745n 0.0v 204.755n 0.0v 209.745n 0.0v 209.755n 0.0v 214.745n 0.0v 214.755n 0.0v 219.745n 0.0v 219.755n 0.0v 224.745n 0.0v 224.755n 0.0v 229.745n 0.0v 229.755n 0.0v 234.745n 0.0v 234.755n 0.95v 239.745n 0.95v 239.755n 0.95v 244.745n 0.95v 244.755n 0.95v 249.745n 0.95v 249.755n 0.95v 254.745n 0.95v 254.755n 0.95v 259.745n 0.95v 259.755n 0.95v 264.745n 0.95v 264.755n 0.95v 269.745n 0.95v 269.755n 0.95v 274.745n 0.95v 274.755n 0.95v 279.745n 0.95v 279.755n 0.95v 284.745n 0.95v 284.755n 0.0v 289.745n 0.0v 289.755n 0.0v 294.745n 0.0v 294.755n 0.95v 299.745n 0.95v 299.755n 0.0v 304.745n 0.0v 304.755n 0.0v 309.745n 0.0v 309.755n 0.0v 314.745n 0.0v 314.755n 0.95v 319.745n 0.95v 319.755n 0.95v 324.745n 0.95v 324.755n 0.95v 329.745n 0.95v 329.755n 0.0v 334.745n 0.0v 334.755n 0.95v 339.745n 0.95v 339.755n 0.0v 344.745n 0.0v 344.755n 0.0v 349.745n 0.0v 349.755n 0.0v 354.745n 0.0v 354.755n 0.95v 359.745n 0.95v 359.755n 0.95v 364.745n 0.95v 364.755n 0.95v 369.745n 0.95v 369.755n 0.0v 374.745n 0.0v 374.755n 0.0v 379.745n 0.0v 379.755n 0.0v 384.745n 0.0v 384.755n 0.95v 389.745n 0.95v 389.755n 0.95v 394.745n 0.95v 394.755n 0.95v 399.745n 0.95v 399.755n 0.0v 404.745n 0.0v 404.755n 0.0v 409.745n 0.0v 409.755n 0.0v 414.745n 0.0v 414.755n 0.0v 419.745n 0.0v 419.755n 0.0v 424.745n 0.0v 424.755n 0.0v 429.745n 0.0v 429.755n 0.95v 434.745n 0.95v 434.755n 0.0v 439.745n 0.0v 439.755n 0.0v 444.745n 0.0v 444.755n 0.95v 449.745n 0.95v 449.755n 0.95v 454.745n 0.95v 454.755n 0.0v 459.745n 0.0v 459.755n 0.95v 464.745n 0.95v 464.755n 0.95v 469.745n 0.95v 469.755n 0.95v 474.745n 0.95v 474.755n 0.0v 479.745n 0.0v 479.755n 0.0v 484.745n 0.0v 484.755n 0.95v 489.745n 0.95v 489.755n 0.95v 494.745n 0.95v 494.755n 0.0v 499.745n 0.0v 499.755n 0.95v 504.745n 0.95v 504.755n 0.0v 509.745n 0.0v 509.755n 0.0v 514.745n 0.0v 514.755n 0.95v 519.745n 0.95v 519.755n 0.95v 524.745n 0.95v 524.755n 0.95v 529.745n 0.95v 529.755n 0.0v 534.745n 0.0v 534.755n 0.95v 539.745n 0.95v 539.755n 0.95v 544.745n 0.95v 544.755n 0.95v 549.745n 0.95v 549.755n 0.95v 554.745n 0.95v 554.755n 0.0v 559.745n 0.0v 559.755n 0.0v 564.745n 0.0v 564.755n 0.95v 569.745n 0.95v 569.755n 0.95v 574.745n 0.95v 574.755n 0.95v 579.745n 0.95v 579.755n 0.95v 584.745n 0.95v 584.755n 0.95v 589.745n 0.95v 589.755n 0.95v 594.745n 0.95v 594.755n 0.95v 599.745n 0.95v 599.755n 0.95v 604.745n 0.95v 604.755n 0.95v 609.745n 0.95v 609.755n 0.0v 614.745n 0.0v 614.755n 0.95v 619.745n 0.95v 619.755n 0.95v 624.745n 0.95v 624.755n 0.95v 629.745n 0.95v 629.755n 0.0v 634.745n 0.0v 634.755n 0.0v 639.745n 0.0v 639.755n 0.95v 644.745n 0.95v 644.755n 0.95v 649.745n 0.95v 649.755n 0.0v 654.745n 0.0v 654.755n 0.0v 659.745n 0.0v 659.755n 0.0v 664.745n 0.0v 664.755n 0.0v 669.745n 0.0v 669.755n 0.95v 674.745n 0.95v 674.755n 0.0v 679.745n 0.0v 679.755n 0.95v 684.745n 0.95v 684.755n 0.95v 689.745n 0.95v 689.755n 0.95v 694.745n 0.95v 694.755n 0.95v 699.745n 0.95v 699.755n 0.95v 704.745n 0.95v 704.755n 0.95v 709.745n 0.95v 709.755n 0.0v 714.745n 0.0v 714.755n 0.95v 719.745n 0.95v 719.755n 0.0v 724.745n 0.0v 724.755n 0.95v 729.745n 0.95v 729.755n 0.95v 734.745n 0.95v 734.755n 0.0v 739.745n 0.0v 739.755n 0.95v 744.745n 0.95v 744.755n 0.95v 749.745n 0.95v 749.755n 0.95v 754.745n 0.95v 754.755n 0.95v 759.745n 0.95v 759.755n 0.95v 764.745n 0.95v 764.755n 0.95v 769.745n 0.95v 769.755n 0.0v 774.745n 0.0v 774.755n 0.95v 779.745n 0.95v 779.755n 0.0v 784.745n 0.0v 784.755n 0.95v 789.745n 0.95v 789.755n 0.0v 794.745n 0.0v 794.755n 0.0v 799.745n 0.0v 799.755n 0.95v 804.745n 0.95v 804.755n 0.0v 809.745n 0.0v 809.755n 0.95v 814.745n 0.95v 814.755n 0.95v 819.745n 0.95v 819.755n 0.0v 824.745n 0.0v 824.755n 0.95v 829.745n 0.95v 829.755n 0.95v 834.745n 0.95v 834.755n 0.95v 839.745n 0.95v 839.755n 0.95v 844.745n 0.95v 844.755n 0.0v 849.745n 0.0v 849.755n 0.95v 854.745n 0.95v 854.755n 0.0v 859.745n 0.0v 859.755n 0.0v 864.745n 0.0v 864.755n 0.0v 869.745n 0.0v 869.755n 0.95v 874.745n 0.95v 874.755n 0.0v 879.745n 0.0v 879.755n 0.95v 884.745n 0.95v 884.755n 0.95v 889.745n 0.95v 889.755n 0.0v 894.745n 0.0v 894.755n 0.0v 899.745n 0.0v 899.755n 0.0v 904.745n 0.0v 904.755n 0.95v 909.745n 0.95v 909.755n 0.0v 914.745n 0.0v 914.755n 0.0v 919.745n 0.0v 919.755n 0.0v 924.745n 0.0v 924.755n 0.95v 929.745n 0.95v 929.755n 0.0v 934.745n 0.0v 934.755n 0.95v 939.745n 0.95v 939.755n 0.0v 944.745n 0.0v 944.755n 0.0v 949.745n 0.0v 949.755n 0.0v 954.745n 0.0v 954.755n 0.0v 959.745n 0.0v 959.755n 0.95v 964.745n 0.95v 964.755n 0.95v 969.745n 0.95v 969.755n 0.0v 974.745n 0.0v 974.755n 0.0v 979.745n 0.0v 979.755n 0.0v 984.745n 0.0v 984.755n 0.0v 989.745n 0.0v 989.755n 0.95v 994.745n 0.95v 994.755n 0.0v 999.745n 0.0v 999.755n 0.0v 1004.745n 0.0v 1004.755n 0.95v 1009.745n 0.95v 1009.755n 0.95v 1014.745n 0.95v 1014.755n 0.95v 1019.745n 0.95v 1019.755n 0.95v 1024.745n 0.95v 1024.755n 0.95v )
* (time, data): [(0, 0), (5, 1), (10, 0), (15, 1), (20, 0), (25, 0), (30, 0), (35, 0), (40, 0), (45, 0), (50, 1), (55, 0), (60, 1), (65, 0), (70, 0), (75, 1), (80, 0), (85, 0), (90, 0), (95, 1), (100, 1), (105, 0), (110, 0), (115, 0), (120, 1), (125, 1), (130, 0), (135, 0), (140, 0), (145, 0), (150, 0), (155, 1), (160, 0), (165, 0), (170, 0), (175, 1), (180, 0), (185, 0), (190, 0), (195, 0), (200, 1), (205, 1), (210, 1), (215, 1), (220, 1), (225, 1), (230, 1), (235, 0), (240, 0), (245, 0), (250, 0), (255, 0), (260, 1), (265, 1), (270, 0), (275, 0), (280, 0), (285, 0), (290, 0), (295, 0), (300, 1), (305, 1), (310, 1), (315, 0), (320, 0), (325, 0), (330, 1), (335, 0), (340, 0), (345, 1), (350, 1), (355, 0), (360, 1), (365, 0), (370, 1), (375, 1), (380, 0), (385, 0), (390, 0), (395, 0), (400, 0), (405, 0), (410, 1), (415, 1), (420, 1), (425, 0), (430, 0), (435, 0), (440, 0), (445, 1), (450, 1), (455, 1), (460, 0), (465, 0), (470, 1), (475, 0), (480, 1), (485, 0), (490, 0), (495, 1), (500, 1), (505, 0), (510, 0), (515, 0), (520, 0), (525, 1), (530, 0), (535, 0), (540, 0), (545, 0), (550, 0), (555, 1), (560, 1), (565, 1), (570, 1), (575, 1), (580, 0), (585, 0), (590, 0), (595, 0), (600, 0), (605, 0), (610, 0), (615, 0), (620, 0), (625, 0), (630, 0), (635, 0), (640, 0), (645, 0), (650, 1), (655, 1), (660, 0), (665, 0), (670, 0), (675, 0), (680, 0), (685, 0), (690, 0), (695, 0), (700, 0), (705, 0), (710, 0), (715, 0), (720, 0), (725, 0), (730, 0), (735, 0), (740, 0), (745, 0), (750, 0), (755, 0), (760, 0), (765, 0), (770, 0), (775, 0), (780, 0), (785, 0), (790, 1), (795, 1), (800, 0), (805, 1), (810, 0), (815, 0), (820, 0), (825, 0), (830, 0), (835, 0), (840, 0), (845, 0), (850, 1), (855, 1), (860, 1), (865, 0), (870, 0), (875, 0), (880, 1), (885, 0), (890, 1), (895, 1), (900, 1), (905, 0), (910, 0), (915, 1), (920, 0), (925, 0), (930, 1), (935, 0), (940, 0), (945, 0), (950, 0), (955, 1), (960, 0), (965, 0), (970, 0), (975, 1), (980, 1), (985, 0), (990, 1), (995, 1), (1000, 1), (1005, 0), (1010, 0), (1015, 0), (1020, 0), (1025, 0)]
Va0_2  a0_2  0 PWL (0n 0.0v 4.745n 0.0v 4.755n 0.95v 9.745n 0.95v 9.755n 0.0v 14.745n 0.0v 14.755n 0.95v 19.745n 0.95v 19.755n 0.0v 24.745n 0.0v 24.755n 0.0v 29.745n 0.0v 29.755n 0.0v 34.745n 0.0v 34.755n 0.0v 39.745n 0.0v 39.755n 0.0v 44.745n 0.0v 44.755n 0.0v 49.745n 0.0v 49.755n 0.95v 54.745n 0.95v 54.755n 0.0v 59.745n 0.0v 59.755n 0.95v 64.745n 0.95v 64.755n 0.0v 69.745n 0.0v 69.755n 0.0v 74.745n 0.0v 74.755n 0.95v 79.745n 0.95v 79.755n 0.0v 84.745n 0.0v 84.755n 0.0v 89.745n 0.0v 89.755n 0.0v 94.745n 0.0v 94.755n 0.95v 99.745n 0.95v 99.755n 0.95v 104.745n 0.95v 104.755n 0.0v 109.745n 0.0v 109.755n 0.0v 114.745n 0.0v 114.755n 0.0v 119.745n 0.0v 119.755n 0.95v 124.745n 0.95v 124.755n 0.95v 129.745n 0.95v 129.755n 0.0v 134.745n 0.0v 134.755n 0.0v 139.745n 0.0v 139.755n 0.0v 144.745n 0.0v 144.755n 0.0v 149.745n 0.0v 149.755n 0.0v 154.745n 0.0v 154.755n 0.95v 159.745n 0.95v 159.755n 0.0v 164.745n 0.0v 164.755n 0.0v 169.745n 0.0v 169.755n 0.0v 174.745n 0.0v 174.755n 0.95v 179.745n 0.95v 179.755n 0.0v 184.745n 0.0v 184.755n 0.0v 189.745n 0.0v 189.755n 0.0v 194.745n 0.0v 194.755n 0.0v 199.745n 0.0v 199.755n 0.95v 204.745n 0.95v 204.755n 0.95v 209.745n 0.95v 209.755n 0.95v 214.745n 0.95v 214.755n 0.95v 219.745n 0.95v 219.755n 0.95v 224.745n 0.95v 224.755n 0.95v 229.745n 0.95v 229.755n 0.95v 234.745n 0.95v 234.755n 0.0v 239.745n 0.0v 239.755n 0.0v 244.745n 0.0v 244.755n 0.0v 249.745n 0.0v 249.755n 0.0v 254.745n 0.0v 254.755n 0.0v 259.745n 0.0v 259.755n 0.95v 264.745n 0.95v 264.755n 0.95v 269.745n 0.95v 269.755n 0.0v 274.745n 0.0v 274.755n 0.0v 279.745n 0.0v 279.755n 0.0v 284.745n 0.0v 284.755n 0.0v 289.745n 0.0v 289.755n 0.0v 294.745n 0.0v 294.755n 0.0v 299.745n 0.0v 299.755n 0.95v 304.745n 0.95v 304.755n 0.95v 309.745n 0.95v 309.755n 0.95v 314.745n 0.95v 314.755n 0.0v 319.745n 0.0v 319.755n 0.0v 324.745n 0.0v 324.755n 0.0v 329.745n 0.0v 329.755n 0.95v 334.745n 0.95v 334.755n 0.0v 339.745n 0.0v 339.755n 0.0v 344.745n 0.0v 344.755n 0.95v 349.745n 0.95v 349.755n 0.95v 354.745n 0.95v 354.755n 0.0v 359.745n 0.0v 359.755n 0.95v 364.745n 0.95v 364.755n 0.0v 369.745n 0.0v 369.755n 0.95v 374.745n 0.95v 374.755n 0.95v 379.745n 0.95v 379.755n 0.0v 384.745n 0.0v 384.755n 0.0v 389.745n 0.0v 389.755n 0.0v 394.745n 0.0v 394.755n 0.0v 399.745n 0.0v 399.755n 0.0v 404.745n 0.0v 404.755n 0.0v 409.745n 0.0v 409.755n 0.95v 414.745n 0.95v 414.755n 0.95v 419.745n 0.95v 419.755n 0.95v 424.745n 0.95v 424.755n 0.0v 429.745n 0.0v 429.755n 0.0v 434.745n 0.0v 434.755n 0.0v 439.745n 0.0v 439.755n 0.0v 444.745n 0.0v 444.755n 0.95v 449.745n 0.95v 449.755n 0.95v 454.745n 0.95v 454.755n 0.95v 459.745n 0.95v 459.755n 0.0v 464.745n 0.0v 464.755n 0.0v 469.745n 0.0v 469.755n 0.95v 474.745n 0.95v 474.755n 0.0v 479.745n 0.0v 479.755n 0.95v 484.745n 0.95v 484.755n 0.0v 489.745n 0.0v 489.755n 0.0v 494.745n 0.0v 494.755n 0.95v 499.745n 0.95v 499.755n 0.95v 504.745n 0.95v 504.755n 0.0v 509.745n 0.0v 509.755n 0.0v 514.745n 0.0v 514.755n 0.0v 519.745n 0.0v 519.755n 0.0v 524.745n 0.0v 524.755n 0.95v 529.745n 0.95v 529.755n 0.0v 534.745n 0.0v 534.755n 0.0v 539.745n 0.0v 539.755n 0.0v 544.745n 0.0v 544.755n 0.0v 549.745n 0.0v 549.755n 0.0v 554.745n 0.0v 554.755n 0.95v 559.745n 0.95v 559.755n 0.95v 564.745n 0.95v 564.755n 0.95v 569.745n 0.95v 569.755n 0.95v 574.745n 0.95v 574.755n 0.95v 579.745n 0.95v 579.755n 0.0v 584.745n 0.0v 584.755n 0.0v 589.745n 0.0v 589.755n 0.0v 594.745n 0.0v 594.755n 0.0v 599.745n 0.0v 599.755n 0.0v 604.745n 0.0v 604.755n 0.0v 609.745n 0.0v 609.755n 0.0v 614.745n 0.0v 614.755n 0.0v 619.745n 0.0v 619.755n 0.0v 624.745n 0.0v 624.755n 0.0v 629.745n 0.0v 629.755n 0.0v 634.745n 0.0v 634.755n 0.0v 639.745n 0.0v 639.755n 0.0v 644.745n 0.0v 644.755n 0.0v 649.745n 0.0v 649.755n 0.95v 654.745n 0.95v 654.755n 0.95v 659.745n 0.95v 659.755n 0.0v 664.745n 0.0v 664.755n 0.0v 669.745n 0.0v 669.755n 0.0v 674.745n 0.0v 674.755n 0.0v 679.745n 0.0v 679.755n 0.0v 684.745n 0.0v 684.755n 0.0v 689.745n 0.0v 689.755n 0.0v 694.745n 0.0v 694.755n 0.0v 699.745n 0.0v 699.755n 0.0v 704.745n 0.0v 704.755n 0.0v 709.745n 0.0v 709.755n 0.0v 714.745n 0.0v 714.755n 0.0v 719.745n 0.0v 719.755n 0.0v 724.745n 0.0v 724.755n 0.0v 729.745n 0.0v 729.755n 0.0v 734.745n 0.0v 734.755n 0.0v 739.745n 0.0v 739.755n 0.0v 744.745n 0.0v 744.755n 0.0v 749.745n 0.0v 749.755n 0.0v 754.745n 0.0v 754.755n 0.0v 759.745n 0.0v 759.755n 0.0v 764.745n 0.0v 764.755n 0.0v 769.745n 0.0v 769.755n 0.0v 774.745n 0.0v 774.755n 0.0v 779.745n 0.0v 779.755n 0.0v 784.745n 0.0v 784.755n 0.0v 789.745n 0.0v 789.755n 0.95v 794.745n 0.95v 794.755n 0.95v 799.745n 0.95v 799.755n 0.0v 804.745n 0.0v 804.755n 0.95v 809.745n 0.95v 809.755n 0.0v 814.745n 0.0v 814.755n 0.0v 819.745n 0.0v 819.755n 0.0v 824.745n 0.0v 824.755n 0.0v 829.745n 0.0v 829.755n 0.0v 834.745n 0.0v 834.755n 0.0v 839.745n 0.0v 839.755n 0.0v 844.745n 0.0v 844.755n 0.0v 849.745n 0.0v 849.755n 0.95v 854.745n 0.95v 854.755n 0.95v 859.745n 0.95v 859.755n 0.95v 864.745n 0.95v 864.755n 0.0v 869.745n 0.0v 869.755n 0.0v 874.745n 0.0v 874.755n 0.0v 879.745n 0.0v 879.755n 0.95v 884.745n 0.95v 884.755n 0.0v 889.745n 0.0v 889.755n 0.95v 894.745n 0.95v 894.755n 0.95v 899.745n 0.95v 899.755n 0.95v 904.745n 0.95v 904.755n 0.0v 909.745n 0.0v 909.755n 0.0v 914.745n 0.0v 914.755n 0.95v 919.745n 0.95v 919.755n 0.0v 924.745n 0.0v 924.755n 0.0v 929.745n 0.0v 929.755n 0.95v 934.745n 0.95v 934.755n 0.0v 939.745n 0.0v 939.755n 0.0v 944.745n 0.0v 944.755n 0.0v 949.745n 0.0v 949.755n 0.0v 954.745n 0.0v 954.755n 0.95v 959.745n 0.95v 959.755n 0.0v 964.745n 0.0v 964.755n 0.0v 969.745n 0.0v 969.755n 0.0v 974.745n 0.0v 974.755n 0.95v 979.745n 0.95v 979.755n 0.95v 984.745n 0.95v 984.755n 0.0v 989.745n 0.0v 989.755n 0.95v 994.745n 0.95v 994.755n 0.95v 999.745n 0.95v 999.755n 0.95v 1004.745n 0.95v 1004.755n 0.0v 1009.745n 0.0v 1009.755n 0.0v 1014.745n 0.0v 1014.755n 0.0v 1019.745n 0.0v 1019.755n 0.0v 1024.745n 0.0v 1024.755n 0.0v )
* (time, data): [(0, 0), (5, 1), (10, 0), (15, 1), (20, 0), (25, 0), (30, 0), (35, 0), (40, 0), (45, 0), (50, 1), (55, 0), (60, 1), (65, 0), (70, 0), (75, 1), (80, 1), (85, 0), (90, 0), (95, 1), (100, 1), (105, 0), (110, 0), (115, 0), (120, 1), (125, 1), (130, 1), (135, 1), (140, 0), (145, 1), (150, 1), (155, 1), (160, 0), (165, 0), (170, 0), (175, 1), (180, 1), (185, 1), (190, 1), (195, 0), (200, 1), (205, 1), (210, 1), (215, 1), (220, 1), (225, 1), (230, 1), (235, 0), (240, 0), (245, 0), (250, 0), (255, 0), (260, 1), (265, 1), (270, 0), (275, 0), (280, 0), (285, 0), (290, 0), (295, 1), (300, 1), (305, 1), (310, 1), (315, 0), (320, 0), (325, 0), (330, 1), (335, 0), (340, 0), (345, 1), (350, 1), (355, 0), (360, 1), (365, 0), (370, 1), (375, 1), (380, 0), (385, 0), (390, 0), (395, 1), (400, 0), (405, 0), (410, 1), (415, 1), (420, 1), (425, 0), (430, 0), (435, 0), (440, 0), (445, 1), (450, 1), (455, 1), (460, 0), (465, 0), (470, 1), (475, 0), (480, 1), (485, 0), (490, 0), (495, 1), (500, 1), (505, 0), (510, 0), (515, 0), (520, 1), (525, 1), (530, 0), (535, 0), (540, 1), (545, 0), (550, 0), (555, 1), (560, 1), (565, 1), (570, 1), (575, 1), (580, 0), (585, 0), (590, 1), (595, 0), (600, 0), (605, 0), (610, 0), (615, 1), (620, 1), (625, 0), (630, 0), (635, 0), (640, 0), (645, 0), (650, 1), (655, 1), (660, 0), (665, 0), (670, 1), (675, 0), (680, 0), (685, 0), (690, 0), (695, 1), (700, 1), (705, 1), (710, 0), (715, 0), (720, 0), (725, 1), (730, 0), (735, 0), (740, 0), (745, 0), (750, 0), (755, 0), (760, 0), (765, 0), (770, 0), (775, 0), (780, 0), (785, 0), (790, 1), (795, 1), (800, 0), (805, 1), (810, 1), (815, 1), (820, 0), (825, 0), (830, 0), (835, 0), (840, 0), (845, 0), (850, 1), (855, 1), (860, 1), (865, 0), (870, 1), (875, 0), (880, 1), (885, 1), (890, 1), (895, 1), (900, 1), (905, 1), (910, 0), (915, 1), (920, 0), (925, 0), (930, 1), (935, 0), (940, 0), (945, 0), (950, 0), (955, 1), (960, 1), (965, 0), (970, 0), (975, 1), (980, 1), (985, 0), (990, 1), (995, 1), (1000, 1), (1005, 0), (1010, 0), (1015, 0), (1020, 0), (1025, 0)]
Va0_3  a0_3  0 PWL (0n 0.0v 4.745n 0.0v 4.755n 0.95v 9.745n 0.95v 9.755n 0.0v 14.745n 0.0v 14.755n 0.95v 19.745n 0.95v 19.755n 0.0v 24.745n 0.0v 24.755n 0.0v 29.745n 0.0v 29.755n 0.0v 34.745n 0.0v 34.755n 0.0v 39.745n 0.0v 39.755n 0.0v 44.745n 0.0v 44.755n 0.0v 49.745n 0.0v 49.755n 0.95v 54.745n 0.95v 54.755n 0.0v 59.745n 0.0v 59.755n 0.95v 64.745n 0.95v 64.755n 0.0v 69.745n 0.0v 69.755n 0.0v 74.745n 0.0v 74.755n 0.95v 79.745n 0.95v 79.755n 0.95v 84.745n 0.95v 84.755n 0.0v 89.745n 0.0v 89.755n 0.0v 94.745n 0.0v 94.755n 0.95v 99.745n 0.95v 99.755n 0.95v 104.745n 0.95v 104.755n 0.0v 109.745n 0.0v 109.755n 0.0v 114.745n 0.0v 114.755n 0.0v 119.745n 0.0v 119.755n 0.95v 124.745n 0.95v 124.755n 0.95v 129.745n 0.95v 129.755n 0.95v 134.745n 0.95v 134.755n 0.95v 139.745n 0.95v 139.755n 0.0v 144.745n 0.0v 144.755n 0.95v 149.745n 0.95v 149.755n 0.95v 154.745n 0.95v 154.755n 0.95v 159.745n 0.95v 159.755n 0.0v 164.745n 0.0v 164.755n 0.0v 169.745n 0.0v 169.755n 0.0v 174.745n 0.0v 174.755n 0.95v 179.745n 0.95v 179.755n 0.95v 184.745n 0.95v 184.755n 0.95v 189.745n 0.95v 189.755n 0.95v 194.745n 0.95v 194.755n 0.0v 199.745n 0.0v 199.755n 0.95v 204.745n 0.95v 204.755n 0.95v 209.745n 0.95v 209.755n 0.95v 214.745n 0.95v 214.755n 0.95v 219.745n 0.95v 219.755n 0.95v 224.745n 0.95v 224.755n 0.95v 229.745n 0.95v 229.755n 0.95v 234.745n 0.95v 234.755n 0.0v 239.745n 0.0v 239.755n 0.0v 244.745n 0.0v 244.755n 0.0v 249.745n 0.0v 249.755n 0.0v 254.745n 0.0v 254.755n 0.0v 259.745n 0.0v 259.755n 0.95v 264.745n 0.95v 264.755n 0.95v 269.745n 0.95v 269.755n 0.0v 274.745n 0.0v 274.755n 0.0v 279.745n 0.0v 279.755n 0.0v 284.745n 0.0v 284.755n 0.0v 289.745n 0.0v 289.755n 0.0v 294.745n 0.0v 294.755n 0.95v 299.745n 0.95v 299.755n 0.95v 304.745n 0.95v 304.755n 0.95v 309.745n 0.95v 309.755n 0.95v 314.745n 0.95v 314.755n 0.0v 319.745n 0.0v 319.755n 0.0v 324.745n 0.0v 324.755n 0.0v 329.745n 0.0v 329.755n 0.95v 334.745n 0.95v 334.755n 0.0v 339.745n 0.0v 339.755n 0.0v 344.745n 0.0v 344.755n 0.95v 349.745n 0.95v 349.755n 0.95v 354.745n 0.95v 354.755n 0.0v 359.745n 0.0v 359.755n 0.95v 364.745n 0.95v 364.755n 0.0v 369.745n 0.0v 369.755n 0.95v 374.745n 0.95v 374.755n 0.95v 379.745n 0.95v 379.755n 0.0v 384.745n 0.0v 384.755n 0.0v 389.745n 0.0v 389.755n 0.0v 394.745n 0.0v 394.755n 0.95v 399.745n 0.95v 399.755n 0.0v 404.745n 0.0v 404.755n 0.0v 409.745n 0.0v 409.755n 0.95v 414.745n 0.95v 414.755n 0.95v 419.745n 0.95v 419.755n 0.95v 424.745n 0.95v 424.755n 0.0v 429.745n 0.0v 429.755n 0.0v 434.745n 0.0v 434.755n 0.0v 439.745n 0.0v 439.755n 0.0v 444.745n 0.0v 444.755n 0.95v 449.745n 0.95v 449.755n 0.95v 454.745n 0.95v 454.755n 0.95v 459.745n 0.95v 459.755n 0.0v 464.745n 0.0v 464.755n 0.0v 469.745n 0.0v 469.755n 0.95v 474.745n 0.95v 474.755n 0.0v 479.745n 0.0v 479.755n 0.95v 484.745n 0.95v 484.755n 0.0v 489.745n 0.0v 489.755n 0.0v 494.745n 0.0v 494.755n 0.95v 499.745n 0.95v 499.755n 0.95v 504.745n 0.95v 504.755n 0.0v 509.745n 0.0v 509.755n 0.0v 514.745n 0.0v 514.755n 0.0v 519.745n 0.0v 519.755n 0.95v 524.745n 0.95v 524.755n 0.95v 529.745n 0.95v 529.755n 0.0v 534.745n 0.0v 534.755n 0.0v 539.745n 0.0v 539.755n 0.95v 544.745n 0.95v 544.755n 0.0v 549.745n 0.0v 549.755n 0.0v 554.745n 0.0v 554.755n 0.95v 559.745n 0.95v 559.755n 0.95v 564.745n 0.95v 564.755n 0.95v 569.745n 0.95v 569.755n 0.95v 574.745n 0.95v 574.755n 0.95v 579.745n 0.95v 579.755n 0.0v 584.745n 0.0v 584.755n 0.0v 589.745n 0.0v 589.755n 0.95v 594.745n 0.95v 594.755n 0.0v 599.745n 0.0v 599.755n 0.0v 604.745n 0.0v 604.755n 0.0v 609.745n 0.0v 609.755n 0.0v 614.745n 0.0v 614.755n 0.95v 619.745n 0.95v 619.755n 0.95v 624.745n 0.95v 624.755n 0.0v 629.745n 0.0v 629.755n 0.0v 634.745n 0.0v 634.755n 0.0v 639.745n 0.0v 639.755n 0.0v 644.745n 0.0v 644.755n 0.0v 649.745n 0.0v 649.755n 0.95v 654.745n 0.95v 654.755n 0.95v 659.745n 0.95v 659.755n 0.0v 664.745n 0.0v 664.755n 0.0v 669.745n 0.0v 669.755n 0.95v 674.745n 0.95v 674.755n 0.0v 679.745n 0.0v 679.755n 0.0v 684.745n 0.0v 684.755n 0.0v 689.745n 0.0v 689.755n 0.0v 694.745n 0.0v 694.755n 0.95v 699.745n 0.95v 699.755n 0.95v 704.745n 0.95v 704.755n 0.95v 709.745n 0.95v 709.755n 0.0v 714.745n 0.0v 714.755n 0.0v 719.745n 0.0v 719.755n 0.0v 724.745n 0.0v 724.755n 0.95v 729.745n 0.95v 729.755n 0.0v 734.745n 0.0v 734.755n 0.0v 739.745n 0.0v 739.755n 0.0v 744.745n 0.0v 744.755n 0.0v 749.745n 0.0v 749.755n 0.0v 754.745n 0.0v 754.755n 0.0v 759.745n 0.0v 759.755n 0.0v 764.745n 0.0v 764.755n 0.0v 769.745n 0.0v 769.755n 0.0v 774.745n 0.0v 774.755n 0.0v 779.745n 0.0v 779.755n 0.0v 784.745n 0.0v 784.755n 0.0v 789.745n 0.0v 789.755n 0.95v 794.745n 0.95v 794.755n 0.95v 799.745n 0.95v 799.755n 0.0v 804.745n 0.0v 804.755n 0.95v 809.745n 0.95v 809.755n 0.95v 814.745n 0.95v 814.755n 0.95v 819.745n 0.95v 819.755n 0.0v 824.745n 0.0v 824.755n 0.0v 829.745n 0.0v 829.755n 0.0v 834.745n 0.0v 834.755n 0.0v 839.745n 0.0v 839.755n 0.0v 844.745n 0.0v 844.755n 0.0v 849.745n 0.0v 849.755n 0.95v 854.745n 0.95v 854.755n 0.95v 859.745n 0.95v 859.755n 0.95v 864.745n 0.95v 864.755n 0.0v 869.745n 0.0v 869.755n 0.95v 874.745n 0.95v 874.755n 0.0v 879.745n 0.0v 879.755n 0.95v 884.745n 0.95v 884.755n 0.95v 889.745n 0.95v 889.755n 0.95v 894.745n 0.95v 894.755n 0.95v 899.745n 0.95v 899.755n 0.95v 904.745n 0.95v 904.755n 0.95v 909.745n 0.95v 909.755n 0.0v 914.745n 0.0v 914.755n 0.95v 919.745n 0.95v 919.755n 0.0v 924.745n 0.0v 924.755n 0.0v 929.745n 0.0v 929.755n 0.95v 934.745n 0.95v 934.755n 0.0v 939.745n 0.0v 939.755n 0.0v 944.745n 0.0v 944.755n 0.0v 949.745n 0.0v 949.755n 0.0v 954.745n 0.0v 954.755n 0.95v 959.745n 0.95v 959.755n 0.95v 964.745n 0.95v 964.755n 0.0v 969.745n 0.0v 969.755n 0.0v 974.745n 0.0v 974.755n 0.95v 979.745n 0.95v 979.755n 0.95v 984.745n 0.95v 984.755n 0.0v 989.745n 0.0v 989.755n 0.95v 994.745n 0.95v 994.755n 0.95v 999.745n 0.95v 999.755n 0.95v 1004.745n 0.95v 1004.755n 0.0v 1009.745n 0.0v 1009.755n 0.0v 1014.745n 0.0v 1014.755n 0.0v 1019.745n 0.0v 1019.755n 0.0v 1024.745n 0.0v 1024.755n 0.0v )
* (time, data): [(0, 0), (5, 1), (10, 0), (15, 1), (20, 0), (25, 0), (30, 0), (35, 0), (40, 0), (45, 0), (50, 1), (55, 0), (60, 1), (65, 0), (70, 0), (75, 1), (80, 1), (85, 0), (90, 0), (95, 1), (100, 1), (105, 0), (110, 0), (115, 0), (120, 1), (125, 1), (130, 1), (135, 1), (140, 0), (145, 1), (150, 1), (155, 1), (160, 0), (165, 0), (170, 0), (175, 1), (180, 1), (185, 1), (190, 1), (195, 0), (200, 1), (205, 1), (210, 1), (215, 1), (220, 1), (225, 1), (230, 1), (235, 0), (240, 0), (245, 0), (250, 0), (255, 0), (260, 1), (265, 1), (270, 0), (275, 0), (280, 0), (285, 0), (290, 0), (295, 1), (300, 1), (305, 1), (310, 1), (315, 0), (320, 0), (325, 0), (330, 1), (335, 0), (340, 0), (345, 1), (350, 1), (355, 0), (360, 1), (365, 0), (370, 1), (375, 1), (380, 0), (385, 0), (390, 0), (395, 1), (400, 0), (405, 0), (410, 1), (415, 1), (420, 1), (425, 0), (430, 0), (435, 0), (440, 0), (445, 1), (450, 1), (455, 1), (460, 0), (465, 0), (470, 1), (475, 0), (480, 1), (485, 0), (490, 0), (495, 1), (500, 1), (505, 0), (510, 0), (515, 0), (520, 1), (525, 1), (530, 0), (535, 0), (540, 1), (545, 0), (550, 0), (555, 1), (560, 1), (565, 1), (570, 1), (575, 1), (580, 0), (585, 0), (590, 1), (595, 0), (600, 0), (605, 0), (610, 0), (615, 1), (620, 1), (625, 0), (630, 0), (635, 0), (640, 0), (645, 0), (650, 1), (655, 1), (660, 0), (665, 0), (670, 1), (675, 0), (680, 0), (685, 0), (690, 0), (695, 1), (700, 1), (705, 1), (710, 0), (715, 0), (720, 0), (725, 1), (730, 0), (735, 0), (740, 0), (745, 0), (750, 0), (755, 0), (760, 0), (765, 0), (770, 0), (775, 0), (780, 0), (785, 0), (790, 1), (795, 1), (800, 0), (805, 1), (810, 1), (815, 1), (820, 0), (825, 0), (830, 0), (835, 0), (840, 0), (845, 0), (850, 1), (855, 1), (860, 1), (865, 0), (870, 1), (875, 0), (880, 1), (885, 1), (890, 1), (895, 1), (900, 1), (905, 1), (910, 0), (915, 1), (920, 0), (925, 0), (930, 1), (935, 0), (940, 0), (945, 0), (950, 0), (955, 1), (960, 1), (965, 0), (970, 0), (975, 1), (980, 1), (985, 0), (990, 1), (995, 1), (1000, 1), (1005, 0), (1010, 0), (1015, 0), (1020, 0), (1025, 0)]
Va0_4  a0_4  0 PWL (0n 0.0v 4.745n 0.0v 4.755n 0.95v 9.745n 0.95v 9.755n 0.0v 14.745n 0.0v 14.755n 0.95v 19.745n 0.95v 19.755n 0.0v 24.745n 0.0v 24.755n 0.0v 29.745n 0.0v 29.755n 0.0v 34.745n 0.0v 34.755n 0.0v 39.745n 0.0v 39.755n 0.0v 44.745n 0.0v 44.755n 0.0v 49.745n 0.0v 49.755n 0.95v 54.745n 0.95v 54.755n 0.0v 59.745n 0.0v 59.755n 0.95v 64.745n 0.95v 64.755n 0.0v 69.745n 0.0v 69.755n 0.0v 74.745n 0.0v 74.755n 0.95v 79.745n 0.95v 79.755n 0.95v 84.745n 0.95v 84.755n 0.0v 89.745n 0.0v 89.755n 0.0v 94.745n 0.0v 94.755n 0.95v 99.745n 0.95v 99.755n 0.95v 104.745n 0.95v 104.755n 0.0v 109.745n 0.0v 109.755n 0.0v 114.745n 0.0v 114.755n 0.0v 119.745n 0.0v 119.755n 0.95v 124.745n 0.95v 124.755n 0.95v 129.745n 0.95v 129.755n 0.95v 134.745n 0.95v 134.755n 0.95v 139.745n 0.95v 139.755n 0.0v 144.745n 0.0v 144.755n 0.95v 149.745n 0.95v 149.755n 0.95v 154.745n 0.95v 154.755n 0.95v 159.745n 0.95v 159.755n 0.0v 164.745n 0.0v 164.755n 0.0v 169.745n 0.0v 169.755n 0.0v 174.745n 0.0v 174.755n 0.95v 179.745n 0.95v 179.755n 0.95v 184.745n 0.95v 184.755n 0.95v 189.745n 0.95v 189.755n 0.95v 194.745n 0.95v 194.755n 0.0v 199.745n 0.0v 199.755n 0.95v 204.745n 0.95v 204.755n 0.95v 209.745n 0.95v 209.755n 0.95v 214.745n 0.95v 214.755n 0.95v 219.745n 0.95v 219.755n 0.95v 224.745n 0.95v 224.755n 0.95v 229.745n 0.95v 229.755n 0.95v 234.745n 0.95v 234.755n 0.0v 239.745n 0.0v 239.755n 0.0v 244.745n 0.0v 244.755n 0.0v 249.745n 0.0v 249.755n 0.0v 254.745n 0.0v 254.755n 0.0v 259.745n 0.0v 259.755n 0.95v 264.745n 0.95v 264.755n 0.95v 269.745n 0.95v 269.755n 0.0v 274.745n 0.0v 274.755n 0.0v 279.745n 0.0v 279.755n 0.0v 284.745n 0.0v 284.755n 0.0v 289.745n 0.0v 289.755n 0.0v 294.745n 0.0v 294.755n 0.95v 299.745n 0.95v 299.755n 0.95v 304.745n 0.95v 304.755n 0.95v 309.745n 0.95v 309.755n 0.95v 314.745n 0.95v 314.755n 0.0v 319.745n 0.0v 319.755n 0.0v 324.745n 0.0v 324.755n 0.0v 329.745n 0.0v 329.755n 0.95v 334.745n 0.95v 334.755n 0.0v 339.745n 0.0v 339.755n 0.0v 344.745n 0.0v 344.755n 0.95v 349.745n 0.95v 349.755n 0.95v 354.745n 0.95v 354.755n 0.0v 359.745n 0.0v 359.755n 0.95v 364.745n 0.95v 364.755n 0.0v 369.745n 0.0v 369.755n 0.95v 374.745n 0.95v 374.755n 0.95v 379.745n 0.95v 379.755n 0.0v 384.745n 0.0v 384.755n 0.0v 389.745n 0.0v 389.755n 0.0v 394.745n 0.0v 394.755n 0.95v 399.745n 0.95v 399.755n 0.0v 404.745n 0.0v 404.755n 0.0v 409.745n 0.0v 409.755n 0.95v 414.745n 0.95v 414.755n 0.95v 419.745n 0.95v 419.755n 0.95v 424.745n 0.95v 424.755n 0.0v 429.745n 0.0v 429.755n 0.0v 434.745n 0.0v 434.755n 0.0v 439.745n 0.0v 439.755n 0.0v 444.745n 0.0v 444.755n 0.95v 449.745n 0.95v 449.755n 0.95v 454.745n 0.95v 454.755n 0.95v 459.745n 0.95v 459.755n 0.0v 464.745n 0.0v 464.755n 0.0v 469.745n 0.0v 469.755n 0.95v 474.745n 0.95v 474.755n 0.0v 479.745n 0.0v 479.755n 0.95v 484.745n 0.95v 484.755n 0.0v 489.745n 0.0v 489.755n 0.0v 494.745n 0.0v 494.755n 0.95v 499.745n 0.95v 499.755n 0.95v 504.745n 0.95v 504.755n 0.0v 509.745n 0.0v 509.755n 0.0v 514.745n 0.0v 514.755n 0.0v 519.745n 0.0v 519.755n 0.95v 524.745n 0.95v 524.755n 0.95v 529.745n 0.95v 529.755n 0.0v 534.745n 0.0v 534.755n 0.0v 539.745n 0.0v 539.755n 0.95v 544.745n 0.95v 544.755n 0.0v 549.745n 0.0v 549.755n 0.0v 554.745n 0.0v 554.755n 0.95v 559.745n 0.95v 559.755n 0.95v 564.745n 0.95v 564.755n 0.95v 569.745n 0.95v 569.755n 0.95v 574.745n 0.95v 574.755n 0.95v 579.745n 0.95v 579.755n 0.0v 584.745n 0.0v 584.755n 0.0v 589.745n 0.0v 589.755n 0.95v 594.745n 0.95v 594.755n 0.0v 599.745n 0.0v 599.755n 0.0v 604.745n 0.0v 604.755n 0.0v 609.745n 0.0v 609.755n 0.0v 614.745n 0.0v 614.755n 0.95v 619.745n 0.95v 619.755n 0.95v 624.745n 0.95v 624.755n 0.0v 629.745n 0.0v 629.755n 0.0v 634.745n 0.0v 634.755n 0.0v 639.745n 0.0v 639.755n 0.0v 644.745n 0.0v 644.755n 0.0v 649.745n 0.0v 649.755n 0.95v 654.745n 0.95v 654.755n 0.95v 659.745n 0.95v 659.755n 0.0v 664.745n 0.0v 664.755n 0.0v 669.745n 0.0v 669.755n 0.95v 674.745n 0.95v 674.755n 0.0v 679.745n 0.0v 679.755n 0.0v 684.745n 0.0v 684.755n 0.0v 689.745n 0.0v 689.755n 0.0v 694.745n 0.0v 694.755n 0.95v 699.745n 0.95v 699.755n 0.95v 704.745n 0.95v 704.755n 0.95v 709.745n 0.95v 709.755n 0.0v 714.745n 0.0v 714.755n 0.0v 719.745n 0.0v 719.755n 0.0v 724.745n 0.0v 724.755n 0.95v 729.745n 0.95v 729.755n 0.0v 734.745n 0.0v 734.755n 0.0v 739.745n 0.0v 739.755n 0.0v 744.745n 0.0v 744.755n 0.0v 749.745n 0.0v 749.755n 0.0v 754.745n 0.0v 754.755n 0.0v 759.745n 0.0v 759.755n 0.0v 764.745n 0.0v 764.755n 0.0v 769.745n 0.0v 769.755n 0.0v 774.745n 0.0v 774.755n 0.0v 779.745n 0.0v 779.755n 0.0v 784.745n 0.0v 784.755n 0.0v 789.745n 0.0v 789.755n 0.95v 794.745n 0.95v 794.755n 0.95v 799.745n 0.95v 799.755n 0.0v 804.745n 0.0v 804.755n 0.95v 809.745n 0.95v 809.755n 0.95v 814.745n 0.95v 814.755n 0.95v 819.745n 0.95v 819.755n 0.0v 824.745n 0.0v 824.755n 0.0v 829.745n 0.0v 829.755n 0.0v 834.745n 0.0v 834.755n 0.0v 839.745n 0.0v 839.755n 0.0v 844.745n 0.0v 844.755n 0.0v 849.745n 0.0v 849.755n 0.95v 854.745n 0.95v 854.755n 0.95v 859.745n 0.95v 859.755n 0.95v 864.745n 0.95v 864.755n 0.0v 869.745n 0.0v 869.755n 0.95v 874.745n 0.95v 874.755n 0.0v 879.745n 0.0v 879.755n 0.95v 884.745n 0.95v 884.755n 0.95v 889.745n 0.95v 889.755n 0.95v 894.745n 0.95v 894.755n 0.95v 899.745n 0.95v 899.755n 0.95v 904.745n 0.95v 904.755n 0.95v 909.745n 0.95v 909.755n 0.0v 914.745n 0.0v 914.755n 0.95v 919.745n 0.95v 919.755n 0.0v 924.745n 0.0v 924.755n 0.0v 929.745n 0.0v 929.755n 0.95v 934.745n 0.95v 934.755n 0.0v 939.745n 0.0v 939.755n 0.0v 944.745n 0.0v 944.755n 0.0v 949.745n 0.0v 949.755n 0.0v 954.745n 0.0v 954.755n 0.95v 959.745n 0.95v 959.755n 0.95v 964.745n 0.95v 964.755n 0.0v 969.745n 0.0v 969.755n 0.0v 974.745n 0.0v 974.755n 0.95v 979.745n 0.95v 979.755n 0.95v 984.745n 0.95v 984.755n 0.0v 989.745n 0.0v 989.755n 0.95v 994.745n 0.95v 994.755n 0.95v 999.745n 0.95v 999.755n 0.95v 1004.745n 0.95v 1004.755n 0.0v 1009.745n 0.0v 1009.755n 0.0v 1014.745n 0.0v 1014.755n 0.0v 1019.745n 0.0v 1019.755n 0.0v 1024.745n 0.0v 1024.755n 0.0v )
* (time, data): [(0, 0), (5, 1), (10, 0), (15, 1), (20, 0), (25, 0), (30, 0), (35, 0), (40, 0), (45, 0), (50, 1), (55, 0), (60, 1), (65, 0), (70, 0), (75, 1), (80, 1), (85, 0), (90, 0), (95, 1), (100, 1), (105, 0), (110, 0), (115, 0), (120, 1), (125, 1), (130, 1), (135, 1), (140, 0), (145, 1), (150, 1), (155, 1), (160, 0), (165, 0), (170, 0), (175, 1), (180, 1), (185, 1), (190, 1), (195, 0), (200, 1), (205, 1), (210, 1), (215, 1), (220, 1), (225, 1), (230, 1), (235, 0), (240, 0), (245, 0), (250, 0), (255, 0), (260, 1), (265, 1), (270, 0), (275, 0), (280, 0), (285, 0), (290, 0), (295, 1), (300, 1), (305, 1), (310, 1), (315, 0), (320, 0), (325, 0), (330, 1), (335, 0), (340, 0), (345, 1), (350, 1), (355, 0), (360, 1), (365, 0), (370, 1), (375, 1), (380, 0), (385, 0), (390, 0), (395, 1), (400, 0), (405, 0), (410, 1), (415, 1), (420, 1), (425, 0), (430, 0), (435, 0), (440, 0), (445, 1), (450, 1), (455, 1), (460, 0), (465, 0), (470, 1), (475, 0), (480, 1), (485, 0), (490, 0), (495, 1), (500, 1), (505, 0), (510, 0), (515, 0), (520, 1), (525, 1), (530, 0), (535, 0), (540, 1), (545, 0), (550, 0), (555, 1), (560, 1), (565, 1), (570, 1), (575, 1), (580, 0), (585, 0), (590, 1), (595, 0), (600, 0), (605, 0), (610, 0), (615, 1), (620, 1), (625, 0), (630, 0), (635, 0), (640, 0), (645, 0), (650, 1), (655, 1), (660, 0), (665, 0), (670, 1), (675, 0), (680, 0), (685, 0), (690, 0), (695, 1), (700, 1), (705, 1), (710, 0), (715, 0), (720, 0), (725, 1), (730, 0), (735, 0), (740, 0), (745, 0), (750, 0), (755, 0), (760, 0), (765, 0), (770, 0), (775, 0), (780, 0), (785, 0), (790, 1), (795, 1), (800, 0), (805, 1), (810, 1), (815, 1), (820, 0), (825, 0), (830, 0), (835, 0), (840, 0), (845, 0), (850, 1), (855, 1), (860, 1), (865, 0), (870, 1), (875, 0), (880, 1), (885, 1), (890, 1), (895, 1), (900, 1), (905, 1), (910, 0), (915, 1), (920, 0), (925, 0), (930, 1), (935, 0), (940, 0), (945, 0), (950, 0), (955, 1), (960, 1), (965, 0), (970, 0), (975, 1), (980, 1), (985, 0), (990, 1), (995, 1), (1000, 1), (1005, 0), (1010, 0), (1015, 0), (1020, 0), (1025, 0)]
Va0_5  a0_5  0 PWL (0n 0.0v 4.745n 0.0v 4.755n 0.95v 9.745n 0.95v 9.755n 0.0v 14.745n 0.0v 14.755n 0.95v 19.745n 0.95v 19.755n 0.0v 24.745n 0.0v 24.755n 0.0v 29.745n 0.0v 29.755n 0.0v 34.745n 0.0v 34.755n 0.0v 39.745n 0.0v 39.755n 0.0v 44.745n 0.0v 44.755n 0.0v 49.745n 0.0v 49.755n 0.95v 54.745n 0.95v 54.755n 0.0v 59.745n 0.0v 59.755n 0.95v 64.745n 0.95v 64.755n 0.0v 69.745n 0.0v 69.755n 0.0v 74.745n 0.0v 74.755n 0.95v 79.745n 0.95v 79.755n 0.95v 84.745n 0.95v 84.755n 0.0v 89.745n 0.0v 89.755n 0.0v 94.745n 0.0v 94.755n 0.95v 99.745n 0.95v 99.755n 0.95v 104.745n 0.95v 104.755n 0.0v 109.745n 0.0v 109.755n 0.0v 114.745n 0.0v 114.755n 0.0v 119.745n 0.0v 119.755n 0.95v 124.745n 0.95v 124.755n 0.95v 129.745n 0.95v 129.755n 0.95v 134.745n 0.95v 134.755n 0.95v 139.745n 0.95v 139.755n 0.0v 144.745n 0.0v 144.755n 0.95v 149.745n 0.95v 149.755n 0.95v 154.745n 0.95v 154.755n 0.95v 159.745n 0.95v 159.755n 0.0v 164.745n 0.0v 164.755n 0.0v 169.745n 0.0v 169.755n 0.0v 174.745n 0.0v 174.755n 0.95v 179.745n 0.95v 179.755n 0.95v 184.745n 0.95v 184.755n 0.95v 189.745n 0.95v 189.755n 0.95v 194.745n 0.95v 194.755n 0.0v 199.745n 0.0v 199.755n 0.95v 204.745n 0.95v 204.755n 0.95v 209.745n 0.95v 209.755n 0.95v 214.745n 0.95v 214.755n 0.95v 219.745n 0.95v 219.755n 0.95v 224.745n 0.95v 224.755n 0.95v 229.745n 0.95v 229.755n 0.95v 234.745n 0.95v 234.755n 0.0v 239.745n 0.0v 239.755n 0.0v 244.745n 0.0v 244.755n 0.0v 249.745n 0.0v 249.755n 0.0v 254.745n 0.0v 254.755n 0.0v 259.745n 0.0v 259.755n 0.95v 264.745n 0.95v 264.755n 0.95v 269.745n 0.95v 269.755n 0.0v 274.745n 0.0v 274.755n 0.0v 279.745n 0.0v 279.755n 0.0v 284.745n 0.0v 284.755n 0.0v 289.745n 0.0v 289.755n 0.0v 294.745n 0.0v 294.755n 0.95v 299.745n 0.95v 299.755n 0.95v 304.745n 0.95v 304.755n 0.95v 309.745n 0.95v 309.755n 0.95v 314.745n 0.95v 314.755n 0.0v 319.745n 0.0v 319.755n 0.0v 324.745n 0.0v 324.755n 0.0v 329.745n 0.0v 329.755n 0.95v 334.745n 0.95v 334.755n 0.0v 339.745n 0.0v 339.755n 0.0v 344.745n 0.0v 344.755n 0.95v 349.745n 0.95v 349.755n 0.95v 354.745n 0.95v 354.755n 0.0v 359.745n 0.0v 359.755n 0.95v 364.745n 0.95v 364.755n 0.0v 369.745n 0.0v 369.755n 0.95v 374.745n 0.95v 374.755n 0.95v 379.745n 0.95v 379.755n 0.0v 384.745n 0.0v 384.755n 0.0v 389.745n 0.0v 389.755n 0.0v 394.745n 0.0v 394.755n 0.95v 399.745n 0.95v 399.755n 0.0v 404.745n 0.0v 404.755n 0.0v 409.745n 0.0v 409.755n 0.95v 414.745n 0.95v 414.755n 0.95v 419.745n 0.95v 419.755n 0.95v 424.745n 0.95v 424.755n 0.0v 429.745n 0.0v 429.755n 0.0v 434.745n 0.0v 434.755n 0.0v 439.745n 0.0v 439.755n 0.0v 444.745n 0.0v 444.755n 0.95v 449.745n 0.95v 449.755n 0.95v 454.745n 0.95v 454.755n 0.95v 459.745n 0.95v 459.755n 0.0v 464.745n 0.0v 464.755n 0.0v 469.745n 0.0v 469.755n 0.95v 474.745n 0.95v 474.755n 0.0v 479.745n 0.0v 479.755n 0.95v 484.745n 0.95v 484.755n 0.0v 489.745n 0.0v 489.755n 0.0v 494.745n 0.0v 494.755n 0.95v 499.745n 0.95v 499.755n 0.95v 504.745n 0.95v 504.755n 0.0v 509.745n 0.0v 509.755n 0.0v 514.745n 0.0v 514.755n 0.0v 519.745n 0.0v 519.755n 0.95v 524.745n 0.95v 524.755n 0.95v 529.745n 0.95v 529.755n 0.0v 534.745n 0.0v 534.755n 0.0v 539.745n 0.0v 539.755n 0.95v 544.745n 0.95v 544.755n 0.0v 549.745n 0.0v 549.755n 0.0v 554.745n 0.0v 554.755n 0.95v 559.745n 0.95v 559.755n 0.95v 564.745n 0.95v 564.755n 0.95v 569.745n 0.95v 569.755n 0.95v 574.745n 0.95v 574.755n 0.95v 579.745n 0.95v 579.755n 0.0v 584.745n 0.0v 584.755n 0.0v 589.745n 0.0v 589.755n 0.95v 594.745n 0.95v 594.755n 0.0v 599.745n 0.0v 599.755n 0.0v 604.745n 0.0v 604.755n 0.0v 609.745n 0.0v 609.755n 0.0v 614.745n 0.0v 614.755n 0.95v 619.745n 0.95v 619.755n 0.95v 624.745n 0.95v 624.755n 0.0v 629.745n 0.0v 629.755n 0.0v 634.745n 0.0v 634.755n 0.0v 639.745n 0.0v 639.755n 0.0v 644.745n 0.0v 644.755n 0.0v 649.745n 0.0v 649.755n 0.95v 654.745n 0.95v 654.755n 0.95v 659.745n 0.95v 659.755n 0.0v 664.745n 0.0v 664.755n 0.0v 669.745n 0.0v 669.755n 0.95v 674.745n 0.95v 674.755n 0.0v 679.745n 0.0v 679.755n 0.0v 684.745n 0.0v 684.755n 0.0v 689.745n 0.0v 689.755n 0.0v 694.745n 0.0v 694.755n 0.95v 699.745n 0.95v 699.755n 0.95v 704.745n 0.95v 704.755n 0.95v 709.745n 0.95v 709.755n 0.0v 714.745n 0.0v 714.755n 0.0v 719.745n 0.0v 719.755n 0.0v 724.745n 0.0v 724.755n 0.95v 729.745n 0.95v 729.755n 0.0v 734.745n 0.0v 734.755n 0.0v 739.745n 0.0v 739.755n 0.0v 744.745n 0.0v 744.755n 0.0v 749.745n 0.0v 749.755n 0.0v 754.745n 0.0v 754.755n 0.0v 759.745n 0.0v 759.755n 0.0v 764.745n 0.0v 764.755n 0.0v 769.745n 0.0v 769.755n 0.0v 774.745n 0.0v 774.755n 0.0v 779.745n 0.0v 779.755n 0.0v 784.745n 0.0v 784.755n 0.0v 789.745n 0.0v 789.755n 0.95v 794.745n 0.95v 794.755n 0.95v 799.745n 0.95v 799.755n 0.0v 804.745n 0.0v 804.755n 0.95v 809.745n 0.95v 809.755n 0.95v 814.745n 0.95v 814.755n 0.95v 819.745n 0.95v 819.755n 0.0v 824.745n 0.0v 824.755n 0.0v 829.745n 0.0v 829.755n 0.0v 834.745n 0.0v 834.755n 0.0v 839.745n 0.0v 839.755n 0.0v 844.745n 0.0v 844.755n 0.0v 849.745n 0.0v 849.755n 0.95v 854.745n 0.95v 854.755n 0.95v 859.745n 0.95v 859.755n 0.95v 864.745n 0.95v 864.755n 0.0v 869.745n 0.0v 869.755n 0.95v 874.745n 0.95v 874.755n 0.0v 879.745n 0.0v 879.755n 0.95v 884.745n 0.95v 884.755n 0.95v 889.745n 0.95v 889.755n 0.95v 894.745n 0.95v 894.755n 0.95v 899.745n 0.95v 899.755n 0.95v 904.745n 0.95v 904.755n 0.95v 909.745n 0.95v 909.755n 0.0v 914.745n 0.0v 914.755n 0.95v 919.745n 0.95v 919.755n 0.0v 924.745n 0.0v 924.755n 0.0v 929.745n 0.0v 929.755n 0.95v 934.745n 0.95v 934.755n 0.0v 939.745n 0.0v 939.755n 0.0v 944.745n 0.0v 944.755n 0.0v 949.745n 0.0v 949.755n 0.0v 954.745n 0.0v 954.755n 0.95v 959.745n 0.95v 959.755n 0.95v 964.745n 0.95v 964.755n 0.0v 969.745n 0.0v 969.755n 0.0v 974.745n 0.0v 974.755n 0.95v 979.745n 0.95v 979.755n 0.95v 984.745n 0.95v 984.755n 0.0v 989.745n 0.0v 989.755n 0.95v 994.745n 0.95v 994.755n 0.95v 999.745n 0.95v 999.755n 0.95v 1004.745n 0.95v 1004.755n 0.0v 1009.745n 0.0v 1009.755n 0.0v 1014.745n 0.0v 1014.755n 0.0v 1019.745n 0.0v 1019.755n 0.0v 1024.745n 0.0v 1024.755n 0.0v )
* (time, data): [(0, 0), (5, 1), (10, 0), (15, 1), (20, 0), (25, 0), (30, 0), (35, 0), (40, 0), (45, 0), (50, 1), (55, 0), (60, 1), (65, 0), (70, 0), (75, 1), (80, 1), (85, 0), (90, 0), (95, 1), (100, 1), (105, 0), (110, 0), (115, 0), (120, 1), (125, 1), (130, 1), (135, 1), (140, 0), (145, 1), (150, 1), (155, 1), (160, 0), (165, 0), (170, 0), (175, 1), (180, 1), (185, 1), (190, 1), (195, 0), (200, 1), (205, 1), (210, 1), (215, 1), (220, 1), (225, 1), (230, 1), (235, 0), (240, 0), (245, 0), (250, 0), (255, 0), (260, 1), (265, 1), (270, 0), (275, 0), (280, 0), (285, 0), (290, 0), (295, 1), (300, 1), (305, 1), (310, 1), (315, 0), (320, 0), (325, 0), (330, 1), (335, 0), (340, 0), (345, 1), (350, 1), (355, 0), (360, 1), (365, 0), (370, 1), (375, 1), (380, 0), (385, 0), (390, 0), (395, 1), (400, 0), (405, 0), (410, 1), (415, 1), (420, 1), (425, 0), (430, 0), (435, 0), (440, 0), (445, 1), (450, 1), (455, 1), (460, 0), (465, 0), (470, 1), (475, 0), (480, 1), (485, 0), (490, 0), (495, 1), (500, 1), (505, 0), (510, 0), (515, 0), (520, 1), (525, 1), (530, 0), (535, 0), (540, 1), (545, 0), (550, 0), (555, 1), (560, 1), (565, 1), (570, 1), (575, 1), (580, 0), (585, 0), (590, 1), (595, 0), (600, 0), (605, 0), (610, 0), (615, 1), (620, 1), (625, 0), (630, 0), (635, 0), (640, 0), (645, 0), (650, 1), (655, 1), (660, 0), (665, 0), (670, 1), (675, 0), (680, 0), (685, 0), (690, 0), (695, 1), (700, 1), (705, 1), (710, 0), (715, 0), (720, 0), (725, 1), (730, 0), (735, 0), (740, 0), (745, 0), (750, 0), (755, 0), (760, 0), (765, 0), (770, 0), (775, 0), (780, 0), (785, 0), (790, 1), (795, 1), (800, 0), (805, 1), (810, 1), (815, 1), (820, 0), (825, 0), (830, 0), (835, 0), (840, 0), (845, 0), (850, 1), (855, 1), (860, 1), (865, 0), (870, 1), (875, 0), (880, 1), (885, 1), (890, 1), (895, 1), (900, 1), (905, 1), (910, 0), (915, 1), (920, 0), (925, 0), (930, 1), (935, 0), (940, 0), (945, 0), (950, 0), (955, 1), (960, 1), (965, 0), (970, 0), (975, 1), (980, 1), (985, 0), (990, 1), (995, 1), (1000, 1), (1005, 0), (1010, 0), (1015, 0), (1020, 0), (1025, 0)]
Va0_6  a0_6  0 PWL (0n 0.0v 4.745n 0.0v 4.755n 0.95v 9.745n 0.95v 9.755n 0.0v 14.745n 0.0v 14.755n 0.95v 19.745n 0.95v 19.755n 0.0v 24.745n 0.0v 24.755n 0.0v 29.745n 0.0v 29.755n 0.0v 34.745n 0.0v 34.755n 0.0v 39.745n 0.0v 39.755n 0.0v 44.745n 0.0v 44.755n 0.0v 49.745n 0.0v 49.755n 0.95v 54.745n 0.95v 54.755n 0.0v 59.745n 0.0v 59.755n 0.95v 64.745n 0.95v 64.755n 0.0v 69.745n 0.0v 69.755n 0.0v 74.745n 0.0v 74.755n 0.95v 79.745n 0.95v 79.755n 0.95v 84.745n 0.95v 84.755n 0.0v 89.745n 0.0v 89.755n 0.0v 94.745n 0.0v 94.755n 0.95v 99.745n 0.95v 99.755n 0.95v 104.745n 0.95v 104.755n 0.0v 109.745n 0.0v 109.755n 0.0v 114.745n 0.0v 114.755n 0.0v 119.745n 0.0v 119.755n 0.95v 124.745n 0.95v 124.755n 0.95v 129.745n 0.95v 129.755n 0.95v 134.745n 0.95v 134.755n 0.95v 139.745n 0.95v 139.755n 0.0v 144.745n 0.0v 144.755n 0.95v 149.745n 0.95v 149.755n 0.95v 154.745n 0.95v 154.755n 0.95v 159.745n 0.95v 159.755n 0.0v 164.745n 0.0v 164.755n 0.0v 169.745n 0.0v 169.755n 0.0v 174.745n 0.0v 174.755n 0.95v 179.745n 0.95v 179.755n 0.95v 184.745n 0.95v 184.755n 0.95v 189.745n 0.95v 189.755n 0.95v 194.745n 0.95v 194.755n 0.0v 199.745n 0.0v 199.755n 0.95v 204.745n 0.95v 204.755n 0.95v 209.745n 0.95v 209.755n 0.95v 214.745n 0.95v 214.755n 0.95v 219.745n 0.95v 219.755n 0.95v 224.745n 0.95v 224.755n 0.95v 229.745n 0.95v 229.755n 0.95v 234.745n 0.95v 234.755n 0.0v 239.745n 0.0v 239.755n 0.0v 244.745n 0.0v 244.755n 0.0v 249.745n 0.0v 249.755n 0.0v 254.745n 0.0v 254.755n 0.0v 259.745n 0.0v 259.755n 0.95v 264.745n 0.95v 264.755n 0.95v 269.745n 0.95v 269.755n 0.0v 274.745n 0.0v 274.755n 0.0v 279.745n 0.0v 279.755n 0.0v 284.745n 0.0v 284.755n 0.0v 289.745n 0.0v 289.755n 0.0v 294.745n 0.0v 294.755n 0.95v 299.745n 0.95v 299.755n 0.95v 304.745n 0.95v 304.755n 0.95v 309.745n 0.95v 309.755n 0.95v 314.745n 0.95v 314.755n 0.0v 319.745n 0.0v 319.755n 0.0v 324.745n 0.0v 324.755n 0.0v 329.745n 0.0v 329.755n 0.95v 334.745n 0.95v 334.755n 0.0v 339.745n 0.0v 339.755n 0.0v 344.745n 0.0v 344.755n 0.95v 349.745n 0.95v 349.755n 0.95v 354.745n 0.95v 354.755n 0.0v 359.745n 0.0v 359.755n 0.95v 364.745n 0.95v 364.755n 0.0v 369.745n 0.0v 369.755n 0.95v 374.745n 0.95v 374.755n 0.95v 379.745n 0.95v 379.755n 0.0v 384.745n 0.0v 384.755n 0.0v 389.745n 0.0v 389.755n 0.0v 394.745n 0.0v 394.755n 0.95v 399.745n 0.95v 399.755n 0.0v 404.745n 0.0v 404.755n 0.0v 409.745n 0.0v 409.755n 0.95v 414.745n 0.95v 414.755n 0.95v 419.745n 0.95v 419.755n 0.95v 424.745n 0.95v 424.755n 0.0v 429.745n 0.0v 429.755n 0.0v 434.745n 0.0v 434.755n 0.0v 439.745n 0.0v 439.755n 0.0v 444.745n 0.0v 444.755n 0.95v 449.745n 0.95v 449.755n 0.95v 454.745n 0.95v 454.755n 0.95v 459.745n 0.95v 459.755n 0.0v 464.745n 0.0v 464.755n 0.0v 469.745n 0.0v 469.755n 0.95v 474.745n 0.95v 474.755n 0.0v 479.745n 0.0v 479.755n 0.95v 484.745n 0.95v 484.755n 0.0v 489.745n 0.0v 489.755n 0.0v 494.745n 0.0v 494.755n 0.95v 499.745n 0.95v 499.755n 0.95v 504.745n 0.95v 504.755n 0.0v 509.745n 0.0v 509.755n 0.0v 514.745n 0.0v 514.755n 0.0v 519.745n 0.0v 519.755n 0.95v 524.745n 0.95v 524.755n 0.95v 529.745n 0.95v 529.755n 0.0v 534.745n 0.0v 534.755n 0.0v 539.745n 0.0v 539.755n 0.95v 544.745n 0.95v 544.755n 0.0v 549.745n 0.0v 549.755n 0.0v 554.745n 0.0v 554.755n 0.95v 559.745n 0.95v 559.755n 0.95v 564.745n 0.95v 564.755n 0.95v 569.745n 0.95v 569.755n 0.95v 574.745n 0.95v 574.755n 0.95v 579.745n 0.95v 579.755n 0.0v 584.745n 0.0v 584.755n 0.0v 589.745n 0.0v 589.755n 0.95v 594.745n 0.95v 594.755n 0.0v 599.745n 0.0v 599.755n 0.0v 604.745n 0.0v 604.755n 0.0v 609.745n 0.0v 609.755n 0.0v 614.745n 0.0v 614.755n 0.95v 619.745n 0.95v 619.755n 0.95v 624.745n 0.95v 624.755n 0.0v 629.745n 0.0v 629.755n 0.0v 634.745n 0.0v 634.755n 0.0v 639.745n 0.0v 639.755n 0.0v 644.745n 0.0v 644.755n 0.0v 649.745n 0.0v 649.755n 0.95v 654.745n 0.95v 654.755n 0.95v 659.745n 0.95v 659.755n 0.0v 664.745n 0.0v 664.755n 0.0v 669.745n 0.0v 669.755n 0.95v 674.745n 0.95v 674.755n 0.0v 679.745n 0.0v 679.755n 0.0v 684.745n 0.0v 684.755n 0.0v 689.745n 0.0v 689.755n 0.0v 694.745n 0.0v 694.755n 0.95v 699.745n 0.95v 699.755n 0.95v 704.745n 0.95v 704.755n 0.95v 709.745n 0.95v 709.755n 0.0v 714.745n 0.0v 714.755n 0.0v 719.745n 0.0v 719.755n 0.0v 724.745n 0.0v 724.755n 0.95v 729.745n 0.95v 729.755n 0.0v 734.745n 0.0v 734.755n 0.0v 739.745n 0.0v 739.755n 0.0v 744.745n 0.0v 744.755n 0.0v 749.745n 0.0v 749.755n 0.0v 754.745n 0.0v 754.755n 0.0v 759.745n 0.0v 759.755n 0.0v 764.745n 0.0v 764.755n 0.0v 769.745n 0.0v 769.755n 0.0v 774.745n 0.0v 774.755n 0.0v 779.745n 0.0v 779.755n 0.0v 784.745n 0.0v 784.755n 0.0v 789.745n 0.0v 789.755n 0.95v 794.745n 0.95v 794.755n 0.95v 799.745n 0.95v 799.755n 0.0v 804.745n 0.0v 804.755n 0.95v 809.745n 0.95v 809.755n 0.95v 814.745n 0.95v 814.755n 0.95v 819.745n 0.95v 819.755n 0.0v 824.745n 0.0v 824.755n 0.0v 829.745n 0.0v 829.755n 0.0v 834.745n 0.0v 834.755n 0.0v 839.745n 0.0v 839.755n 0.0v 844.745n 0.0v 844.755n 0.0v 849.745n 0.0v 849.755n 0.95v 854.745n 0.95v 854.755n 0.95v 859.745n 0.95v 859.755n 0.95v 864.745n 0.95v 864.755n 0.0v 869.745n 0.0v 869.755n 0.95v 874.745n 0.95v 874.755n 0.0v 879.745n 0.0v 879.755n 0.95v 884.745n 0.95v 884.755n 0.95v 889.745n 0.95v 889.755n 0.95v 894.745n 0.95v 894.755n 0.95v 899.745n 0.95v 899.755n 0.95v 904.745n 0.95v 904.755n 0.95v 909.745n 0.95v 909.755n 0.0v 914.745n 0.0v 914.755n 0.95v 919.745n 0.95v 919.755n 0.0v 924.745n 0.0v 924.755n 0.0v 929.745n 0.0v 929.755n 0.95v 934.745n 0.95v 934.755n 0.0v 939.745n 0.0v 939.755n 0.0v 944.745n 0.0v 944.755n 0.0v 949.745n 0.0v 949.755n 0.0v 954.745n 0.0v 954.755n 0.95v 959.745n 0.95v 959.755n 0.95v 964.745n 0.95v 964.755n 0.0v 969.745n 0.0v 969.755n 0.0v 974.745n 0.0v 974.755n 0.95v 979.745n 0.95v 979.755n 0.95v 984.745n 0.95v 984.755n 0.0v 989.745n 0.0v 989.755n 0.95v 994.745n 0.95v 994.755n 0.95v 999.745n 0.95v 999.755n 0.95v 1004.745n 0.95v 1004.755n 0.0v 1009.745n 0.0v 1009.755n 0.0v 1014.745n 0.0v 1014.755n 0.0v 1019.745n 0.0v 1019.755n 0.0v 1024.745n 0.0v 1024.755n 0.0v )
* (time, data): [(0, 0), (5, 1), (10, 0), (15, 1), (20, 0), (25, 0), (30, 0), (35, 0), (40, 0), (45, 0), (50, 1), (55, 0), (60, 1), (65, 0), (70, 0), (75, 1), (80, 1), (85, 0), (90, 0), (95, 1), (100, 1), (105, 0), (110, 0), (115, 0), (120, 1), (125, 1), (130, 1), (135, 1), (140, 0), (145, 1), (150, 1), (155, 1), (160, 0), (165, 0), (170, 0), (175, 1), (180, 1), (185, 1), (190, 1), (195, 0), (200, 1), (205, 1), (210, 1), (215, 1), (220, 1), (225, 1), (230, 1), (235, 0), (240, 0), (245, 0), (250, 0), (255, 0), (260, 1), (265, 1), (270, 0), (275, 0), (280, 0), (285, 0), (290, 0), (295, 1), (300, 1), (305, 1), (310, 1), (315, 0), (320, 0), (325, 0), (330, 1), (335, 0), (340, 0), (345, 1), (350, 1), (355, 0), (360, 1), (365, 0), (370, 1), (375, 1), (380, 0), (385, 0), (390, 0), (395, 1), (400, 0), (405, 0), (410, 1), (415, 1), (420, 1), (425, 0), (430, 0), (435, 0), (440, 0), (445, 1), (450, 1), (455, 1), (460, 0), (465, 0), (470, 1), (475, 0), (480, 1), (485, 0), (490, 0), (495, 1), (500, 1), (505, 0), (510, 0), (515, 0), (520, 1), (525, 1), (530, 0), (535, 0), (540, 1), (545, 0), (550, 0), (555, 1), (560, 1), (565, 1), (570, 1), (575, 1), (580, 0), (585, 0), (590, 1), (595, 0), (600, 0), (605, 0), (610, 0), (615, 1), (620, 1), (625, 0), (630, 0), (635, 0), (640, 0), (645, 0), (650, 1), (655, 1), (660, 0), (665, 0), (670, 1), (675, 0), (680, 0), (685, 0), (690, 0), (695, 1), (700, 1), (705, 1), (710, 0), (715, 0), (720, 0), (725, 1), (730, 0), (735, 0), (740, 0), (745, 0), (750, 0), (755, 0), (760, 0), (765, 0), (770, 0), (775, 0), (780, 0), (785, 0), (790, 1), (795, 1), (800, 0), (805, 1), (810, 1), (815, 1), (820, 0), (825, 0), (830, 0), (835, 0), (840, 0), (845, 0), (850, 1), (855, 1), (860, 1), (865, 0), (870, 1), (875, 0), (880, 1), (885, 1), (890, 1), (895, 1), (900, 1), (905, 1), (910, 0), (915, 1), (920, 0), (925, 0), (930, 1), (935, 0), (940, 0), (945, 0), (950, 0), (955, 1), (960, 1), (965, 0), (970, 0), (975, 1), (980, 1), (985, 0), (990, 1), (995, 1), (1000, 1), (1005, 0), (1010, 0), (1015, 0), (1020, 0), (1025, 0)]
Va0_7  a0_7  0 PWL (0n 0.0v 4.745n 0.0v 4.755n 0.95v 9.745n 0.95v 9.755n 0.0v 14.745n 0.0v 14.755n 0.95v 19.745n 0.95v 19.755n 0.0v 24.745n 0.0v 24.755n 0.0v 29.745n 0.0v 29.755n 0.0v 34.745n 0.0v 34.755n 0.0v 39.745n 0.0v 39.755n 0.0v 44.745n 0.0v 44.755n 0.0v 49.745n 0.0v 49.755n 0.95v 54.745n 0.95v 54.755n 0.0v 59.745n 0.0v 59.755n 0.95v 64.745n 0.95v 64.755n 0.0v 69.745n 0.0v 69.755n 0.0v 74.745n 0.0v 74.755n 0.95v 79.745n 0.95v 79.755n 0.95v 84.745n 0.95v 84.755n 0.0v 89.745n 0.0v 89.755n 0.0v 94.745n 0.0v 94.755n 0.95v 99.745n 0.95v 99.755n 0.95v 104.745n 0.95v 104.755n 0.0v 109.745n 0.0v 109.755n 0.0v 114.745n 0.0v 114.755n 0.0v 119.745n 0.0v 119.755n 0.95v 124.745n 0.95v 124.755n 0.95v 129.745n 0.95v 129.755n 0.95v 134.745n 0.95v 134.755n 0.95v 139.745n 0.95v 139.755n 0.0v 144.745n 0.0v 144.755n 0.95v 149.745n 0.95v 149.755n 0.95v 154.745n 0.95v 154.755n 0.95v 159.745n 0.95v 159.755n 0.0v 164.745n 0.0v 164.755n 0.0v 169.745n 0.0v 169.755n 0.0v 174.745n 0.0v 174.755n 0.95v 179.745n 0.95v 179.755n 0.95v 184.745n 0.95v 184.755n 0.95v 189.745n 0.95v 189.755n 0.95v 194.745n 0.95v 194.755n 0.0v 199.745n 0.0v 199.755n 0.95v 204.745n 0.95v 204.755n 0.95v 209.745n 0.95v 209.755n 0.95v 214.745n 0.95v 214.755n 0.95v 219.745n 0.95v 219.755n 0.95v 224.745n 0.95v 224.755n 0.95v 229.745n 0.95v 229.755n 0.95v 234.745n 0.95v 234.755n 0.0v 239.745n 0.0v 239.755n 0.0v 244.745n 0.0v 244.755n 0.0v 249.745n 0.0v 249.755n 0.0v 254.745n 0.0v 254.755n 0.0v 259.745n 0.0v 259.755n 0.95v 264.745n 0.95v 264.755n 0.95v 269.745n 0.95v 269.755n 0.0v 274.745n 0.0v 274.755n 0.0v 279.745n 0.0v 279.755n 0.0v 284.745n 0.0v 284.755n 0.0v 289.745n 0.0v 289.755n 0.0v 294.745n 0.0v 294.755n 0.95v 299.745n 0.95v 299.755n 0.95v 304.745n 0.95v 304.755n 0.95v 309.745n 0.95v 309.755n 0.95v 314.745n 0.95v 314.755n 0.0v 319.745n 0.0v 319.755n 0.0v 324.745n 0.0v 324.755n 0.0v 329.745n 0.0v 329.755n 0.95v 334.745n 0.95v 334.755n 0.0v 339.745n 0.0v 339.755n 0.0v 344.745n 0.0v 344.755n 0.95v 349.745n 0.95v 349.755n 0.95v 354.745n 0.95v 354.755n 0.0v 359.745n 0.0v 359.755n 0.95v 364.745n 0.95v 364.755n 0.0v 369.745n 0.0v 369.755n 0.95v 374.745n 0.95v 374.755n 0.95v 379.745n 0.95v 379.755n 0.0v 384.745n 0.0v 384.755n 0.0v 389.745n 0.0v 389.755n 0.0v 394.745n 0.0v 394.755n 0.95v 399.745n 0.95v 399.755n 0.0v 404.745n 0.0v 404.755n 0.0v 409.745n 0.0v 409.755n 0.95v 414.745n 0.95v 414.755n 0.95v 419.745n 0.95v 419.755n 0.95v 424.745n 0.95v 424.755n 0.0v 429.745n 0.0v 429.755n 0.0v 434.745n 0.0v 434.755n 0.0v 439.745n 0.0v 439.755n 0.0v 444.745n 0.0v 444.755n 0.95v 449.745n 0.95v 449.755n 0.95v 454.745n 0.95v 454.755n 0.95v 459.745n 0.95v 459.755n 0.0v 464.745n 0.0v 464.755n 0.0v 469.745n 0.0v 469.755n 0.95v 474.745n 0.95v 474.755n 0.0v 479.745n 0.0v 479.755n 0.95v 484.745n 0.95v 484.755n 0.0v 489.745n 0.0v 489.755n 0.0v 494.745n 0.0v 494.755n 0.95v 499.745n 0.95v 499.755n 0.95v 504.745n 0.95v 504.755n 0.0v 509.745n 0.0v 509.755n 0.0v 514.745n 0.0v 514.755n 0.0v 519.745n 0.0v 519.755n 0.95v 524.745n 0.95v 524.755n 0.95v 529.745n 0.95v 529.755n 0.0v 534.745n 0.0v 534.755n 0.0v 539.745n 0.0v 539.755n 0.95v 544.745n 0.95v 544.755n 0.0v 549.745n 0.0v 549.755n 0.0v 554.745n 0.0v 554.755n 0.95v 559.745n 0.95v 559.755n 0.95v 564.745n 0.95v 564.755n 0.95v 569.745n 0.95v 569.755n 0.95v 574.745n 0.95v 574.755n 0.95v 579.745n 0.95v 579.755n 0.0v 584.745n 0.0v 584.755n 0.0v 589.745n 0.0v 589.755n 0.95v 594.745n 0.95v 594.755n 0.0v 599.745n 0.0v 599.755n 0.0v 604.745n 0.0v 604.755n 0.0v 609.745n 0.0v 609.755n 0.0v 614.745n 0.0v 614.755n 0.95v 619.745n 0.95v 619.755n 0.95v 624.745n 0.95v 624.755n 0.0v 629.745n 0.0v 629.755n 0.0v 634.745n 0.0v 634.755n 0.0v 639.745n 0.0v 639.755n 0.0v 644.745n 0.0v 644.755n 0.0v 649.745n 0.0v 649.755n 0.95v 654.745n 0.95v 654.755n 0.95v 659.745n 0.95v 659.755n 0.0v 664.745n 0.0v 664.755n 0.0v 669.745n 0.0v 669.755n 0.95v 674.745n 0.95v 674.755n 0.0v 679.745n 0.0v 679.755n 0.0v 684.745n 0.0v 684.755n 0.0v 689.745n 0.0v 689.755n 0.0v 694.745n 0.0v 694.755n 0.95v 699.745n 0.95v 699.755n 0.95v 704.745n 0.95v 704.755n 0.95v 709.745n 0.95v 709.755n 0.0v 714.745n 0.0v 714.755n 0.0v 719.745n 0.0v 719.755n 0.0v 724.745n 0.0v 724.755n 0.95v 729.745n 0.95v 729.755n 0.0v 734.745n 0.0v 734.755n 0.0v 739.745n 0.0v 739.755n 0.0v 744.745n 0.0v 744.755n 0.0v 749.745n 0.0v 749.755n 0.0v 754.745n 0.0v 754.755n 0.0v 759.745n 0.0v 759.755n 0.0v 764.745n 0.0v 764.755n 0.0v 769.745n 0.0v 769.755n 0.0v 774.745n 0.0v 774.755n 0.0v 779.745n 0.0v 779.755n 0.0v 784.745n 0.0v 784.755n 0.0v 789.745n 0.0v 789.755n 0.95v 794.745n 0.95v 794.755n 0.95v 799.745n 0.95v 799.755n 0.0v 804.745n 0.0v 804.755n 0.95v 809.745n 0.95v 809.755n 0.95v 814.745n 0.95v 814.755n 0.95v 819.745n 0.95v 819.755n 0.0v 824.745n 0.0v 824.755n 0.0v 829.745n 0.0v 829.755n 0.0v 834.745n 0.0v 834.755n 0.0v 839.745n 0.0v 839.755n 0.0v 844.745n 0.0v 844.755n 0.0v 849.745n 0.0v 849.755n 0.95v 854.745n 0.95v 854.755n 0.95v 859.745n 0.95v 859.755n 0.95v 864.745n 0.95v 864.755n 0.0v 869.745n 0.0v 869.755n 0.95v 874.745n 0.95v 874.755n 0.0v 879.745n 0.0v 879.755n 0.95v 884.745n 0.95v 884.755n 0.95v 889.745n 0.95v 889.755n 0.95v 894.745n 0.95v 894.755n 0.95v 899.745n 0.95v 899.755n 0.95v 904.745n 0.95v 904.755n 0.95v 909.745n 0.95v 909.755n 0.0v 914.745n 0.0v 914.755n 0.95v 919.745n 0.95v 919.755n 0.0v 924.745n 0.0v 924.755n 0.0v 929.745n 0.0v 929.755n 0.95v 934.745n 0.95v 934.755n 0.0v 939.745n 0.0v 939.755n 0.0v 944.745n 0.0v 944.755n 0.0v 949.745n 0.0v 949.755n 0.0v 954.745n 0.0v 954.755n 0.95v 959.745n 0.95v 959.755n 0.95v 964.745n 0.95v 964.755n 0.0v 969.745n 0.0v 969.755n 0.0v 974.745n 0.0v 974.755n 0.95v 979.745n 0.95v 979.755n 0.95v 984.745n 0.95v 984.755n 0.0v 989.745n 0.0v 989.755n 0.95v 994.745n 0.95v 994.755n 0.95v 999.745n 0.95v 999.755n 0.95v 1004.745n 0.95v 1004.755n 0.0v 1009.745n 0.0v 1009.755n 0.0v 1014.745n 0.0v 1014.755n 0.0v 1019.745n 0.0v 1019.755n 0.0v 1024.745n 0.0v 1024.755n 0.0v )
* (time, data): [(0, 0), (5, 1), (10, 0), (15, 1), (20, 0), (25, 0), (30, 0), (35, 0), (40, 0), (45, 0), (50, 1), (55, 0), (60, 1), (65, 0), (70, 0), (75, 1), (80, 1), (85, 0), (90, 0), (95, 1), (100, 1), (105, 0), (110, 0), (115, 0), (120, 1), (125, 1), (130, 1), (135, 1), (140, 0), (145, 1), (150, 1), (155, 1), (160, 0), (165, 0), (170, 0), (175, 1), (180, 1), (185, 1), (190, 1), (195, 0), (200, 1), (205, 1), (210, 1), (215, 1), (220, 1), (225, 1), (230, 1), (235, 0), (240, 0), (245, 0), (250, 0), (255, 0), (260, 1), (265, 1), (270, 0), (275, 0), (280, 0), (285, 0), (290, 0), (295, 1), (300, 1), (305, 1), (310, 1), (315, 0), (320, 0), (325, 0), (330, 1), (335, 0), (340, 0), (345, 1), (350, 1), (355, 0), (360, 1), (365, 0), (370, 1), (375, 1), (380, 0), (385, 0), (390, 0), (395, 1), (400, 0), (405, 0), (410, 1), (415, 1), (420, 1), (425, 0), (430, 0), (435, 0), (440, 0), (445, 1), (450, 1), (455, 1), (460, 0), (465, 0), (470, 1), (475, 0), (480, 1), (485, 0), (490, 0), (495, 1), (500, 1), (505, 0), (510, 0), (515, 0), (520, 1), (525, 1), (530, 0), (535, 0), (540, 1), (545, 0), (550, 0), (555, 1), (560, 1), (565, 1), (570, 1), (575, 1), (580, 0), (585, 0), (590, 1), (595, 0), (600, 0), (605, 0), (610, 0), (615, 1), (620, 1), (625, 0), (630, 0), (635, 0), (640, 0), (645, 0), (650, 1), (655, 1), (660, 0), (665, 0), (670, 1), (675, 0), (680, 0), (685, 0), (690, 0), (695, 1), (700, 1), (705, 1), (710, 0), (715, 0), (720, 0), (725, 1), (730, 0), (735, 0), (740, 0), (745, 0), (750, 0), (755, 0), (760, 0), (765, 0), (770, 0), (775, 0), (780, 0), (785, 0), (790, 1), (795, 1), (800, 0), (805, 1), (810, 1), (815, 1), (820, 0), (825, 0), (830, 0), (835, 0), (840, 0), (845, 0), (850, 1), (855, 1), (860, 1), (865, 0), (870, 1), (875, 0), (880, 1), (885, 1), (890, 1), (895, 1), (900, 1), (905, 1), (910, 0), (915, 1), (920, 0), (925, 0), (930, 1), (935, 0), (940, 0), (945, 0), (950, 0), (955, 1), (960, 1), (965, 0), (970, 0), (975, 1), (980, 1), (985, 0), (990, 1), (995, 1), (1000, 1), (1005, 0), (1010, 0), (1015, 0), (1020, 0), (1025, 0)]
Va0_8  a0_8  0 PWL (0n 0.0v 4.745n 0.0v 4.755n 0.95v 9.745n 0.95v 9.755n 0.0v 14.745n 0.0v 14.755n 0.95v 19.745n 0.95v 19.755n 0.0v 24.745n 0.0v 24.755n 0.0v 29.745n 0.0v 29.755n 0.0v 34.745n 0.0v 34.755n 0.0v 39.745n 0.0v 39.755n 0.0v 44.745n 0.0v 44.755n 0.0v 49.745n 0.0v 49.755n 0.95v 54.745n 0.95v 54.755n 0.0v 59.745n 0.0v 59.755n 0.95v 64.745n 0.95v 64.755n 0.0v 69.745n 0.0v 69.755n 0.0v 74.745n 0.0v 74.755n 0.95v 79.745n 0.95v 79.755n 0.95v 84.745n 0.95v 84.755n 0.0v 89.745n 0.0v 89.755n 0.0v 94.745n 0.0v 94.755n 0.95v 99.745n 0.95v 99.755n 0.95v 104.745n 0.95v 104.755n 0.0v 109.745n 0.0v 109.755n 0.0v 114.745n 0.0v 114.755n 0.0v 119.745n 0.0v 119.755n 0.95v 124.745n 0.95v 124.755n 0.95v 129.745n 0.95v 129.755n 0.95v 134.745n 0.95v 134.755n 0.95v 139.745n 0.95v 139.755n 0.0v 144.745n 0.0v 144.755n 0.95v 149.745n 0.95v 149.755n 0.95v 154.745n 0.95v 154.755n 0.95v 159.745n 0.95v 159.755n 0.0v 164.745n 0.0v 164.755n 0.0v 169.745n 0.0v 169.755n 0.0v 174.745n 0.0v 174.755n 0.95v 179.745n 0.95v 179.755n 0.95v 184.745n 0.95v 184.755n 0.95v 189.745n 0.95v 189.755n 0.95v 194.745n 0.95v 194.755n 0.0v 199.745n 0.0v 199.755n 0.95v 204.745n 0.95v 204.755n 0.95v 209.745n 0.95v 209.755n 0.95v 214.745n 0.95v 214.755n 0.95v 219.745n 0.95v 219.755n 0.95v 224.745n 0.95v 224.755n 0.95v 229.745n 0.95v 229.755n 0.95v 234.745n 0.95v 234.755n 0.0v 239.745n 0.0v 239.755n 0.0v 244.745n 0.0v 244.755n 0.0v 249.745n 0.0v 249.755n 0.0v 254.745n 0.0v 254.755n 0.0v 259.745n 0.0v 259.755n 0.95v 264.745n 0.95v 264.755n 0.95v 269.745n 0.95v 269.755n 0.0v 274.745n 0.0v 274.755n 0.0v 279.745n 0.0v 279.755n 0.0v 284.745n 0.0v 284.755n 0.0v 289.745n 0.0v 289.755n 0.0v 294.745n 0.0v 294.755n 0.95v 299.745n 0.95v 299.755n 0.95v 304.745n 0.95v 304.755n 0.95v 309.745n 0.95v 309.755n 0.95v 314.745n 0.95v 314.755n 0.0v 319.745n 0.0v 319.755n 0.0v 324.745n 0.0v 324.755n 0.0v 329.745n 0.0v 329.755n 0.95v 334.745n 0.95v 334.755n 0.0v 339.745n 0.0v 339.755n 0.0v 344.745n 0.0v 344.755n 0.95v 349.745n 0.95v 349.755n 0.95v 354.745n 0.95v 354.755n 0.0v 359.745n 0.0v 359.755n 0.95v 364.745n 0.95v 364.755n 0.0v 369.745n 0.0v 369.755n 0.95v 374.745n 0.95v 374.755n 0.95v 379.745n 0.95v 379.755n 0.0v 384.745n 0.0v 384.755n 0.0v 389.745n 0.0v 389.755n 0.0v 394.745n 0.0v 394.755n 0.95v 399.745n 0.95v 399.755n 0.0v 404.745n 0.0v 404.755n 0.0v 409.745n 0.0v 409.755n 0.95v 414.745n 0.95v 414.755n 0.95v 419.745n 0.95v 419.755n 0.95v 424.745n 0.95v 424.755n 0.0v 429.745n 0.0v 429.755n 0.0v 434.745n 0.0v 434.755n 0.0v 439.745n 0.0v 439.755n 0.0v 444.745n 0.0v 444.755n 0.95v 449.745n 0.95v 449.755n 0.95v 454.745n 0.95v 454.755n 0.95v 459.745n 0.95v 459.755n 0.0v 464.745n 0.0v 464.755n 0.0v 469.745n 0.0v 469.755n 0.95v 474.745n 0.95v 474.755n 0.0v 479.745n 0.0v 479.755n 0.95v 484.745n 0.95v 484.755n 0.0v 489.745n 0.0v 489.755n 0.0v 494.745n 0.0v 494.755n 0.95v 499.745n 0.95v 499.755n 0.95v 504.745n 0.95v 504.755n 0.0v 509.745n 0.0v 509.755n 0.0v 514.745n 0.0v 514.755n 0.0v 519.745n 0.0v 519.755n 0.95v 524.745n 0.95v 524.755n 0.95v 529.745n 0.95v 529.755n 0.0v 534.745n 0.0v 534.755n 0.0v 539.745n 0.0v 539.755n 0.95v 544.745n 0.95v 544.755n 0.0v 549.745n 0.0v 549.755n 0.0v 554.745n 0.0v 554.755n 0.95v 559.745n 0.95v 559.755n 0.95v 564.745n 0.95v 564.755n 0.95v 569.745n 0.95v 569.755n 0.95v 574.745n 0.95v 574.755n 0.95v 579.745n 0.95v 579.755n 0.0v 584.745n 0.0v 584.755n 0.0v 589.745n 0.0v 589.755n 0.95v 594.745n 0.95v 594.755n 0.0v 599.745n 0.0v 599.755n 0.0v 604.745n 0.0v 604.755n 0.0v 609.745n 0.0v 609.755n 0.0v 614.745n 0.0v 614.755n 0.95v 619.745n 0.95v 619.755n 0.95v 624.745n 0.95v 624.755n 0.0v 629.745n 0.0v 629.755n 0.0v 634.745n 0.0v 634.755n 0.0v 639.745n 0.0v 639.755n 0.0v 644.745n 0.0v 644.755n 0.0v 649.745n 0.0v 649.755n 0.95v 654.745n 0.95v 654.755n 0.95v 659.745n 0.95v 659.755n 0.0v 664.745n 0.0v 664.755n 0.0v 669.745n 0.0v 669.755n 0.95v 674.745n 0.95v 674.755n 0.0v 679.745n 0.0v 679.755n 0.0v 684.745n 0.0v 684.755n 0.0v 689.745n 0.0v 689.755n 0.0v 694.745n 0.0v 694.755n 0.95v 699.745n 0.95v 699.755n 0.95v 704.745n 0.95v 704.755n 0.95v 709.745n 0.95v 709.755n 0.0v 714.745n 0.0v 714.755n 0.0v 719.745n 0.0v 719.755n 0.0v 724.745n 0.0v 724.755n 0.95v 729.745n 0.95v 729.755n 0.0v 734.745n 0.0v 734.755n 0.0v 739.745n 0.0v 739.755n 0.0v 744.745n 0.0v 744.755n 0.0v 749.745n 0.0v 749.755n 0.0v 754.745n 0.0v 754.755n 0.0v 759.745n 0.0v 759.755n 0.0v 764.745n 0.0v 764.755n 0.0v 769.745n 0.0v 769.755n 0.0v 774.745n 0.0v 774.755n 0.0v 779.745n 0.0v 779.755n 0.0v 784.745n 0.0v 784.755n 0.0v 789.745n 0.0v 789.755n 0.95v 794.745n 0.95v 794.755n 0.95v 799.745n 0.95v 799.755n 0.0v 804.745n 0.0v 804.755n 0.95v 809.745n 0.95v 809.755n 0.95v 814.745n 0.95v 814.755n 0.95v 819.745n 0.95v 819.755n 0.0v 824.745n 0.0v 824.755n 0.0v 829.745n 0.0v 829.755n 0.0v 834.745n 0.0v 834.755n 0.0v 839.745n 0.0v 839.755n 0.0v 844.745n 0.0v 844.755n 0.0v 849.745n 0.0v 849.755n 0.95v 854.745n 0.95v 854.755n 0.95v 859.745n 0.95v 859.755n 0.95v 864.745n 0.95v 864.755n 0.0v 869.745n 0.0v 869.755n 0.95v 874.745n 0.95v 874.755n 0.0v 879.745n 0.0v 879.755n 0.95v 884.745n 0.95v 884.755n 0.95v 889.745n 0.95v 889.755n 0.95v 894.745n 0.95v 894.755n 0.95v 899.745n 0.95v 899.755n 0.95v 904.745n 0.95v 904.755n 0.95v 909.745n 0.95v 909.755n 0.0v 914.745n 0.0v 914.755n 0.95v 919.745n 0.95v 919.755n 0.0v 924.745n 0.0v 924.755n 0.0v 929.745n 0.0v 929.755n 0.95v 934.745n 0.95v 934.755n 0.0v 939.745n 0.0v 939.755n 0.0v 944.745n 0.0v 944.755n 0.0v 949.745n 0.0v 949.755n 0.0v 954.745n 0.0v 954.755n 0.95v 959.745n 0.95v 959.755n 0.95v 964.745n 0.95v 964.755n 0.0v 969.745n 0.0v 969.755n 0.0v 974.745n 0.0v 974.755n 0.95v 979.745n 0.95v 979.755n 0.95v 984.745n 0.95v 984.755n 0.0v 989.745n 0.0v 989.755n 0.95v 994.745n 0.95v 994.755n 0.95v 999.745n 0.95v 999.755n 0.95v 1004.745n 0.95v 1004.755n 0.0v 1009.745n 0.0v 1009.755n 0.0v 1014.745n 0.0v 1014.755n 0.0v 1019.745n 0.0v 1019.755n 0.0v 1024.745n 0.0v 1024.755n 0.0v )

 * Generation of control signals
* (time, data): [(0, 1), (5, 0), (10, 0), (15, 0), (20, 0), (25, 0), (30, 0), (35, 0), (40, 0), (45, 0), (50, 0), (55, 0), (60, 0), (65, 0), (70, 0), (75, 0), (80, 0), (85, 0), (90, 0), (95, 0), (100, 1), (105, 0), (110, 1), (115, 0), (120, 0), (125, 0), (130, 0), (135, 1), (140, 0), (145, 0), (150, 1), (155, 0), (160, 0), (165, 0), (170, 0), (175, 0), (180, 0), (185, 0), (190, 1), (195, 0), (200, 0), (205, 1), (210, 1), (215, 1), (220, 0), (225, 1), (230, 0), (235, 0), (240, 1), (245, 0), (250, 1), (255, 0), (260, 0), (265, 0), (270, 0), (275, 1), (280, 0), (285, 0), (290, 1), (295, 0), (300, 0), (305, 1), (310, 0), (315, 0), (320, 1), (325, 1), (330, 0), (335, 0), (340, 0), (345, 0), (350, 0), (355, 0), (360, 0), (365, 0), (370, 0), (375, 0), (380, 0), (385, 0), (390, 0), (395, 0), (400, 0), (405, 0), (410, 0), (415, 1), (420, 0), (425, 0), (430, 0), (435, 0), (440, 0), (445, 0), (450, 1), (455, 0), (460, 0), (465, 0), (470, 0), (475, 0), (480, 0), (485, 0), (490, 0), (495, 0), (500, 0), (505, 0), (510, 1), (515, 0), (520, 0), (525, 0), (530, 0), (535, 0), (540, 0), (545, 0), (550, 1), (555, 0), (560, 0), (565, 0), (570, 1), (575, 1), (580, 0), (585, 1), (590, 0), (595, 0), (600, 1), (605, 0), (610, 0), (615, 0), (620, 0), (625, 0), (630, 0), (635, 1), (640, 0), (645, 0), (650, 0), (655, 1), (660, 0), (665, 1), (670, 0), (675, 0), (680, 0), (685, 0), (690, 1), (695, 0), (700, 1), (705, 1), (710, 0), (715, 0), (720, 0), (725, 0), (730, 0), (735, 0), (740, 0), (745, 0), (750, 0), (755, 0), (760, 0), (765, 0), (770, 0), (775, 0), (780, 0), (785, 0), (790, 0), (795, 1), (800, 0), (805, 0), (810, 0), (815, 1), (820, 0), (825, 0), (830, 1), (835, 0), (840, 0), (845, 0), (850, 0), (855, 0), (860, 0), (865, 0), (870, 0), (875, 0), (880, 0), (885, 0), (890, 0), (895, 0), (900, 1), (905, 0), (910, 0), (915, 0), (920, 0), (925, 0), (930, 0), (935, 0), (940, 0), (945, 1), (950, 0), (955, 0), (960, 0), (965, 0), (970, 0), (975, 0), (980, 0), (985, 0), (990, 0), (995, 0), (1000, 1), (1005, 0), (1010, 1), (1015, 1), (1020, 1), (1025, 1)]
VCSB0 CSB0 0 PWL (0n 0.95v 4.745n 0.95v 4.755n 0.0v 9.745n 0.0v 9.755n 0.0v 14.745n 0.0v 14.755n 0.0v 19.745n 0.0v 19.755n 0.0v 24.745n 0.0v 24.755n 0.0v 29.745n 0.0v 29.755n 0.0v 34.745n 0.0v 34.755n 0.0v 39.745n 0.0v 39.755n 0.0v 44.745n 0.0v 44.755n 0.0v 49.745n 0.0v 49.755n 0.0v 54.745n 0.0v 54.755n 0.0v 59.745n 0.0v 59.755n 0.0v 64.745n 0.0v 64.755n 0.0v 69.745n 0.0v 69.755n 0.0v 74.745n 0.0v 74.755n 0.0v 79.745n 0.0v 79.755n 0.0v 84.745n 0.0v 84.755n 0.0v 89.745n 0.0v 89.755n 0.0v 94.745n 0.0v 94.755n 0.0v 99.745n 0.0v 99.755n 0.95v 104.745n 0.95v 104.755n 0.0v 109.745n 0.0v 109.755n 0.95v 114.745n 0.95v 114.755n 0.0v 119.745n 0.0v 119.755n 0.0v 124.745n 0.0v 124.755n 0.0v 129.745n 0.0v 129.755n 0.0v 134.745n 0.0v 134.755n 0.95v 139.745n 0.95v 139.755n 0.0v 144.745n 0.0v 144.755n 0.0v 149.745n 0.0v 149.755n 0.95v 154.745n 0.95v 154.755n 0.0v 159.745n 0.0v 159.755n 0.0v 164.745n 0.0v 164.755n 0.0v 169.745n 0.0v 169.755n 0.0v 174.745n 0.0v 174.755n 0.0v 179.745n 0.0v 179.755n 0.0v 184.745n 0.0v 184.755n 0.0v 189.745n 0.0v 189.755n 0.95v 194.745n 0.95v 194.755n 0.0v 199.745n 0.0v 199.755n 0.0v 204.745n 0.0v 204.755n 0.95v 209.745n 0.95v 209.755n 0.95v 214.745n 0.95v 214.755n 0.95v 219.745n 0.95v 219.755n 0.0v 224.745n 0.0v 224.755n 0.95v 229.745n 0.95v 229.755n 0.0v 234.745n 0.0v 234.755n 0.0v 239.745n 0.0v 239.755n 0.95v 244.745n 0.95v 244.755n 0.0v 249.745n 0.0v 249.755n 0.95v 254.745n 0.95v 254.755n 0.0v 259.745n 0.0v 259.755n 0.0v 264.745n 0.0v 264.755n 0.0v 269.745n 0.0v 269.755n 0.0v 274.745n 0.0v 274.755n 0.95v 279.745n 0.95v 279.755n 0.0v 284.745n 0.0v 284.755n 0.0v 289.745n 0.0v 289.755n 0.95v 294.745n 0.95v 294.755n 0.0v 299.745n 0.0v 299.755n 0.0v 304.745n 0.0v 304.755n 0.95v 309.745n 0.95v 309.755n 0.0v 314.745n 0.0v 314.755n 0.0v 319.745n 0.0v 319.755n 0.95v 324.745n 0.95v 324.755n 0.95v 329.745n 0.95v 329.755n 0.0v 334.745n 0.0v 334.755n 0.0v 339.745n 0.0v 339.755n 0.0v 344.745n 0.0v 344.755n 0.0v 349.745n 0.0v 349.755n 0.0v 354.745n 0.0v 354.755n 0.0v 359.745n 0.0v 359.755n 0.0v 364.745n 0.0v 364.755n 0.0v 369.745n 0.0v 369.755n 0.0v 374.745n 0.0v 374.755n 0.0v 379.745n 0.0v 379.755n 0.0v 384.745n 0.0v 384.755n 0.0v 389.745n 0.0v 389.755n 0.0v 394.745n 0.0v 394.755n 0.0v 399.745n 0.0v 399.755n 0.0v 404.745n 0.0v 404.755n 0.0v 409.745n 0.0v 409.755n 0.0v 414.745n 0.0v 414.755n 0.95v 419.745n 0.95v 419.755n 0.0v 424.745n 0.0v 424.755n 0.0v 429.745n 0.0v 429.755n 0.0v 434.745n 0.0v 434.755n 0.0v 439.745n 0.0v 439.755n 0.0v 444.745n 0.0v 444.755n 0.0v 449.745n 0.0v 449.755n 0.95v 454.745n 0.95v 454.755n 0.0v 459.745n 0.0v 459.755n 0.0v 464.745n 0.0v 464.755n 0.0v 469.745n 0.0v 469.755n 0.0v 474.745n 0.0v 474.755n 0.0v 479.745n 0.0v 479.755n 0.0v 484.745n 0.0v 484.755n 0.0v 489.745n 0.0v 489.755n 0.0v 494.745n 0.0v 494.755n 0.0v 499.745n 0.0v 499.755n 0.0v 504.745n 0.0v 504.755n 0.0v 509.745n 0.0v 509.755n 0.95v 514.745n 0.95v 514.755n 0.0v 519.745n 0.0v 519.755n 0.0v 524.745n 0.0v 524.755n 0.0v 529.745n 0.0v 529.755n 0.0v 534.745n 0.0v 534.755n 0.0v 539.745n 0.0v 539.755n 0.0v 544.745n 0.0v 544.755n 0.0v 549.745n 0.0v 549.755n 0.95v 554.745n 0.95v 554.755n 0.0v 559.745n 0.0v 559.755n 0.0v 564.745n 0.0v 564.755n 0.0v 569.745n 0.0v 569.755n 0.95v 574.745n 0.95v 574.755n 0.95v 579.745n 0.95v 579.755n 0.0v 584.745n 0.0v 584.755n 0.95v 589.745n 0.95v 589.755n 0.0v 594.745n 0.0v 594.755n 0.0v 599.745n 0.0v 599.755n 0.95v 604.745n 0.95v 604.755n 0.0v 609.745n 0.0v 609.755n 0.0v 614.745n 0.0v 614.755n 0.0v 619.745n 0.0v 619.755n 0.0v 624.745n 0.0v 624.755n 0.0v 629.745n 0.0v 629.755n 0.0v 634.745n 0.0v 634.755n 0.95v 639.745n 0.95v 639.755n 0.0v 644.745n 0.0v 644.755n 0.0v 649.745n 0.0v 649.755n 0.0v 654.745n 0.0v 654.755n 0.95v 659.745n 0.95v 659.755n 0.0v 664.745n 0.0v 664.755n 0.95v 669.745n 0.95v 669.755n 0.0v 674.745n 0.0v 674.755n 0.0v 679.745n 0.0v 679.755n 0.0v 684.745n 0.0v 684.755n 0.0v 689.745n 0.0v 689.755n 0.95v 694.745n 0.95v 694.755n 0.0v 699.745n 0.0v 699.755n 0.95v 704.745n 0.95v 704.755n 0.95v 709.745n 0.95v 709.755n 0.0v 714.745n 0.0v 714.755n 0.0v 719.745n 0.0v 719.755n 0.0v 724.745n 0.0v 724.755n 0.0v 729.745n 0.0v 729.755n 0.0v 734.745n 0.0v 734.755n 0.0v 739.745n 0.0v 739.755n 0.0v 744.745n 0.0v 744.755n 0.0v 749.745n 0.0v 749.755n 0.0v 754.745n 0.0v 754.755n 0.0v 759.745n 0.0v 759.755n 0.0v 764.745n 0.0v 764.755n 0.0v 769.745n 0.0v 769.755n 0.0v 774.745n 0.0v 774.755n 0.0v 779.745n 0.0v 779.755n 0.0v 784.745n 0.0v 784.755n 0.0v 789.745n 0.0v 789.755n 0.0v 794.745n 0.0v 794.755n 0.95v 799.745n 0.95v 799.755n 0.0v 804.745n 0.0v 804.755n 0.0v 809.745n 0.0v 809.755n 0.0v 814.745n 0.0v 814.755n 0.95v 819.745n 0.95v 819.755n 0.0v 824.745n 0.0v 824.755n 0.0v 829.745n 0.0v 829.755n 0.95v 834.745n 0.95v 834.755n 0.0v 839.745n 0.0v 839.755n 0.0v 844.745n 0.0v 844.755n 0.0v 849.745n 0.0v 849.755n 0.0v 854.745n 0.0v 854.755n 0.0v 859.745n 0.0v 859.755n 0.0v 864.745n 0.0v 864.755n 0.0v 869.745n 0.0v 869.755n 0.0v 874.745n 0.0v 874.755n 0.0v 879.745n 0.0v 879.755n 0.0v 884.745n 0.0v 884.755n 0.0v 889.745n 0.0v 889.755n 0.0v 894.745n 0.0v 894.755n 0.0v 899.745n 0.0v 899.755n 0.95v 904.745n 0.95v 904.755n 0.0v 909.745n 0.0v 909.755n 0.0v 914.745n 0.0v 914.755n 0.0v 919.745n 0.0v 919.755n 0.0v 924.745n 0.0v 924.755n 0.0v 929.745n 0.0v 929.755n 0.0v 934.745n 0.0v 934.755n 0.0v 939.745n 0.0v 939.755n 0.0v 944.745n 0.0v 944.755n 0.95v 949.745n 0.95v 949.755n 0.0v 954.745n 0.0v 954.755n 0.0v 959.745n 0.0v 959.755n 0.0v 964.745n 0.0v 964.755n 0.0v 969.745n 0.0v 969.755n 0.0v 974.745n 0.0v 974.755n 0.0v 979.745n 0.0v 979.755n 0.0v 984.745n 0.0v 984.755n 0.0v 989.745n 0.0v 989.755n 0.0v 994.745n 0.0v 994.755n 0.0v 999.745n 0.0v 999.755n 0.95v 1004.745n 0.95v 1004.755n 0.0v 1009.745n 0.0v 1009.755n 0.95v 1014.745n 0.95v 1014.755n 0.95v 1019.745n 0.95v 1019.755n 0.95v 1024.745n 0.95v 1024.755n 0.95v )
* (time, data): [(0, 1), (5, 0), (10, 0), (15, 0), (20, 1), (25, 0), (30, 0), (35, 0), (40, 0), (45, 0), (50, 0), (55, 1), (60, 0), (65, 0), (70, 1), (75, 0), (80, 0), (85, 0), (90, 1), (95, 0), (100, 1), (105, 0), (110, 1), (115, 0), (120, 1), (125, 0), (130, 0), (135, 1), (140, 1), (145, 1), (150, 1), (155, 1), (160, 1), (165, 0), (170, 1), (175, 1), (180, 0), (185, 0), (190, 1), (195, 1), (200, 0), (205, 1), (210, 1), (215, 1), (220, 1), (225, 1), (230, 0), (235, 1), (240, 1), (245, 0), (250, 1), (255, 1), (260, 1), (265, 0), (270, 0), (275, 1), (280, 1), (285, 0), (290, 1), (295, 1), (300, 0), (305, 1), (310, 1), (315, 0), (320, 1), (325, 1), (330, 1), (335, 1), (340, 1), (345, 0), (350, 1), (355, 1), (360, 0), (365, 0), (370, 1), (375, 1), (380, 1), (385, 1), (390, 0), (395, 1), (400, 1), (405, 1), (410, 0), (415, 1), (420, 1), (425, 0), (430, 1), (435, 0), (440, 0), (445, 0), (450, 1), (455, 1), (460, 0), (465, 0), (470, 1), (475, 0), (480, 0), (485, 0), (490, 0), (495, 1), (500, 0), (505, 1), (510, 1), (515, 1), (520, 0), (525, 1), (530, 0), (535, 0), (540, 0), (545, 1), (550, 1), (555, 0), (560, 0), (565, 1), (570, 1), (575, 1), (580, 1), (585, 1), (590, 1), (595, 0), (600, 1), (605, 1), (610, 1), (615, 1), (620, 1), (625, 1), (630, 1), (635, 1), (640, 0), (645, 0), (650, 1), (655, 1), (660, 1), (665, 1), (670, 0), (675, 0), (680, 1), (685, 0), (690, 1), (695, 1), (700, 1), (705, 1), (710, 1), (715, 1), (720, 0), (725, 1), (730, 0), (735, 0), (740, 1), (745, 0), (750, 1), (755, 1), (760, 1), (765, 0), (770, 1), (775, 1), (780, 1), (785, 1), (790, 1), (795, 1), (800, 0), (805, 1), (810, 1), (815, 1), (820, 1), (825, 1), (830, 1), (835, 1), (840, 0), (845, 0), (850, 0), (855, 0), (860, 1), (865, 0), (870, 0), (875, 1), (880, 1), (885, 0), (890, 0), (895, 1), (900, 1), (905, 0), (910, 0), (915, 1), (920, 0), (925, 0), (930, 1), (935, 0), (940, 1), (945, 1), (950, 0), (955, 0), (960, 1), (965, 1), (970, 0), (975, 1), (980, 0), (985, 0), (990, 0), (995, 1), (1000, 1), (1005, 0), (1010, 1), (1015, 1), (1020, 1), (1025, 1)]
VWEB0 WEB0 0 PWL (0n 0.95v 4.745n 0.95v 4.755n 0.0v 9.745n 0.0v 9.755n 0.0v 14.745n 0.0v 14.755n 0.0v 19.745n 0.0v 19.755n 0.95v 24.745n 0.95v 24.755n 0.0v 29.745n 0.0v 29.755n 0.0v 34.745n 0.0v 34.755n 0.0v 39.745n 0.0v 39.755n 0.0v 44.745n 0.0v 44.755n 0.0v 49.745n 0.0v 49.755n 0.0v 54.745n 0.0v 54.755n 0.95v 59.745n 0.95v 59.755n 0.0v 64.745n 0.0v 64.755n 0.0v 69.745n 0.0v 69.755n 0.95v 74.745n 0.95v 74.755n 0.0v 79.745n 0.0v 79.755n 0.0v 84.745n 0.0v 84.755n 0.0v 89.745n 0.0v 89.755n 0.95v 94.745n 0.95v 94.755n 0.0v 99.745n 0.0v 99.755n 0.95v 104.745n 0.95v 104.755n 0.0v 109.745n 0.0v 109.755n 0.95v 114.745n 0.95v 114.755n 0.0v 119.745n 0.0v 119.755n 0.95v 124.745n 0.95v 124.755n 0.0v 129.745n 0.0v 129.755n 0.0v 134.745n 0.0v 134.755n 0.95v 139.745n 0.95v 139.755n 0.95v 144.745n 0.95v 144.755n 0.95v 149.745n 0.95v 149.755n 0.95v 154.745n 0.95v 154.755n 0.95v 159.745n 0.95v 159.755n 0.95v 164.745n 0.95v 164.755n 0.0v 169.745n 0.0v 169.755n 0.95v 174.745n 0.95v 174.755n 0.95v 179.745n 0.95v 179.755n 0.0v 184.745n 0.0v 184.755n 0.0v 189.745n 0.0v 189.755n 0.95v 194.745n 0.95v 194.755n 0.95v 199.745n 0.95v 199.755n 0.0v 204.745n 0.0v 204.755n 0.95v 209.745n 0.95v 209.755n 0.95v 214.745n 0.95v 214.755n 0.95v 219.745n 0.95v 219.755n 0.95v 224.745n 0.95v 224.755n 0.95v 229.745n 0.95v 229.755n 0.0v 234.745n 0.0v 234.755n 0.95v 239.745n 0.95v 239.755n 0.95v 244.745n 0.95v 244.755n 0.0v 249.745n 0.0v 249.755n 0.95v 254.745n 0.95v 254.755n 0.95v 259.745n 0.95v 259.755n 0.95v 264.745n 0.95v 264.755n 0.0v 269.745n 0.0v 269.755n 0.0v 274.745n 0.0v 274.755n 0.95v 279.745n 0.95v 279.755n 0.95v 284.745n 0.95v 284.755n 0.0v 289.745n 0.0v 289.755n 0.95v 294.745n 0.95v 294.755n 0.95v 299.745n 0.95v 299.755n 0.0v 304.745n 0.0v 304.755n 0.95v 309.745n 0.95v 309.755n 0.95v 314.745n 0.95v 314.755n 0.0v 319.745n 0.0v 319.755n 0.95v 324.745n 0.95v 324.755n 0.95v 329.745n 0.95v 329.755n 0.95v 334.745n 0.95v 334.755n 0.95v 339.745n 0.95v 339.755n 0.95v 344.745n 0.95v 344.755n 0.0v 349.745n 0.0v 349.755n 0.95v 354.745n 0.95v 354.755n 0.95v 359.745n 0.95v 359.755n 0.0v 364.745n 0.0v 364.755n 0.0v 369.745n 0.0v 369.755n 0.95v 374.745n 0.95v 374.755n 0.95v 379.745n 0.95v 379.755n 0.95v 384.745n 0.95v 384.755n 0.95v 389.745n 0.95v 389.755n 0.0v 394.745n 0.0v 394.755n 0.95v 399.745n 0.95v 399.755n 0.95v 404.745n 0.95v 404.755n 0.95v 409.745n 0.95v 409.755n 0.0v 414.745n 0.0v 414.755n 0.95v 419.745n 0.95v 419.755n 0.95v 424.745n 0.95v 424.755n 0.0v 429.745n 0.0v 429.755n 0.95v 434.745n 0.95v 434.755n 0.0v 439.745n 0.0v 439.755n 0.0v 444.745n 0.0v 444.755n 0.0v 449.745n 0.0v 449.755n 0.95v 454.745n 0.95v 454.755n 0.95v 459.745n 0.95v 459.755n 0.0v 464.745n 0.0v 464.755n 0.0v 469.745n 0.0v 469.755n 0.95v 474.745n 0.95v 474.755n 0.0v 479.745n 0.0v 479.755n 0.0v 484.745n 0.0v 484.755n 0.0v 489.745n 0.0v 489.755n 0.0v 494.745n 0.0v 494.755n 0.95v 499.745n 0.95v 499.755n 0.0v 504.745n 0.0v 504.755n 0.95v 509.745n 0.95v 509.755n 0.95v 514.745n 0.95v 514.755n 0.95v 519.745n 0.95v 519.755n 0.0v 524.745n 0.0v 524.755n 0.95v 529.745n 0.95v 529.755n 0.0v 534.745n 0.0v 534.755n 0.0v 539.745n 0.0v 539.755n 0.0v 544.745n 0.0v 544.755n 0.95v 549.745n 0.95v 549.755n 0.95v 554.745n 0.95v 554.755n 0.0v 559.745n 0.0v 559.755n 0.0v 564.745n 0.0v 564.755n 0.95v 569.745n 0.95v 569.755n 0.95v 574.745n 0.95v 574.755n 0.95v 579.745n 0.95v 579.755n 0.95v 584.745n 0.95v 584.755n 0.95v 589.745n 0.95v 589.755n 0.95v 594.745n 0.95v 594.755n 0.0v 599.745n 0.0v 599.755n 0.95v 604.745n 0.95v 604.755n 0.95v 609.745n 0.95v 609.755n 0.95v 614.745n 0.95v 614.755n 0.95v 619.745n 0.95v 619.755n 0.95v 624.745n 0.95v 624.755n 0.95v 629.745n 0.95v 629.755n 0.95v 634.745n 0.95v 634.755n 0.95v 639.745n 0.95v 639.755n 0.0v 644.745n 0.0v 644.755n 0.0v 649.745n 0.0v 649.755n 0.95v 654.745n 0.95v 654.755n 0.95v 659.745n 0.95v 659.755n 0.95v 664.745n 0.95v 664.755n 0.95v 669.745n 0.95v 669.755n 0.0v 674.745n 0.0v 674.755n 0.0v 679.745n 0.0v 679.755n 0.95v 684.745n 0.95v 684.755n 0.0v 689.745n 0.0v 689.755n 0.95v 694.745n 0.95v 694.755n 0.95v 699.745n 0.95v 699.755n 0.95v 704.745n 0.95v 704.755n 0.95v 709.745n 0.95v 709.755n 0.95v 714.745n 0.95v 714.755n 0.95v 719.745n 0.95v 719.755n 0.0v 724.745n 0.0v 724.755n 0.95v 729.745n 0.95v 729.755n 0.0v 734.745n 0.0v 734.755n 0.0v 739.745n 0.0v 739.755n 0.95v 744.745n 0.95v 744.755n 0.0v 749.745n 0.0v 749.755n 0.95v 754.745n 0.95v 754.755n 0.95v 759.745n 0.95v 759.755n 0.95v 764.745n 0.95v 764.755n 0.0v 769.745n 0.0v 769.755n 0.95v 774.745n 0.95v 774.755n 0.95v 779.745n 0.95v 779.755n 0.95v 784.745n 0.95v 784.755n 0.95v 789.745n 0.95v 789.755n 0.95v 794.745n 0.95v 794.755n 0.95v 799.745n 0.95v 799.755n 0.0v 804.745n 0.0v 804.755n 0.95v 809.745n 0.95v 809.755n 0.95v 814.745n 0.95v 814.755n 0.95v 819.745n 0.95v 819.755n 0.95v 824.745n 0.95v 824.755n 0.95v 829.745n 0.95v 829.755n 0.95v 834.745n 0.95v 834.755n 0.95v 839.745n 0.95v 839.755n 0.0v 844.745n 0.0v 844.755n 0.0v 849.745n 0.0v 849.755n 0.0v 854.745n 0.0v 854.755n 0.0v 859.745n 0.0v 859.755n 0.95v 864.745n 0.95v 864.755n 0.0v 869.745n 0.0v 869.755n 0.0v 874.745n 0.0v 874.755n 0.95v 879.745n 0.95v 879.755n 0.95v 884.745n 0.95v 884.755n 0.0v 889.745n 0.0v 889.755n 0.0v 894.745n 0.0v 894.755n 0.95v 899.745n 0.95v 899.755n 0.95v 904.745n 0.95v 904.755n 0.0v 909.745n 0.0v 909.755n 0.0v 914.745n 0.0v 914.755n 0.95v 919.745n 0.95v 919.755n 0.0v 924.745n 0.0v 924.755n 0.0v 929.745n 0.0v 929.755n 0.95v 934.745n 0.95v 934.755n 0.0v 939.745n 0.0v 939.755n 0.95v 944.745n 0.95v 944.755n 0.95v 949.745n 0.95v 949.755n 0.0v 954.745n 0.0v 954.755n 0.0v 959.745n 0.0v 959.755n 0.95v 964.745n 0.95v 964.755n 0.95v 969.745n 0.95v 969.755n 0.0v 974.745n 0.0v 974.755n 0.95v 979.745n 0.95v 979.755n 0.0v 984.745n 0.0v 984.755n 0.0v 989.745n 0.0v 989.755n 0.0v 994.745n 0.0v 994.755n 0.95v 999.745n 0.95v 999.755n 0.95v 1004.745n 0.95v 1004.755n 0.0v 1009.745n 0.0v 1009.755n 0.95v 1014.745n 0.95v 1014.755n 0.95v 1019.745n 0.95v 1019.755n 0.95v 1024.745n 0.95v 1024.755n 0.95v )

* Generation of wmask signals
* (time, data): [(0, 0), (5, 1), (10, 1), (15, 1), (20, 1), (25, 1), (30, 1), (35, 1), (40, 1), (45, 1), (50, 0), (55, 0), (60, 0), (65, 1), (70, 1), (75, 1), (80, 1), (85, 1), (90, 1), (95, 0), (100, 0), (105, 1), (110, 1), (115, 1), (120, 1), (125, 1), (130, 1), (135, 1), (140, 1), (145, 1), (150, 1), (155, 1), (160, 1), (165, 1), (170, 1), (175, 1), (180, 1), (185, 1), (190, 1), (195, 1), (200, 1), (205, 1), (210, 1), (215, 1), (220, 1), (225, 1), (230, 1), (235, 1), (240, 1), (245, 1), (250, 1), (255, 1), (260, 1), (265, 1), (270, 1), (275, 1), (280, 1), (285, 1), (290, 1), (295, 1), (300, 1), (305, 1), (310, 1), (315, 1), (320, 1), (325, 1), (330, 1), (335, 1), (340, 1), (345, 0), (350, 0), (355, 0), (360, 1), (365, 0), (370, 0), (375, 0), (380, 0), (385, 0), (390, 1), (395, 1), (400, 1), (405, 1), (410, 0), (415, 0), (420, 0), (425, 1), (430, 1), (435, 0), (440, 0), (445, 1), (450, 1), (455, 1), (460, 1), (465, 0), (470, 0), (475, 1), (480, 0), (485, 1), (490, 1), (495, 1), (500, 1), (505, 1), (510, 1), (515, 1), (520, 1), (525, 1), (530, 1), (535, 0), (540, 1), (545, 1), (550, 1), (555, 0), (560, 1), (565, 1), (570, 1), (575, 1), (580, 1), (585, 1), (590, 1), (595, 1), (600, 1), (605, 1), (610, 1), (615, 1), (620, 1), (625, 1), (630, 1), (635, 1), (640, 1), (645, 1), (650, 1), (655, 1), (660, 1), (665, 1), (670, 1), (675, 1), (680, 1), (685, 1), (690, 1), (695, 1), (700, 1), (705, 1), (710, 1), (715, 1), (720, 0), (725, 0), (730, 1), (735, 1), (740, 1), (745, 1), (750, 1), (755, 1), (760, 1), (765, 1), (770, 1), (775, 1), (780, 1), (785, 1), (790, 1), (795, 1), (800, 1), (805, 1), (810, 1), (815, 1), (820, 1), (825, 1), (830, 1), (835, 1), (840, 0), (845, 0), (850, 0), (855, 1), (860, 1), (865, 1), (870, 1), (875, 1), (880, 1), (885, 0), (890, 1), (895, 1), (900, 1), (905, 1), (910, 1), (915, 1), (920, 0), (925, 0), (930, 0), (935, 1), (940, 1), (945, 1), (950, 0), (955, 0), (960, 0), (965, 0), (970, 0), (975, 0), (980, 1), (985, 1), (990, 1), (995, 1), (1000, 1), (1005, 1), (1010, 1), (1015, 1), (1020, 1), (1025, 1)]
VWMASK0_0  WMASK0_0  0 PWL (0n 0.0v 4.745n 0.0v 4.755n 0.95v 9.745n 0.95v 9.755n 0.95v 14.745n 0.95v 14.755n 0.95v 19.745n 0.95v 19.755n 0.95v 24.745n 0.95v 24.755n 0.95v 29.745n 0.95v 29.755n 0.95v 34.745n 0.95v 34.755n 0.95v 39.745n 0.95v 39.755n 0.95v 44.745n 0.95v 44.755n 0.95v 49.745n 0.95v 49.755n 0.0v 54.745n 0.0v 54.755n 0.0v 59.745n 0.0v 59.755n 0.0v 64.745n 0.0v 64.755n 0.95v 69.745n 0.95v 69.755n 0.95v 74.745n 0.95v 74.755n 0.95v 79.745n 0.95v 79.755n 0.95v 84.745n 0.95v 84.755n 0.95v 89.745n 0.95v 89.755n 0.95v 94.745n 0.95v 94.755n 0.0v 99.745n 0.0v 99.755n 0.0v 104.745n 0.0v 104.755n 0.95v 109.745n 0.95v 109.755n 0.95v 114.745n 0.95v 114.755n 0.95v 119.745n 0.95v 119.755n 0.95v 124.745n 0.95v 124.755n 0.95v 129.745n 0.95v 129.755n 0.95v 134.745n 0.95v 134.755n 0.95v 139.745n 0.95v 139.755n 0.95v 144.745n 0.95v 144.755n 0.95v 149.745n 0.95v 149.755n 0.95v 154.745n 0.95v 154.755n 0.95v 159.745n 0.95v 159.755n 0.95v 164.745n 0.95v 164.755n 0.95v 169.745n 0.95v 169.755n 0.95v 174.745n 0.95v 174.755n 0.95v 179.745n 0.95v 179.755n 0.95v 184.745n 0.95v 184.755n 0.95v 189.745n 0.95v 189.755n 0.95v 194.745n 0.95v 194.755n 0.95v 199.745n 0.95v 199.755n 0.95v 204.745n 0.95v 204.755n 0.95v 209.745n 0.95v 209.755n 0.95v 214.745n 0.95v 214.755n 0.95v 219.745n 0.95v 219.755n 0.95v 224.745n 0.95v 224.755n 0.95v 229.745n 0.95v 229.755n 0.95v 234.745n 0.95v 234.755n 0.95v 239.745n 0.95v 239.755n 0.95v 244.745n 0.95v 244.755n 0.95v 249.745n 0.95v 249.755n 0.95v 254.745n 0.95v 254.755n 0.95v 259.745n 0.95v 259.755n 0.95v 264.745n 0.95v 264.755n 0.95v 269.745n 0.95v 269.755n 0.95v 274.745n 0.95v 274.755n 0.95v 279.745n 0.95v 279.755n 0.95v 284.745n 0.95v 284.755n 0.95v 289.745n 0.95v 289.755n 0.95v 294.745n 0.95v 294.755n 0.95v 299.745n 0.95v 299.755n 0.95v 304.745n 0.95v 304.755n 0.95v 309.745n 0.95v 309.755n 0.95v 314.745n 0.95v 314.755n 0.95v 319.745n 0.95v 319.755n 0.95v 324.745n 0.95v 324.755n 0.95v 329.745n 0.95v 329.755n 0.95v 334.745n 0.95v 334.755n 0.95v 339.745n 0.95v 339.755n 0.95v 344.745n 0.95v 344.755n 0.0v 349.745n 0.0v 349.755n 0.0v 354.745n 0.0v 354.755n 0.0v 359.745n 0.0v 359.755n 0.95v 364.745n 0.95v 364.755n 0.0v 369.745n 0.0v 369.755n 0.0v 374.745n 0.0v 374.755n 0.0v 379.745n 0.0v 379.755n 0.0v 384.745n 0.0v 384.755n 0.0v 389.745n 0.0v 389.755n 0.95v 394.745n 0.95v 394.755n 0.95v 399.745n 0.95v 399.755n 0.95v 404.745n 0.95v 404.755n 0.95v 409.745n 0.95v 409.755n 0.0v 414.745n 0.0v 414.755n 0.0v 419.745n 0.0v 419.755n 0.0v 424.745n 0.0v 424.755n 0.95v 429.745n 0.95v 429.755n 0.95v 434.745n 0.95v 434.755n 0.0v 439.745n 0.0v 439.755n 0.0v 444.745n 0.0v 444.755n 0.95v 449.745n 0.95v 449.755n 0.95v 454.745n 0.95v 454.755n 0.95v 459.745n 0.95v 459.755n 0.95v 464.745n 0.95v 464.755n 0.0v 469.745n 0.0v 469.755n 0.0v 474.745n 0.0v 474.755n 0.95v 479.745n 0.95v 479.755n 0.0v 484.745n 0.0v 484.755n 0.95v 489.745n 0.95v 489.755n 0.95v 494.745n 0.95v 494.755n 0.95v 499.745n 0.95v 499.755n 0.95v 504.745n 0.95v 504.755n 0.95v 509.745n 0.95v 509.755n 0.95v 514.745n 0.95v 514.755n 0.95v 519.745n 0.95v 519.755n 0.95v 524.745n 0.95v 524.755n 0.95v 529.745n 0.95v 529.755n 0.95v 534.745n 0.95v 534.755n 0.0v 539.745n 0.0v 539.755n 0.95v 544.745n 0.95v 544.755n 0.95v 549.745n 0.95v 549.755n 0.95v 554.745n 0.95v 554.755n 0.0v 559.745n 0.0v 559.755n 0.95v 564.745n 0.95v 564.755n 0.95v 569.745n 0.95v 569.755n 0.95v 574.745n 0.95v 574.755n 0.95v 579.745n 0.95v 579.755n 0.95v 584.745n 0.95v 584.755n 0.95v 589.745n 0.95v 589.755n 0.95v 594.745n 0.95v 594.755n 0.95v 599.745n 0.95v 599.755n 0.95v 604.745n 0.95v 604.755n 0.95v 609.745n 0.95v 609.755n 0.95v 614.745n 0.95v 614.755n 0.95v 619.745n 0.95v 619.755n 0.95v 624.745n 0.95v 624.755n 0.95v 629.745n 0.95v 629.755n 0.95v 634.745n 0.95v 634.755n 0.95v 639.745n 0.95v 639.755n 0.95v 644.745n 0.95v 644.755n 0.95v 649.745n 0.95v 649.755n 0.95v 654.745n 0.95v 654.755n 0.95v 659.745n 0.95v 659.755n 0.95v 664.745n 0.95v 664.755n 0.95v 669.745n 0.95v 669.755n 0.95v 674.745n 0.95v 674.755n 0.95v 679.745n 0.95v 679.755n 0.95v 684.745n 0.95v 684.755n 0.95v 689.745n 0.95v 689.755n 0.95v 694.745n 0.95v 694.755n 0.95v 699.745n 0.95v 699.755n 0.95v 704.745n 0.95v 704.755n 0.95v 709.745n 0.95v 709.755n 0.95v 714.745n 0.95v 714.755n 0.95v 719.745n 0.95v 719.755n 0.0v 724.745n 0.0v 724.755n 0.0v 729.745n 0.0v 729.755n 0.95v 734.745n 0.95v 734.755n 0.95v 739.745n 0.95v 739.755n 0.95v 744.745n 0.95v 744.755n 0.95v 749.745n 0.95v 749.755n 0.95v 754.745n 0.95v 754.755n 0.95v 759.745n 0.95v 759.755n 0.95v 764.745n 0.95v 764.755n 0.95v 769.745n 0.95v 769.755n 0.95v 774.745n 0.95v 774.755n 0.95v 779.745n 0.95v 779.755n 0.95v 784.745n 0.95v 784.755n 0.95v 789.745n 0.95v 789.755n 0.95v 794.745n 0.95v 794.755n 0.95v 799.745n 0.95v 799.755n 0.95v 804.745n 0.95v 804.755n 0.95v 809.745n 0.95v 809.755n 0.95v 814.745n 0.95v 814.755n 0.95v 819.745n 0.95v 819.755n 0.95v 824.745n 0.95v 824.755n 0.95v 829.745n 0.95v 829.755n 0.95v 834.745n 0.95v 834.755n 0.95v 839.745n 0.95v 839.755n 0.0v 844.745n 0.0v 844.755n 0.0v 849.745n 0.0v 849.755n 0.0v 854.745n 0.0v 854.755n 0.95v 859.745n 0.95v 859.755n 0.95v 864.745n 0.95v 864.755n 0.95v 869.745n 0.95v 869.755n 0.95v 874.745n 0.95v 874.755n 0.95v 879.745n 0.95v 879.755n 0.95v 884.745n 0.95v 884.755n 0.0v 889.745n 0.0v 889.755n 0.95v 894.745n 0.95v 894.755n 0.95v 899.745n 0.95v 899.755n 0.95v 904.745n 0.95v 904.755n 0.95v 909.745n 0.95v 909.755n 0.95v 914.745n 0.95v 914.755n 0.95v 919.745n 0.95v 919.755n 0.0v 924.745n 0.0v 924.755n 0.0v 929.745n 0.0v 929.755n 0.0v 934.745n 0.0v 934.755n 0.95v 939.745n 0.95v 939.755n 0.95v 944.745n 0.95v 944.755n 0.95v 949.745n 0.95v 949.755n 0.0v 954.745n 0.0v 954.755n 0.0v 959.745n 0.0v 959.755n 0.0v 964.745n 0.0v 964.755n 0.0v 969.745n 0.0v 969.755n 0.0v 974.745n 0.0v 974.755n 0.0v 979.745n 0.0v 979.755n 0.95v 984.745n 0.95v 984.755n 0.95v 989.745n 0.95v 989.755n 0.95v 994.745n 0.95v 994.755n 0.95v 999.745n 0.95v 999.755n 0.95v 1004.745n 0.95v 1004.755n 0.95v 1009.745n 0.95v 1009.755n 0.95v 1014.745n 0.95v 1014.755n 0.95v 1019.745n 0.95v 1019.755n 0.95v 1024.745n 0.95v 1024.755n 0.95v )
* (time, data): [(0, 0), (5, 1), (10, 1), (15, 1), (20, 1), (25, 1), (30, 0), (35, 1), (40, 1), (45, 1), (50, 1), (55, 1), (60, 1), (65, 1), (70, 1), (75, 1), (80, 1), (85, 1), (90, 1), (95, 1), (100, 1), (105, 1), (110, 1), (115, 1), (120, 1), (125, 1), (130, 1), (135, 1), (140, 1), (145, 1), (150, 1), (155, 1), (160, 1), (165, 1), (170, 1), (175, 1), (180, 1), (185, 1), (190, 1), (195, 1), (200, 1), (205, 1), (210, 1), (215, 1), (220, 1), (225, 1), (230, 1), (235, 1), (240, 1), (245, 1), (250, 1), (255, 1), (260, 1), (265, 0), (270, 1), (275, 1), (280, 1), (285, 1), (290, 1), (295, 1), (300, 1), (305, 1), (310, 1), (315, 0), (320, 0), (325, 0), (330, 0), (335, 0), (340, 0), (345, 0), (350, 0), (355, 0), (360, 1), (365, 0), (370, 0), (375, 0), (380, 0), (385, 0), (390, 1), (395, 1), (400, 1), (405, 1), (410, 1), (415, 1), (420, 1), (425, 1), (430, 1), (435, 1), (440, 1), (445, 1), (450, 1), (455, 1), (460, 1), (465, 1), (470, 1), (475, 0), (480, 1), (485, 1), (490, 0), (495, 0), (500, 1), (505, 1), (510, 1), (515, 1), (520, 1), (525, 1), (530, 1), (535, 1), (540, 1), (545, 1), (550, 1), (555, 1), (560, 1), (565, 1), (570, 1), (575, 1), (580, 1), (585, 1), (590, 1), (595, 1), (600, 1), (605, 1), (610, 1), (615, 1), (620, 1), (625, 1), (630, 1), (635, 1), (640, 0), (645, 0), (650, 0), (655, 0), (660, 0), (665, 0), (670, 1), (675, 1), (680, 1), (685, 1), (690, 1), (695, 1), (700, 1), (705, 1), (710, 1), (715, 1), (720, 1), (725, 1), (730, 1), (735, 1), (740, 1), (745, 0), (750, 0), (755, 0), (760, 0), (765, 1), (770, 1), (775, 1), (780, 1), (785, 1), (790, 1), (795, 1), (800, 1), (805, 1), (810, 1), (815, 1), (820, 1), (825, 1), (830, 1), (835, 1), (840, 1), (845, 1), (850, 0), (855, 1), (860, 1), (865, 1), (870, 1), (875, 1), (880, 1), (885, 1), (890, 1), (895, 1), (900, 1), (905, 1), (910, 1), (915, 1), (920, 1), (925, 0), (930, 0), (935, 1), (940, 1), (945, 1), (950, 0), (955, 0), (960, 0), (965, 0), (970, 1), (975, 1), (980, 1), (985, 1), (990, 1), (995, 1), (1000, 1), (1005, 1), (1010, 1), (1015, 1), (1020, 1), (1025, 1)]
VWMASK0_1  WMASK0_1  0 PWL (0n 0.0v 4.745n 0.0v 4.755n 0.95v 9.745n 0.95v 9.755n 0.95v 14.745n 0.95v 14.755n 0.95v 19.745n 0.95v 19.755n 0.95v 24.745n 0.95v 24.755n 0.95v 29.745n 0.95v 29.755n 0.0v 34.745n 0.0v 34.755n 0.95v 39.745n 0.95v 39.755n 0.95v 44.745n 0.95v 44.755n 0.95v 49.745n 0.95v 49.755n 0.95v 54.745n 0.95v 54.755n 0.95v 59.745n 0.95v 59.755n 0.95v 64.745n 0.95v 64.755n 0.95v 69.745n 0.95v 69.755n 0.95v 74.745n 0.95v 74.755n 0.95v 79.745n 0.95v 79.755n 0.95v 84.745n 0.95v 84.755n 0.95v 89.745n 0.95v 89.755n 0.95v 94.745n 0.95v 94.755n 0.95v 99.745n 0.95v 99.755n 0.95v 104.745n 0.95v 104.755n 0.95v 109.745n 0.95v 109.755n 0.95v 114.745n 0.95v 114.755n 0.95v 119.745n 0.95v 119.755n 0.95v 124.745n 0.95v 124.755n 0.95v 129.745n 0.95v 129.755n 0.95v 134.745n 0.95v 134.755n 0.95v 139.745n 0.95v 139.755n 0.95v 144.745n 0.95v 144.755n 0.95v 149.745n 0.95v 149.755n 0.95v 154.745n 0.95v 154.755n 0.95v 159.745n 0.95v 159.755n 0.95v 164.745n 0.95v 164.755n 0.95v 169.745n 0.95v 169.755n 0.95v 174.745n 0.95v 174.755n 0.95v 179.745n 0.95v 179.755n 0.95v 184.745n 0.95v 184.755n 0.95v 189.745n 0.95v 189.755n 0.95v 194.745n 0.95v 194.755n 0.95v 199.745n 0.95v 199.755n 0.95v 204.745n 0.95v 204.755n 0.95v 209.745n 0.95v 209.755n 0.95v 214.745n 0.95v 214.755n 0.95v 219.745n 0.95v 219.755n 0.95v 224.745n 0.95v 224.755n 0.95v 229.745n 0.95v 229.755n 0.95v 234.745n 0.95v 234.755n 0.95v 239.745n 0.95v 239.755n 0.95v 244.745n 0.95v 244.755n 0.95v 249.745n 0.95v 249.755n 0.95v 254.745n 0.95v 254.755n 0.95v 259.745n 0.95v 259.755n 0.95v 264.745n 0.95v 264.755n 0.0v 269.745n 0.0v 269.755n 0.95v 274.745n 0.95v 274.755n 0.95v 279.745n 0.95v 279.755n 0.95v 284.745n 0.95v 284.755n 0.95v 289.745n 0.95v 289.755n 0.95v 294.745n 0.95v 294.755n 0.95v 299.745n 0.95v 299.755n 0.95v 304.745n 0.95v 304.755n 0.95v 309.745n 0.95v 309.755n 0.95v 314.745n 0.95v 314.755n 0.0v 319.745n 0.0v 319.755n 0.0v 324.745n 0.0v 324.755n 0.0v 329.745n 0.0v 329.755n 0.0v 334.745n 0.0v 334.755n 0.0v 339.745n 0.0v 339.755n 0.0v 344.745n 0.0v 344.755n 0.0v 349.745n 0.0v 349.755n 0.0v 354.745n 0.0v 354.755n 0.0v 359.745n 0.0v 359.755n 0.95v 364.745n 0.95v 364.755n 0.0v 369.745n 0.0v 369.755n 0.0v 374.745n 0.0v 374.755n 0.0v 379.745n 0.0v 379.755n 0.0v 384.745n 0.0v 384.755n 0.0v 389.745n 0.0v 389.755n 0.95v 394.745n 0.95v 394.755n 0.95v 399.745n 0.95v 399.755n 0.95v 404.745n 0.95v 404.755n 0.95v 409.745n 0.95v 409.755n 0.95v 414.745n 0.95v 414.755n 0.95v 419.745n 0.95v 419.755n 0.95v 424.745n 0.95v 424.755n 0.95v 429.745n 0.95v 429.755n 0.95v 434.745n 0.95v 434.755n 0.95v 439.745n 0.95v 439.755n 0.95v 444.745n 0.95v 444.755n 0.95v 449.745n 0.95v 449.755n 0.95v 454.745n 0.95v 454.755n 0.95v 459.745n 0.95v 459.755n 0.95v 464.745n 0.95v 464.755n 0.95v 469.745n 0.95v 469.755n 0.95v 474.745n 0.95v 474.755n 0.0v 479.745n 0.0v 479.755n 0.95v 484.745n 0.95v 484.755n 0.95v 489.745n 0.95v 489.755n 0.0v 494.745n 0.0v 494.755n 0.0v 499.745n 0.0v 499.755n 0.95v 504.745n 0.95v 504.755n 0.95v 509.745n 0.95v 509.755n 0.95v 514.745n 0.95v 514.755n 0.95v 519.745n 0.95v 519.755n 0.95v 524.745n 0.95v 524.755n 0.95v 529.745n 0.95v 529.755n 0.95v 534.745n 0.95v 534.755n 0.95v 539.745n 0.95v 539.755n 0.95v 544.745n 0.95v 544.755n 0.95v 549.745n 0.95v 549.755n 0.95v 554.745n 0.95v 554.755n 0.95v 559.745n 0.95v 559.755n 0.95v 564.745n 0.95v 564.755n 0.95v 569.745n 0.95v 569.755n 0.95v 574.745n 0.95v 574.755n 0.95v 579.745n 0.95v 579.755n 0.95v 584.745n 0.95v 584.755n 0.95v 589.745n 0.95v 589.755n 0.95v 594.745n 0.95v 594.755n 0.95v 599.745n 0.95v 599.755n 0.95v 604.745n 0.95v 604.755n 0.95v 609.745n 0.95v 609.755n 0.95v 614.745n 0.95v 614.755n 0.95v 619.745n 0.95v 619.755n 0.95v 624.745n 0.95v 624.755n 0.95v 629.745n 0.95v 629.755n 0.95v 634.745n 0.95v 634.755n 0.95v 639.745n 0.95v 639.755n 0.0v 644.745n 0.0v 644.755n 0.0v 649.745n 0.0v 649.755n 0.0v 654.745n 0.0v 654.755n 0.0v 659.745n 0.0v 659.755n 0.0v 664.745n 0.0v 664.755n 0.0v 669.745n 0.0v 669.755n 0.95v 674.745n 0.95v 674.755n 0.95v 679.745n 0.95v 679.755n 0.95v 684.745n 0.95v 684.755n 0.95v 689.745n 0.95v 689.755n 0.95v 694.745n 0.95v 694.755n 0.95v 699.745n 0.95v 699.755n 0.95v 704.745n 0.95v 704.755n 0.95v 709.745n 0.95v 709.755n 0.95v 714.745n 0.95v 714.755n 0.95v 719.745n 0.95v 719.755n 0.95v 724.745n 0.95v 724.755n 0.95v 729.745n 0.95v 729.755n 0.95v 734.745n 0.95v 734.755n 0.95v 739.745n 0.95v 739.755n 0.95v 744.745n 0.95v 744.755n 0.0v 749.745n 0.0v 749.755n 0.0v 754.745n 0.0v 754.755n 0.0v 759.745n 0.0v 759.755n 0.0v 764.745n 0.0v 764.755n 0.95v 769.745n 0.95v 769.755n 0.95v 774.745n 0.95v 774.755n 0.95v 779.745n 0.95v 779.755n 0.95v 784.745n 0.95v 784.755n 0.95v 789.745n 0.95v 789.755n 0.95v 794.745n 0.95v 794.755n 0.95v 799.745n 0.95v 799.755n 0.95v 804.745n 0.95v 804.755n 0.95v 809.745n 0.95v 809.755n 0.95v 814.745n 0.95v 814.755n 0.95v 819.745n 0.95v 819.755n 0.95v 824.745n 0.95v 824.755n 0.95v 829.745n 0.95v 829.755n 0.95v 834.745n 0.95v 834.755n 0.95v 839.745n 0.95v 839.755n 0.95v 844.745n 0.95v 844.755n 0.95v 849.745n 0.95v 849.755n 0.0v 854.745n 0.0v 854.755n 0.95v 859.745n 0.95v 859.755n 0.95v 864.745n 0.95v 864.755n 0.95v 869.745n 0.95v 869.755n 0.95v 874.745n 0.95v 874.755n 0.95v 879.745n 0.95v 879.755n 0.95v 884.745n 0.95v 884.755n 0.95v 889.745n 0.95v 889.755n 0.95v 894.745n 0.95v 894.755n 0.95v 899.745n 0.95v 899.755n 0.95v 904.745n 0.95v 904.755n 0.95v 909.745n 0.95v 909.755n 0.95v 914.745n 0.95v 914.755n 0.95v 919.745n 0.95v 919.755n 0.95v 924.745n 0.95v 924.755n 0.0v 929.745n 0.0v 929.755n 0.0v 934.745n 0.0v 934.755n 0.95v 939.745n 0.95v 939.755n 0.95v 944.745n 0.95v 944.755n 0.95v 949.745n 0.95v 949.755n 0.0v 954.745n 0.0v 954.755n 0.0v 959.745n 0.0v 959.755n 0.0v 964.745n 0.0v 964.755n 0.0v 969.745n 0.0v 969.755n 0.95v 974.745n 0.95v 974.755n 0.95v 979.745n 0.95v 979.755n 0.95v 984.745n 0.95v 984.755n 0.95v 989.745n 0.95v 989.755n 0.95v 994.745n 0.95v 994.755n 0.95v 999.745n 0.95v 999.755n 0.95v 1004.745n 0.95v 1004.755n 0.95v 1009.745n 0.95v 1009.755n 0.95v 1014.745n 0.95v 1014.755n 0.95v 1019.745n 0.95v 1019.755n 0.95v 1024.745n 0.95v 1024.755n 0.95v )
* (time, data): [(0, 0), (5, 1), (10, 1), (15, 1), (20, 1), (25, 1), (30, 0), (35, 1), (40, 1), (45, 1), (50, 0), (55, 0), (60, 0), (65, 1), (70, 1), (75, 1), (80, 1), (85, 1), (90, 1), (95, 1), (100, 1), (105, 1), (110, 1), (115, 1), (120, 1), (125, 1), (130, 1), (135, 1), (140, 1), (145, 1), (150, 1), (155, 1), (160, 1), (165, 1), (170, 1), (175, 1), (180, 1), (185, 1), (190, 1), (195, 1), (200, 1), (205, 1), (210, 1), (215, 1), (220, 1), (225, 1), (230, 1), (235, 1), (240, 1), (245, 0), (250, 0), (255, 0), (260, 0), (265, 1), (270, 1), (275, 1), (280, 1), (285, 1), (290, 1), (295, 1), (300, 1), (305, 1), (310, 1), (315, 0), (320, 0), (325, 0), (330, 0), (335, 0), (340, 0), (345, 0), (350, 0), (355, 0), (360, 1), (365, 1), (370, 1), (375, 1), (380, 1), (385, 1), (390, 1), (395, 1), (400, 1), (405, 1), (410, 1), (415, 1), (420, 1), (425, 1), (430, 1), (435, 1), (440, 1), (445, 0), (450, 0), (455, 0), (460, 1), (465, 1), (470, 1), (475, 1), (480, 0), (485, 0), (490, 1), (495, 1), (500, 1), (505, 1), (510, 1), (515, 1), (520, 1), (525, 1), (530, 1), (535, 1), (540, 1), (545, 1), (550, 1), (555, 0), (560, 1), (565, 1), (570, 1), (575, 1), (580, 1), (585, 1), (590, 1), (595, 1), (600, 1), (605, 1), (610, 1), (615, 1), (620, 1), (625, 1), (630, 1), (635, 1), (640, 1), (645, 0), (650, 0), (655, 0), (660, 0), (665, 0), (670, 1), (675, 1), (680, 1), (685, 1), (690, 1), (695, 1), (700, 1), (705, 1), (710, 1), (715, 1), (720, 0), (725, 0), (730, 1), (735, 1), (740, 1), (745, 1), (750, 1), (755, 1), (760, 1), (765, 1), (770, 1), (775, 1), (780, 1), (785, 1), (790, 1), (795, 1), (800, 1), (805, 1), (810, 1), (815, 1), (820, 1), (825, 1), (830, 1), (835, 1), (840, 0), (845, 1), (850, 0), (855, 1), (860, 1), (865, 1), (870, 1), (875, 1), (880, 1), (885, 1), (890, 0), (895, 0), (900, 0), (905, 1), (910, 1), (915, 1), (920, 0), (925, 1), (930, 1), (935, 1), (940, 1), (945, 1), (950, 1), (955, 0), (960, 0), (965, 0), (970, 1), (975, 1), (980, 1), (985, 1), (990, 1), (995, 1), (1000, 1), (1005, 1), (1010, 1), (1015, 1), (1020, 1), (1025, 1)]
VWMASK0_2  WMASK0_2  0 PWL (0n 0.0v 4.745n 0.0v 4.755n 0.95v 9.745n 0.95v 9.755n 0.95v 14.745n 0.95v 14.755n 0.95v 19.745n 0.95v 19.755n 0.95v 24.745n 0.95v 24.755n 0.95v 29.745n 0.95v 29.755n 0.0v 34.745n 0.0v 34.755n 0.95v 39.745n 0.95v 39.755n 0.95v 44.745n 0.95v 44.755n 0.95v 49.745n 0.95v 49.755n 0.0v 54.745n 0.0v 54.755n 0.0v 59.745n 0.0v 59.755n 0.0v 64.745n 0.0v 64.755n 0.95v 69.745n 0.95v 69.755n 0.95v 74.745n 0.95v 74.755n 0.95v 79.745n 0.95v 79.755n 0.95v 84.745n 0.95v 84.755n 0.95v 89.745n 0.95v 89.755n 0.95v 94.745n 0.95v 94.755n 0.95v 99.745n 0.95v 99.755n 0.95v 104.745n 0.95v 104.755n 0.95v 109.745n 0.95v 109.755n 0.95v 114.745n 0.95v 114.755n 0.95v 119.745n 0.95v 119.755n 0.95v 124.745n 0.95v 124.755n 0.95v 129.745n 0.95v 129.755n 0.95v 134.745n 0.95v 134.755n 0.95v 139.745n 0.95v 139.755n 0.95v 144.745n 0.95v 144.755n 0.95v 149.745n 0.95v 149.755n 0.95v 154.745n 0.95v 154.755n 0.95v 159.745n 0.95v 159.755n 0.95v 164.745n 0.95v 164.755n 0.95v 169.745n 0.95v 169.755n 0.95v 174.745n 0.95v 174.755n 0.95v 179.745n 0.95v 179.755n 0.95v 184.745n 0.95v 184.755n 0.95v 189.745n 0.95v 189.755n 0.95v 194.745n 0.95v 194.755n 0.95v 199.745n 0.95v 199.755n 0.95v 204.745n 0.95v 204.755n 0.95v 209.745n 0.95v 209.755n 0.95v 214.745n 0.95v 214.755n 0.95v 219.745n 0.95v 219.755n 0.95v 224.745n 0.95v 224.755n 0.95v 229.745n 0.95v 229.755n 0.95v 234.745n 0.95v 234.755n 0.95v 239.745n 0.95v 239.755n 0.95v 244.745n 0.95v 244.755n 0.0v 249.745n 0.0v 249.755n 0.0v 254.745n 0.0v 254.755n 0.0v 259.745n 0.0v 259.755n 0.0v 264.745n 0.0v 264.755n 0.95v 269.745n 0.95v 269.755n 0.95v 274.745n 0.95v 274.755n 0.95v 279.745n 0.95v 279.755n 0.95v 284.745n 0.95v 284.755n 0.95v 289.745n 0.95v 289.755n 0.95v 294.745n 0.95v 294.755n 0.95v 299.745n 0.95v 299.755n 0.95v 304.745n 0.95v 304.755n 0.95v 309.745n 0.95v 309.755n 0.95v 314.745n 0.95v 314.755n 0.0v 319.745n 0.0v 319.755n 0.0v 324.745n 0.0v 324.755n 0.0v 329.745n 0.0v 329.755n 0.0v 334.745n 0.0v 334.755n 0.0v 339.745n 0.0v 339.755n 0.0v 344.745n 0.0v 344.755n 0.0v 349.745n 0.0v 349.755n 0.0v 354.745n 0.0v 354.755n 0.0v 359.745n 0.0v 359.755n 0.95v 364.745n 0.95v 364.755n 0.95v 369.745n 0.95v 369.755n 0.95v 374.745n 0.95v 374.755n 0.95v 379.745n 0.95v 379.755n 0.95v 384.745n 0.95v 384.755n 0.95v 389.745n 0.95v 389.755n 0.95v 394.745n 0.95v 394.755n 0.95v 399.745n 0.95v 399.755n 0.95v 404.745n 0.95v 404.755n 0.95v 409.745n 0.95v 409.755n 0.95v 414.745n 0.95v 414.755n 0.95v 419.745n 0.95v 419.755n 0.95v 424.745n 0.95v 424.755n 0.95v 429.745n 0.95v 429.755n 0.95v 434.745n 0.95v 434.755n 0.95v 439.745n 0.95v 439.755n 0.95v 444.745n 0.95v 444.755n 0.0v 449.745n 0.0v 449.755n 0.0v 454.745n 0.0v 454.755n 0.0v 459.745n 0.0v 459.755n 0.95v 464.745n 0.95v 464.755n 0.95v 469.745n 0.95v 469.755n 0.95v 474.745n 0.95v 474.755n 0.95v 479.745n 0.95v 479.755n 0.0v 484.745n 0.0v 484.755n 0.0v 489.745n 0.0v 489.755n 0.95v 494.745n 0.95v 494.755n 0.95v 499.745n 0.95v 499.755n 0.95v 504.745n 0.95v 504.755n 0.95v 509.745n 0.95v 509.755n 0.95v 514.745n 0.95v 514.755n 0.95v 519.745n 0.95v 519.755n 0.95v 524.745n 0.95v 524.755n 0.95v 529.745n 0.95v 529.755n 0.95v 534.745n 0.95v 534.755n 0.95v 539.745n 0.95v 539.755n 0.95v 544.745n 0.95v 544.755n 0.95v 549.745n 0.95v 549.755n 0.95v 554.745n 0.95v 554.755n 0.0v 559.745n 0.0v 559.755n 0.95v 564.745n 0.95v 564.755n 0.95v 569.745n 0.95v 569.755n 0.95v 574.745n 0.95v 574.755n 0.95v 579.745n 0.95v 579.755n 0.95v 584.745n 0.95v 584.755n 0.95v 589.745n 0.95v 589.755n 0.95v 594.745n 0.95v 594.755n 0.95v 599.745n 0.95v 599.755n 0.95v 604.745n 0.95v 604.755n 0.95v 609.745n 0.95v 609.755n 0.95v 614.745n 0.95v 614.755n 0.95v 619.745n 0.95v 619.755n 0.95v 624.745n 0.95v 624.755n 0.95v 629.745n 0.95v 629.755n 0.95v 634.745n 0.95v 634.755n 0.95v 639.745n 0.95v 639.755n 0.95v 644.745n 0.95v 644.755n 0.0v 649.745n 0.0v 649.755n 0.0v 654.745n 0.0v 654.755n 0.0v 659.745n 0.0v 659.755n 0.0v 664.745n 0.0v 664.755n 0.0v 669.745n 0.0v 669.755n 0.95v 674.745n 0.95v 674.755n 0.95v 679.745n 0.95v 679.755n 0.95v 684.745n 0.95v 684.755n 0.95v 689.745n 0.95v 689.755n 0.95v 694.745n 0.95v 694.755n 0.95v 699.745n 0.95v 699.755n 0.95v 704.745n 0.95v 704.755n 0.95v 709.745n 0.95v 709.755n 0.95v 714.745n 0.95v 714.755n 0.95v 719.745n 0.95v 719.755n 0.0v 724.745n 0.0v 724.755n 0.0v 729.745n 0.0v 729.755n 0.95v 734.745n 0.95v 734.755n 0.95v 739.745n 0.95v 739.755n 0.95v 744.745n 0.95v 744.755n 0.95v 749.745n 0.95v 749.755n 0.95v 754.745n 0.95v 754.755n 0.95v 759.745n 0.95v 759.755n 0.95v 764.745n 0.95v 764.755n 0.95v 769.745n 0.95v 769.755n 0.95v 774.745n 0.95v 774.755n 0.95v 779.745n 0.95v 779.755n 0.95v 784.745n 0.95v 784.755n 0.95v 789.745n 0.95v 789.755n 0.95v 794.745n 0.95v 794.755n 0.95v 799.745n 0.95v 799.755n 0.95v 804.745n 0.95v 804.755n 0.95v 809.745n 0.95v 809.755n 0.95v 814.745n 0.95v 814.755n 0.95v 819.745n 0.95v 819.755n 0.95v 824.745n 0.95v 824.755n 0.95v 829.745n 0.95v 829.755n 0.95v 834.745n 0.95v 834.755n 0.95v 839.745n 0.95v 839.755n 0.0v 844.745n 0.0v 844.755n 0.95v 849.745n 0.95v 849.755n 0.0v 854.745n 0.0v 854.755n 0.95v 859.745n 0.95v 859.755n 0.95v 864.745n 0.95v 864.755n 0.95v 869.745n 0.95v 869.755n 0.95v 874.745n 0.95v 874.755n 0.95v 879.745n 0.95v 879.755n 0.95v 884.745n 0.95v 884.755n 0.95v 889.745n 0.95v 889.755n 0.0v 894.745n 0.0v 894.755n 0.0v 899.745n 0.0v 899.755n 0.0v 904.745n 0.0v 904.755n 0.95v 909.745n 0.95v 909.755n 0.95v 914.745n 0.95v 914.755n 0.95v 919.745n 0.95v 919.755n 0.0v 924.745n 0.0v 924.755n 0.95v 929.745n 0.95v 929.755n 0.95v 934.745n 0.95v 934.755n 0.95v 939.745n 0.95v 939.755n 0.95v 944.745n 0.95v 944.755n 0.95v 949.745n 0.95v 949.755n 0.95v 954.745n 0.95v 954.755n 0.0v 959.745n 0.0v 959.755n 0.0v 964.745n 0.0v 964.755n 0.0v 969.745n 0.0v 969.755n 0.95v 974.745n 0.95v 974.755n 0.95v 979.745n 0.95v 979.755n 0.95v 984.745n 0.95v 984.755n 0.95v 989.745n 0.95v 989.755n 0.95v 994.745n 0.95v 994.755n 0.95v 999.745n 0.95v 999.755n 0.95v 1004.745n 0.95v 1004.755n 0.95v 1009.745n 0.95v 1009.755n 0.95v 1014.745n 0.95v 1014.755n 0.95v 1019.745n 0.95v 1019.755n 0.95v 1024.745n 0.95v 1024.755n 0.95v )
* (time, data): [(0, 0), (5, 1), (10, 1), (15, 1), (20, 1), (25, 1), (30, 0), (35, 1), (40, 1), (45, 1), (50, 0), (55, 0), (60, 1), (65, 1), (70, 1), (75, 1), (80, 1), (85, 1), (90, 1), (95, 0), (100, 0), (105, 1), (110, 1), (115, 1), (120, 1), (125, 1), (130, 1), (135, 1), (140, 1), (145, 1), (150, 1), (155, 1), (160, 1), (165, 1), (170, 1), (175, 1), (180, 1), (185, 1), (190, 1), (195, 1), (200, 1), (205, 1), (210, 1), (215, 1), (220, 1), (225, 1), (230, 1), (235, 1), (240, 1), (245, 1), (250, 1), (255, 1), (260, 1), (265, 1), (270, 1), (275, 1), (280, 1), (285, 1), (290, 1), (295, 1), (300, 1), (305, 1), (310, 1), (315, 0), (320, 0), (325, 0), (330, 0), (335, 0), (340, 0), (345, 1), (350, 1), (355, 1), (360, 1), (365, 0), (370, 0), (375, 0), (380, 0), (385, 0), (390, 1), (395, 1), (400, 1), (405, 1), (410, 1), (415, 1), (420, 1), (425, 1), (430, 1), (435, 0), (440, 1), (445, 0), (450, 0), (455, 0), (460, 1), (465, 1), (470, 1), (475, 0), (480, 1), (485, 0), (490, 1), (495, 1), (500, 1), (505, 1), (510, 1), (515, 1), (520, 1), (525, 1), (530, 0), (535, 0), (540, 1), (545, 1), (550, 1), (555, 0), (560, 1), (565, 1), (570, 1), (575, 1), (580, 1), (585, 1), (590, 1), (595, 1), (600, 1), (605, 1), (610, 1), (615, 1), (620, 1), (625, 1), (630, 1), (635, 1), (640, 0), (645, 0), (650, 0), (655, 0), (660, 0), (665, 0), (670, 1), (675, 1), (680, 1), (685, 1), (690, 1), (695, 1), (700, 1), (705, 1), (710, 1), (715, 1), (720, 0), (725, 0), (730, 1), (735, 0), (740, 0), (745, 1), (750, 1), (755, 1), (760, 1), (765, 1), (770, 1), (775, 1), (780, 1), (785, 1), (790, 1), (795, 1), (800, 1), (805, 1), (810, 1), (815, 1), (820, 1), (825, 1), (830, 1), (835, 1), (840, 0), (845, 1), (850, 1), (855, 1), (860, 1), (865, 1), (870, 1), (875, 1), (880, 1), (885, 1), (890, 1), (895, 1), (900, 1), (905, 1), (910, 1), (915, 1), (920, 0), (925, 0), (930, 0), (935, 1), (940, 1), (945, 1), (950, 0), (955, 1), (960, 1), (965, 1), (970, 0), (975, 0), (980, 1), (985, 1), (990, 1), (995, 1), (1000, 1), (1005, 0), (1010, 0), (1015, 0), (1020, 0), (1025, 0)]
VWMASK0_3  WMASK0_3  0 PWL (0n 0.0v 4.745n 0.0v 4.755n 0.95v 9.745n 0.95v 9.755n 0.95v 14.745n 0.95v 14.755n 0.95v 19.745n 0.95v 19.755n 0.95v 24.745n 0.95v 24.755n 0.95v 29.745n 0.95v 29.755n 0.0v 34.745n 0.0v 34.755n 0.95v 39.745n 0.95v 39.755n 0.95v 44.745n 0.95v 44.755n 0.95v 49.745n 0.95v 49.755n 0.0v 54.745n 0.0v 54.755n 0.0v 59.745n 0.0v 59.755n 0.95v 64.745n 0.95v 64.755n 0.95v 69.745n 0.95v 69.755n 0.95v 74.745n 0.95v 74.755n 0.95v 79.745n 0.95v 79.755n 0.95v 84.745n 0.95v 84.755n 0.95v 89.745n 0.95v 89.755n 0.95v 94.745n 0.95v 94.755n 0.0v 99.745n 0.0v 99.755n 0.0v 104.745n 0.0v 104.755n 0.95v 109.745n 0.95v 109.755n 0.95v 114.745n 0.95v 114.755n 0.95v 119.745n 0.95v 119.755n 0.95v 124.745n 0.95v 124.755n 0.95v 129.745n 0.95v 129.755n 0.95v 134.745n 0.95v 134.755n 0.95v 139.745n 0.95v 139.755n 0.95v 144.745n 0.95v 144.755n 0.95v 149.745n 0.95v 149.755n 0.95v 154.745n 0.95v 154.755n 0.95v 159.745n 0.95v 159.755n 0.95v 164.745n 0.95v 164.755n 0.95v 169.745n 0.95v 169.755n 0.95v 174.745n 0.95v 174.755n 0.95v 179.745n 0.95v 179.755n 0.95v 184.745n 0.95v 184.755n 0.95v 189.745n 0.95v 189.755n 0.95v 194.745n 0.95v 194.755n 0.95v 199.745n 0.95v 199.755n 0.95v 204.745n 0.95v 204.755n 0.95v 209.745n 0.95v 209.755n 0.95v 214.745n 0.95v 214.755n 0.95v 219.745n 0.95v 219.755n 0.95v 224.745n 0.95v 224.755n 0.95v 229.745n 0.95v 229.755n 0.95v 234.745n 0.95v 234.755n 0.95v 239.745n 0.95v 239.755n 0.95v 244.745n 0.95v 244.755n 0.95v 249.745n 0.95v 249.755n 0.95v 254.745n 0.95v 254.755n 0.95v 259.745n 0.95v 259.755n 0.95v 264.745n 0.95v 264.755n 0.95v 269.745n 0.95v 269.755n 0.95v 274.745n 0.95v 274.755n 0.95v 279.745n 0.95v 279.755n 0.95v 284.745n 0.95v 284.755n 0.95v 289.745n 0.95v 289.755n 0.95v 294.745n 0.95v 294.755n 0.95v 299.745n 0.95v 299.755n 0.95v 304.745n 0.95v 304.755n 0.95v 309.745n 0.95v 309.755n 0.95v 314.745n 0.95v 314.755n 0.0v 319.745n 0.0v 319.755n 0.0v 324.745n 0.0v 324.755n 0.0v 329.745n 0.0v 329.755n 0.0v 334.745n 0.0v 334.755n 0.0v 339.745n 0.0v 339.755n 0.0v 344.745n 0.0v 344.755n 0.95v 349.745n 0.95v 349.755n 0.95v 354.745n 0.95v 354.755n 0.95v 359.745n 0.95v 359.755n 0.95v 364.745n 0.95v 364.755n 0.0v 369.745n 0.0v 369.755n 0.0v 374.745n 0.0v 374.755n 0.0v 379.745n 0.0v 379.755n 0.0v 384.745n 0.0v 384.755n 0.0v 389.745n 0.0v 389.755n 0.95v 394.745n 0.95v 394.755n 0.95v 399.745n 0.95v 399.755n 0.95v 404.745n 0.95v 404.755n 0.95v 409.745n 0.95v 409.755n 0.95v 414.745n 0.95v 414.755n 0.95v 419.745n 0.95v 419.755n 0.95v 424.745n 0.95v 424.755n 0.95v 429.745n 0.95v 429.755n 0.95v 434.745n 0.95v 434.755n 0.0v 439.745n 0.0v 439.755n 0.95v 444.745n 0.95v 444.755n 0.0v 449.745n 0.0v 449.755n 0.0v 454.745n 0.0v 454.755n 0.0v 459.745n 0.0v 459.755n 0.95v 464.745n 0.95v 464.755n 0.95v 469.745n 0.95v 469.755n 0.95v 474.745n 0.95v 474.755n 0.0v 479.745n 0.0v 479.755n 0.95v 484.745n 0.95v 484.755n 0.0v 489.745n 0.0v 489.755n 0.95v 494.745n 0.95v 494.755n 0.95v 499.745n 0.95v 499.755n 0.95v 504.745n 0.95v 504.755n 0.95v 509.745n 0.95v 509.755n 0.95v 514.745n 0.95v 514.755n 0.95v 519.745n 0.95v 519.755n 0.95v 524.745n 0.95v 524.755n 0.95v 529.745n 0.95v 529.755n 0.0v 534.745n 0.0v 534.755n 0.0v 539.745n 0.0v 539.755n 0.95v 544.745n 0.95v 544.755n 0.95v 549.745n 0.95v 549.755n 0.95v 554.745n 0.95v 554.755n 0.0v 559.745n 0.0v 559.755n 0.95v 564.745n 0.95v 564.755n 0.95v 569.745n 0.95v 569.755n 0.95v 574.745n 0.95v 574.755n 0.95v 579.745n 0.95v 579.755n 0.95v 584.745n 0.95v 584.755n 0.95v 589.745n 0.95v 589.755n 0.95v 594.745n 0.95v 594.755n 0.95v 599.745n 0.95v 599.755n 0.95v 604.745n 0.95v 604.755n 0.95v 609.745n 0.95v 609.755n 0.95v 614.745n 0.95v 614.755n 0.95v 619.745n 0.95v 619.755n 0.95v 624.745n 0.95v 624.755n 0.95v 629.745n 0.95v 629.755n 0.95v 634.745n 0.95v 634.755n 0.95v 639.745n 0.95v 639.755n 0.0v 644.745n 0.0v 644.755n 0.0v 649.745n 0.0v 649.755n 0.0v 654.745n 0.0v 654.755n 0.0v 659.745n 0.0v 659.755n 0.0v 664.745n 0.0v 664.755n 0.0v 669.745n 0.0v 669.755n 0.95v 674.745n 0.95v 674.755n 0.95v 679.745n 0.95v 679.755n 0.95v 684.745n 0.95v 684.755n 0.95v 689.745n 0.95v 689.755n 0.95v 694.745n 0.95v 694.755n 0.95v 699.745n 0.95v 699.755n 0.95v 704.745n 0.95v 704.755n 0.95v 709.745n 0.95v 709.755n 0.95v 714.745n 0.95v 714.755n 0.95v 719.745n 0.95v 719.755n 0.0v 724.745n 0.0v 724.755n 0.0v 729.745n 0.0v 729.755n 0.95v 734.745n 0.95v 734.755n 0.0v 739.745n 0.0v 739.755n 0.0v 744.745n 0.0v 744.755n 0.95v 749.745n 0.95v 749.755n 0.95v 754.745n 0.95v 754.755n 0.95v 759.745n 0.95v 759.755n 0.95v 764.745n 0.95v 764.755n 0.95v 769.745n 0.95v 769.755n 0.95v 774.745n 0.95v 774.755n 0.95v 779.745n 0.95v 779.755n 0.95v 784.745n 0.95v 784.755n 0.95v 789.745n 0.95v 789.755n 0.95v 794.745n 0.95v 794.755n 0.95v 799.745n 0.95v 799.755n 0.95v 804.745n 0.95v 804.755n 0.95v 809.745n 0.95v 809.755n 0.95v 814.745n 0.95v 814.755n 0.95v 819.745n 0.95v 819.755n 0.95v 824.745n 0.95v 824.755n 0.95v 829.745n 0.95v 829.755n 0.95v 834.745n 0.95v 834.755n 0.95v 839.745n 0.95v 839.755n 0.0v 844.745n 0.0v 844.755n 0.95v 849.745n 0.95v 849.755n 0.95v 854.745n 0.95v 854.755n 0.95v 859.745n 0.95v 859.755n 0.95v 864.745n 0.95v 864.755n 0.95v 869.745n 0.95v 869.755n 0.95v 874.745n 0.95v 874.755n 0.95v 879.745n 0.95v 879.755n 0.95v 884.745n 0.95v 884.755n 0.95v 889.745n 0.95v 889.755n 0.95v 894.745n 0.95v 894.755n 0.95v 899.745n 0.95v 899.755n 0.95v 904.745n 0.95v 904.755n 0.95v 909.745n 0.95v 909.755n 0.95v 914.745n 0.95v 914.755n 0.95v 919.745n 0.95v 919.755n 0.0v 924.745n 0.0v 924.755n 0.0v 929.745n 0.0v 929.755n 0.0v 934.745n 0.0v 934.755n 0.95v 939.745n 0.95v 939.755n 0.95v 944.745n 0.95v 944.755n 0.95v 949.745n 0.95v 949.755n 0.0v 954.745n 0.0v 954.755n 0.95v 959.745n 0.95v 959.755n 0.95v 964.745n 0.95v 964.755n 0.95v 969.745n 0.95v 969.755n 0.0v 974.745n 0.0v 974.755n 0.0v 979.745n 0.0v 979.755n 0.95v 984.745n 0.95v 984.755n 0.95v 989.745n 0.95v 989.755n 0.95v 994.745n 0.95v 994.755n 0.95v 999.745n 0.95v 999.755n 0.95v 1004.745n 0.95v 1004.755n 0.0v 1009.745n 0.0v 1009.755n 0.0v 1014.745n 0.0v 1014.755n 0.0v 1019.745n 0.0v 1019.755n 0.0v 1024.745n 0.0v 1024.755n 0.0v )
* PULSE: period=5
Vclk0 clk0 0 PULSE (0 0.95 4.995n 0.01n 0.01n 2.49n 5n)

 * Generation of dout measurements
* CHECK dout0_0 vdout0_0ck4 = 0 time = 25
* CHECK dout0_1 vdout0_1ck4 = 0 time = 25
* CHECK dout0_2 vdout0_2ck4 = 0 time = 25
* CHECK dout0_3 vdout0_3ck4 = 0 time = 25
* CHECK dout0_4 vdout0_4ck4 = 0.95 time = 25
* CHECK dout0_5 vdout0_5ck4 = 0.95 time = 25
* CHECK dout0_6 vdout0_6ck4 = 0 time = 25
* CHECK dout0_7 vdout0_7ck4 = 0 time = 25
* CHECK dout0_8 vdout0_8ck4 = 0.95 time = 25
* CHECK dout0_9 vdout0_9ck4 = 0.95 time = 25
* CHECK dout0_10 vdout0_10ck4 = 0.95 time = 25
* CHECK dout0_11 vdout0_11ck4 = 0.95 time = 25
* CHECK dout0_12 vdout0_12ck4 = 0.95 time = 25
* CHECK dout0_13 vdout0_13ck4 = 0 time = 25
* CHECK dout0_14 vdout0_14ck4 = 0.95 time = 25
* CHECK dout0_15 vdout0_15ck4 = 0 time = 25
* CHECK dout0_16 vdout0_16ck4 = 0.95 time = 25
* CHECK dout0_17 vdout0_17ck4 = 0 time = 25
* CHECK dout0_18 vdout0_18ck4 = 0.95 time = 25
* CHECK dout0_19 vdout0_19ck4 = 0 time = 25
* CHECK dout0_20 vdout0_20ck4 = 0.95 time = 25
* CHECK dout0_21 vdout0_21ck4 = 0.95 time = 25
* CHECK dout0_22 vdout0_22ck4 = 0 time = 25
* CHECK dout0_23 vdout0_23ck4 = 0.95 time = 25
* CHECK dout0_24 vdout0_24ck4 = 0 time = 25
* CHECK dout0_25 vdout0_25ck4 = 0 time = 25
* CHECK dout0_26 vdout0_26ck4 = 0 time = 25
* CHECK dout0_27 vdout0_27ck4 = 0.95 time = 25
* CHECK dout0_28 vdout0_28ck4 = 0 time = 25
* CHECK dout0_29 vdout0_29ck4 = 0.95 time = 25
* CHECK dout0_30 vdout0_30ck4 = 0.95 time = 25
* CHECK dout0_31 vdout0_31ck4 = 0 time = 25
* CHECK dout0_0 vdout0_0ck11 = 0.95 time = 60
* CHECK dout0_1 vdout0_1ck11 = 0.95 time = 60
* CHECK dout0_2 vdout0_2ck11 = 0 time = 60
* CHECK dout0_3 vdout0_3ck11 = 0.95 time = 60
* CHECK dout0_4 vdout0_4ck11 = 0 time = 60
* CHECK dout0_5 vdout0_5ck11 = 0.95 time = 60
* CHECK dout0_6 vdout0_6ck11 = 0 time = 60
* CHECK dout0_7 vdout0_7ck11 = 0 time = 60
* CHECK dout0_8 vdout0_8ck11 = 0.95 time = 60
* CHECK dout0_9 vdout0_9ck11 = 0.95 time = 60
* CHECK dout0_10 vdout0_10ck11 = 0.95 time = 60
* CHECK dout0_11 vdout0_11ck11 = 0.95 time = 60
* CHECK dout0_12 vdout0_12ck11 = 0.95 time = 60
* CHECK dout0_13 vdout0_13ck11 = 0 time = 60
* CHECK dout0_14 vdout0_14ck11 = 0.95 time = 60
* CHECK dout0_15 vdout0_15ck11 = 0.95 time = 60
* CHECK dout0_16 vdout0_16ck11 = 0 time = 60
* CHECK dout0_17 vdout0_17ck11 = 0.95 time = 60
* CHECK dout0_18 vdout0_18ck11 = 0.95 time = 60
* CHECK dout0_19 vdout0_19ck11 = 0.95 time = 60
* CHECK dout0_20 vdout0_20ck11 = 0 time = 60
* CHECK dout0_21 vdout0_21ck11 = 0 time = 60
* CHECK dout0_22 vdout0_22ck11 = 0.95 time = 60
* CHECK dout0_23 vdout0_23ck11 = 0.95 time = 60
* CHECK dout0_24 vdout0_24ck11 = 0 time = 60
* CHECK dout0_25 vdout0_25ck11 = 0 time = 60
* CHECK dout0_26 vdout0_26ck11 = 0.95 time = 60
* CHECK dout0_27 vdout0_27ck11 = 0.95 time = 60
* CHECK dout0_28 vdout0_28ck11 = 0.95 time = 60
* CHECK dout0_29 vdout0_29ck11 = 0.95 time = 60
* CHECK dout0_30 vdout0_30ck11 = 0.95 time = 60
* CHECK dout0_31 vdout0_31ck11 = 0.95 time = 60
* CHECK dout0_0 vdout0_0ck14 = 0 time = 75
* CHECK dout0_1 vdout0_1ck14 = 0 time = 75
* CHECK dout0_2 vdout0_2ck14 = 0.95 time = 75
* CHECK dout0_3 vdout0_3ck14 = 0 time = 75
* CHECK dout0_4 vdout0_4ck14 = 0.95 time = 75
* CHECK dout0_5 vdout0_5ck14 = 0 time = 75
* CHECK dout0_6 vdout0_6ck14 = 0.95 time = 75
* CHECK dout0_7 vdout0_7ck14 = 0 time = 75
* CHECK dout0_8 vdout0_8ck14 = 0.95 time = 75
* CHECK dout0_9 vdout0_9ck14 = 0 time = 75
* CHECK dout0_10 vdout0_10ck14 = 0.95 time = 75
* CHECK dout0_11 vdout0_11ck14 = 0.95 time = 75
* CHECK dout0_12 vdout0_12ck14 = 0 time = 75
* CHECK dout0_13 vdout0_13ck14 = 0.95 time = 75
* CHECK dout0_14 vdout0_14ck14 = 0.95 time = 75
* CHECK dout0_15 vdout0_15ck14 = 0 time = 75
* CHECK dout0_16 vdout0_16ck14 = 0.95 time = 75
* CHECK dout0_17 vdout0_17ck14 = 0 time = 75
* CHECK dout0_18 vdout0_18ck14 = 0 time = 75
* CHECK dout0_19 vdout0_19ck14 = 0 time = 75
* CHECK dout0_20 vdout0_20ck14 = 0 time = 75
* CHECK dout0_21 vdout0_21ck14 = 0 time = 75
* CHECK dout0_22 vdout0_22ck14 = 0 time = 75
* CHECK dout0_23 vdout0_23ck14 = 0.95 time = 75
* CHECK dout0_24 vdout0_24ck14 = 0.95 time = 75
* CHECK dout0_25 vdout0_25ck14 = 0.95 time = 75
* CHECK dout0_26 vdout0_26ck14 = 0.95 time = 75
* CHECK dout0_27 vdout0_27ck14 = 0 time = 75
* CHECK dout0_28 vdout0_28ck14 = 0 time = 75
* CHECK dout0_29 vdout0_29ck14 = 0.95 time = 75
* CHECK dout0_30 vdout0_30ck14 = 0.95 time = 75
* CHECK dout0_31 vdout0_31ck14 = 0 time = 75
* CHECK dout0_0 vdout0_0ck18 = 0.95 time = 95
* CHECK dout0_1 vdout0_1ck18 = 0.95 time = 95
* CHECK dout0_2 vdout0_2ck18 = 0 time = 95
* CHECK dout0_3 vdout0_3ck18 = 0.95 time = 95
* CHECK dout0_4 vdout0_4ck18 = 0 time = 95
* CHECK dout0_5 vdout0_5ck18 = 0.95 time = 95
* CHECK dout0_6 vdout0_6ck18 = 0 time = 95
* CHECK dout0_7 vdout0_7ck18 = 0 time = 95
* CHECK dout0_8 vdout0_8ck18 = 0.95 time = 95
* CHECK dout0_9 vdout0_9ck18 = 0.95 time = 95
* CHECK dout0_10 vdout0_10ck18 = 0.95 time = 95
* CHECK dout0_11 vdout0_11ck18 = 0.95 time = 95
* CHECK dout0_12 vdout0_12ck18 = 0.95 time = 95
* CHECK dout0_13 vdout0_13ck18 = 0 time = 95
* CHECK dout0_14 vdout0_14ck18 = 0.95 time = 95
* CHECK dout0_15 vdout0_15ck18 = 0.95 time = 95
* CHECK dout0_16 vdout0_16ck18 = 0 time = 95
* CHECK dout0_17 vdout0_17ck18 = 0.95 time = 95
* CHECK dout0_18 vdout0_18ck18 = 0.95 time = 95
* CHECK dout0_19 vdout0_19ck18 = 0.95 time = 95
* CHECK dout0_20 vdout0_20ck18 = 0 time = 95
* CHECK dout0_21 vdout0_21ck18 = 0 time = 95
* CHECK dout0_22 vdout0_22ck18 = 0.95 time = 95
* CHECK dout0_23 vdout0_23ck18 = 0.95 time = 95
* CHECK dout0_24 vdout0_24ck18 = 0 time = 95
* CHECK dout0_25 vdout0_25ck18 = 0 time = 95
* CHECK dout0_26 vdout0_26ck18 = 0.95 time = 95
* CHECK dout0_27 vdout0_27ck18 = 0.95 time = 95
* CHECK dout0_28 vdout0_28ck18 = 0.95 time = 95
* CHECK dout0_29 vdout0_29ck18 = 0.95 time = 95
* CHECK dout0_30 vdout0_30ck18 = 0.95 time = 95
* CHECK dout0_31 vdout0_31ck18 = 0.95 time = 95
* CHECK dout0_0 vdout0_0ck24 = 0 time = 125
* CHECK dout0_1 vdout0_1ck24 = 0.95 time = 125
* CHECK dout0_2 vdout0_2ck24 = 0 time = 125
* CHECK dout0_3 vdout0_3ck24 = 0 time = 125
* CHECK dout0_4 vdout0_4ck24 = 0 time = 125
* CHECK dout0_5 vdout0_5ck24 = 0 time = 125
* CHECK dout0_6 vdout0_6ck24 = 0.95 time = 125
* CHECK dout0_7 vdout0_7ck24 = 0 time = 125
* CHECK dout0_8 vdout0_8ck24 = 0.95 time = 125
* CHECK dout0_9 vdout0_9ck24 = 0 time = 125
* CHECK dout0_10 vdout0_10ck24 = 0.95 time = 125
* CHECK dout0_11 vdout0_11ck24 = 0 time = 125
* CHECK dout0_12 vdout0_12ck24 = 0.95 time = 125
* CHECK dout0_13 vdout0_13ck24 = 0.95 time = 125
* CHECK dout0_14 vdout0_14ck24 = 0 time = 125
* CHECK dout0_15 vdout0_15ck24 = 0.95 time = 125
* CHECK dout0_16 vdout0_16ck24 = 0.95 time = 125
* CHECK dout0_17 vdout0_17ck24 = 0 time = 125
* CHECK dout0_18 vdout0_18ck24 = 0.95 time = 125
* CHECK dout0_19 vdout0_19ck24 = 0 time = 125
* CHECK dout0_20 vdout0_20ck24 = 0.95 time = 125
* CHECK dout0_21 vdout0_21ck24 = 0 time = 125
* CHECK dout0_22 vdout0_22ck24 = 0.95 time = 125
* CHECK dout0_23 vdout0_23ck24 = 0.95 time = 125
* CHECK dout0_24 vdout0_24ck24 = 0 time = 125
* CHECK dout0_25 vdout0_25ck24 = 0 time = 125
* CHECK dout0_26 vdout0_26ck24 = 0.95 time = 125
* CHECK dout0_27 vdout0_27ck24 = 0.95 time = 125
* CHECK dout0_28 vdout0_28ck24 = 0.95 time = 125
* CHECK dout0_29 vdout0_29ck24 = 0.95 time = 125
* CHECK dout0_30 vdout0_30ck24 = 0 time = 125
* CHECK dout0_31 vdout0_31ck24 = 0 time = 125
* CHECK dout0_0 vdout0_0ck28 = 0 time = 145
* CHECK dout0_1 vdout0_1ck28 = 0.95 time = 145
* CHECK dout0_2 vdout0_2ck28 = 0.95 time = 145
* CHECK dout0_3 vdout0_3ck28 = 0.95 time = 145
* CHECK dout0_4 vdout0_4ck28 = 0 time = 145
* CHECK dout0_5 vdout0_5ck28 = 0 time = 145
* CHECK dout0_6 vdout0_6ck28 = 0 time = 145
* CHECK dout0_7 vdout0_7ck28 = 0.95 time = 145
* CHECK dout0_8 vdout0_8ck28 = 0.95 time = 145
* CHECK dout0_9 vdout0_9ck28 = 0 time = 145
* CHECK dout0_10 vdout0_10ck28 = 0.95 time = 145
* CHECK dout0_11 vdout0_11ck28 = 0 time = 145
* CHECK dout0_12 vdout0_12ck28 = 0.95 time = 145
* CHECK dout0_13 vdout0_13ck28 = 0 time = 145
* CHECK dout0_14 vdout0_14ck28 = 0.95 time = 145
* CHECK dout0_15 vdout0_15ck28 = 0 time = 145
* CHECK dout0_16 vdout0_16ck28 = 0 time = 145
* CHECK dout0_17 vdout0_17ck28 = 0.95 time = 145
* CHECK dout0_18 vdout0_18ck28 = 0 time = 145
* CHECK dout0_19 vdout0_19ck28 = 0 time = 145
* CHECK dout0_20 vdout0_20ck28 = 0.95 time = 145
* CHECK dout0_21 vdout0_21ck28 = 0 time = 145
* CHECK dout0_22 vdout0_22ck28 = 0.95 time = 145
* CHECK dout0_23 vdout0_23ck28 = 0.95 time = 145
* CHECK dout0_24 vdout0_24ck28 = 0.95 time = 145
* CHECK dout0_25 vdout0_25ck28 = 0 time = 145
* CHECK dout0_26 vdout0_26ck28 = 0 time = 145
* CHECK dout0_27 vdout0_27ck28 = 0 time = 145
* CHECK dout0_28 vdout0_28ck28 = 0.95 time = 145
* CHECK dout0_29 vdout0_29ck28 = 0 time = 145
* CHECK dout0_30 vdout0_30ck28 = 0.95 time = 145
* CHECK dout0_31 vdout0_31ck28 = 0 time = 145
* CHECK dout0_0 vdout0_0ck29 = 0.95 time = 150
* CHECK dout0_1 vdout0_1ck29 = 0.95 time = 150
* CHECK dout0_2 vdout0_2ck29 = 0 time = 150
* CHECK dout0_3 vdout0_3ck29 = 0 time = 150
* CHECK dout0_4 vdout0_4ck29 = 0.95 time = 150
* CHECK dout0_5 vdout0_5ck29 = 0 time = 150
* CHECK dout0_6 vdout0_6ck29 = 0.95 time = 150
* CHECK dout0_7 vdout0_7ck29 = 0 time = 150
* CHECK dout0_8 vdout0_8ck29 = 0 time = 150
* CHECK dout0_9 vdout0_9ck29 = 0 time = 150
* CHECK dout0_10 vdout0_10ck29 = 0 time = 150
* CHECK dout0_11 vdout0_11ck29 = 0 time = 150
* CHECK dout0_12 vdout0_12ck29 = 0.95 time = 150
* CHECK dout0_13 vdout0_13ck29 = 0.95 time = 150
* CHECK dout0_14 vdout0_14ck29 = 0.95 time = 150
* CHECK dout0_15 vdout0_15ck29 = 0.95 time = 150
* CHECK dout0_16 vdout0_16ck29 = 0 time = 150
* CHECK dout0_17 vdout0_17ck29 = 0 time = 150
* CHECK dout0_18 vdout0_18ck29 = 0 time = 150
* CHECK dout0_19 vdout0_19ck29 = 0 time = 150
* CHECK dout0_20 vdout0_20ck29 = 0.95 time = 150
* CHECK dout0_21 vdout0_21ck29 = 0 time = 150
* CHECK dout0_22 vdout0_22ck29 = 0 time = 150
* CHECK dout0_23 vdout0_23ck29 = 0.95 time = 150
* CHECK dout0_24 vdout0_24ck29 = 0.95 time = 150
* CHECK dout0_25 vdout0_25ck29 = 0 time = 150
* CHECK dout0_26 vdout0_26ck29 = 0.95 time = 150
* CHECK dout0_27 vdout0_27ck29 = 0.95 time = 150
* CHECK dout0_28 vdout0_28ck29 = 0.95 time = 150
* CHECK dout0_29 vdout0_29ck29 = 0.95 time = 150
* CHECK dout0_30 vdout0_30ck29 = 0 time = 150
* CHECK dout0_31 vdout0_31ck29 = 0 time = 150
* CHECK dout0_0 vdout0_0ck31 = 0 time = 160
* CHECK dout0_1 vdout0_1ck31 = 0.95 time = 160
* CHECK dout0_2 vdout0_2ck31 = 0 time = 160
* CHECK dout0_3 vdout0_3ck31 = 0 time = 160
* CHECK dout0_4 vdout0_4ck31 = 0 time = 160
* CHECK dout0_5 vdout0_5ck31 = 0 time = 160
* CHECK dout0_6 vdout0_6ck31 = 0.95 time = 160
* CHECK dout0_7 vdout0_7ck31 = 0 time = 160
* CHECK dout0_8 vdout0_8ck31 = 0.95 time = 160
* CHECK dout0_9 vdout0_9ck31 = 0 time = 160
* CHECK dout0_10 vdout0_10ck31 = 0.95 time = 160
* CHECK dout0_11 vdout0_11ck31 = 0 time = 160
* CHECK dout0_12 vdout0_12ck31 = 0.95 time = 160
* CHECK dout0_13 vdout0_13ck31 = 0.95 time = 160
* CHECK dout0_14 vdout0_14ck31 = 0 time = 160
* CHECK dout0_15 vdout0_15ck31 = 0.95 time = 160
* CHECK dout0_16 vdout0_16ck31 = 0.95 time = 160
* CHECK dout0_17 vdout0_17ck31 = 0 time = 160
* CHECK dout0_18 vdout0_18ck31 = 0.95 time = 160
* CHECK dout0_19 vdout0_19ck31 = 0 time = 160
* CHECK dout0_20 vdout0_20ck31 = 0.95 time = 160
* CHECK dout0_21 vdout0_21ck31 = 0 time = 160
* CHECK dout0_22 vdout0_22ck31 = 0.95 time = 160
* CHECK dout0_23 vdout0_23ck31 = 0.95 time = 160
* CHECK dout0_24 vdout0_24ck31 = 0 time = 160
* CHECK dout0_25 vdout0_25ck31 = 0 time = 160
* CHECK dout0_26 vdout0_26ck31 = 0.95 time = 160
* CHECK dout0_27 vdout0_27ck31 = 0.95 time = 160
* CHECK dout0_28 vdout0_28ck31 = 0.95 time = 160
* CHECK dout0_29 vdout0_29ck31 = 0.95 time = 160
* CHECK dout0_30 vdout0_30ck31 = 0 time = 160
* CHECK dout0_31 vdout0_31ck31 = 0 time = 160
* CHECK dout0_0 vdout0_0ck32 = 0 time = 165
* CHECK dout0_1 vdout0_1ck32 = 0 time = 165
* CHECK dout0_2 vdout0_2ck32 = 0 time = 165
* CHECK dout0_3 vdout0_3ck32 = 0 time = 165
* CHECK dout0_4 vdout0_4ck32 = 0.95 time = 165
* CHECK dout0_5 vdout0_5ck32 = 0.95 time = 165
* CHECK dout0_6 vdout0_6ck32 = 0 time = 165
* CHECK dout0_7 vdout0_7ck32 = 0 time = 165
* CHECK dout0_8 vdout0_8ck32 = 0.95 time = 165
* CHECK dout0_9 vdout0_9ck32 = 0.95 time = 165
* CHECK dout0_10 vdout0_10ck32 = 0.95 time = 165
* CHECK dout0_11 vdout0_11ck32 = 0.95 time = 165
* CHECK dout0_12 vdout0_12ck32 = 0.95 time = 165
* CHECK dout0_13 vdout0_13ck32 = 0 time = 165
* CHECK dout0_14 vdout0_14ck32 = 0.95 time = 165
* CHECK dout0_15 vdout0_15ck32 = 0 time = 165
* CHECK dout0_16 vdout0_16ck32 = 0.95 time = 165
* CHECK dout0_17 vdout0_17ck32 = 0 time = 165
* CHECK dout0_18 vdout0_18ck32 = 0.95 time = 165
* CHECK dout0_19 vdout0_19ck32 = 0 time = 165
* CHECK dout0_20 vdout0_20ck32 = 0.95 time = 165
* CHECK dout0_21 vdout0_21ck32 = 0.95 time = 165
* CHECK dout0_22 vdout0_22ck32 = 0 time = 165
* CHECK dout0_23 vdout0_23ck32 = 0.95 time = 165
* CHECK dout0_24 vdout0_24ck32 = 0 time = 165
* CHECK dout0_25 vdout0_25ck32 = 0 time = 165
* CHECK dout0_26 vdout0_26ck32 = 0 time = 165
* CHECK dout0_27 vdout0_27ck32 = 0.95 time = 165
* CHECK dout0_28 vdout0_28ck32 = 0 time = 165
* CHECK dout0_29 vdout0_29ck32 = 0.95 time = 165
* CHECK dout0_30 vdout0_30ck32 = 0.95 time = 165
* CHECK dout0_31 vdout0_31ck32 = 0 time = 165
* CHECK dout0_0 vdout0_0ck34 = 0 time = 175
* CHECK dout0_1 vdout0_1ck34 = 0 time = 175
* CHECK dout0_2 vdout0_2ck34 = 0 time = 175
* CHECK dout0_3 vdout0_3ck34 = 0 time = 175
* CHECK dout0_4 vdout0_4ck34 = 0.95 time = 175
* CHECK dout0_5 vdout0_5ck34 = 0.95 time = 175
* CHECK dout0_6 vdout0_6ck34 = 0 time = 175
* CHECK dout0_7 vdout0_7ck34 = 0 time = 175
* CHECK dout0_8 vdout0_8ck34 = 0.95 time = 175
* CHECK dout0_9 vdout0_9ck34 = 0.95 time = 175
* CHECK dout0_10 vdout0_10ck34 = 0.95 time = 175
* CHECK dout0_11 vdout0_11ck34 = 0.95 time = 175
* CHECK dout0_12 vdout0_12ck34 = 0.95 time = 175
* CHECK dout0_13 vdout0_13ck34 = 0 time = 175
* CHECK dout0_14 vdout0_14ck34 = 0.95 time = 175
* CHECK dout0_15 vdout0_15ck34 = 0 time = 175
* CHECK dout0_16 vdout0_16ck34 = 0.95 time = 175
* CHECK dout0_17 vdout0_17ck34 = 0 time = 175
* CHECK dout0_18 vdout0_18ck34 = 0.95 time = 175
* CHECK dout0_19 vdout0_19ck34 = 0 time = 175
* CHECK dout0_20 vdout0_20ck34 = 0.95 time = 175
* CHECK dout0_21 vdout0_21ck34 = 0.95 time = 175
* CHECK dout0_22 vdout0_22ck34 = 0 time = 175
* CHECK dout0_23 vdout0_23ck34 = 0.95 time = 175
* CHECK dout0_24 vdout0_24ck34 = 0 time = 175
* CHECK dout0_25 vdout0_25ck34 = 0 time = 175
* CHECK dout0_26 vdout0_26ck34 = 0 time = 175
* CHECK dout0_27 vdout0_27ck34 = 0.95 time = 175
* CHECK dout0_28 vdout0_28ck34 = 0 time = 175
* CHECK dout0_29 vdout0_29ck34 = 0.95 time = 175
* CHECK dout0_30 vdout0_30ck34 = 0.95 time = 175
* CHECK dout0_31 vdout0_31ck34 = 0 time = 175
* CHECK dout0_0 vdout0_0ck35 = 0 time = 180
* CHECK dout0_1 vdout0_1ck35 = 0.95 time = 180
* CHECK dout0_2 vdout0_2ck35 = 0 time = 180
* CHECK dout0_3 vdout0_3ck35 = 0 time = 180
* CHECK dout0_4 vdout0_4ck35 = 0 time = 180
* CHECK dout0_5 vdout0_5ck35 = 0 time = 180
* CHECK dout0_6 vdout0_6ck35 = 0.95 time = 180
* CHECK dout0_7 vdout0_7ck35 = 0 time = 180
* CHECK dout0_8 vdout0_8ck35 = 0.95 time = 180
* CHECK dout0_9 vdout0_9ck35 = 0 time = 180
* CHECK dout0_10 vdout0_10ck35 = 0.95 time = 180
* CHECK dout0_11 vdout0_11ck35 = 0 time = 180
* CHECK dout0_12 vdout0_12ck35 = 0.95 time = 180
* CHECK dout0_13 vdout0_13ck35 = 0.95 time = 180
* CHECK dout0_14 vdout0_14ck35 = 0 time = 180
* CHECK dout0_15 vdout0_15ck35 = 0.95 time = 180
* CHECK dout0_16 vdout0_16ck35 = 0.95 time = 180
* CHECK dout0_17 vdout0_17ck35 = 0 time = 180
* CHECK dout0_18 vdout0_18ck35 = 0.95 time = 180
* CHECK dout0_19 vdout0_19ck35 = 0 time = 180
* CHECK dout0_20 vdout0_20ck35 = 0.95 time = 180
* CHECK dout0_21 vdout0_21ck35 = 0 time = 180
* CHECK dout0_22 vdout0_22ck35 = 0.95 time = 180
* CHECK dout0_23 vdout0_23ck35 = 0.95 time = 180
* CHECK dout0_24 vdout0_24ck35 = 0 time = 180
* CHECK dout0_25 vdout0_25ck35 = 0 time = 180
* CHECK dout0_26 vdout0_26ck35 = 0.95 time = 180
* CHECK dout0_27 vdout0_27ck35 = 0.95 time = 180
* CHECK dout0_28 vdout0_28ck35 = 0.95 time = 180
* CHECK dout0_29 vdout0_29ck35 = 0.95 time = 180
* CHECK dout0_30 vdout0_30ck35 = 0 time = 180
* CHECK dout0_31 vdout0_31ck35 = 0 time = 180
* CHECK dout0_0 vdout0_0ck39 = 0 time = 200
* CHECK dout0_1 vdout0_1ck39 = 0.95 time = 200
* CHECK dout0_2 vdout0_2ck39 = 0.95 time = 200
* CHECK dout0_3 vdout0_3ck39 = 0.95 time = 200
* CHECK dout0_4 vdout0_4ck39 = 0 time = 200
* CHECK dout0_5 vdout0_5ck39 = 0 time = 200
* CHECK dout0_6 vdout0_6ck39 = 0 time = 200
* CHECK dout0_7 vdout0_7ck39 = 0.95 time = 200
* CHECK dout0_8 vdout0_8ck39 = 0.95 time = 200
* CHECK dout0_9 vdout0_9ck39 = 0 time = 200
* CHECK dout0_10 vdout0_10ck39 = 0.95 time = 200
* CHECK dout0_11 vdout0_11ck39 = 0 time = 200
* CHECK dout0_12 vdout0_12ck39 = 0.95 time = 200
* CHECK dout0_13 vdout0_13ck39 = 0 time = 200
* CHECK dout0_14 vdout0_14ck39 = 0.95 time = 200
* CHECK dout0_15 vdout0_15ck39 = 0 time = 200
* CHECK dout0_16 vdout0_16ck39 = 0 time = 200
* CHECK dout0_17 vdout0_17ck39 = 0.95 time = 200
* CHECK dout0_18 vdout0_18ck39 = 0 time = 200
* CHECK dout0_19 vdout0_19ck39 = 0 time = 200
* CHECK dout0_20 vdout0_20ck39 = 0.95 time = 200
* CHECK dout0_21 vdout0_21ck39 = 0 time = 200
* CHECK dout0_22 vdout0_22ck39 = 0.95 time = 200
* CHECK dout0_23 vdout0_23ck39 = 0.95 time = 200
* CHECK dout0_24 vdout0_24ck39 = 0.95 time = 200
* CHECK dout0_25 vdout0_25ck39 = 0 time = 200
* CHECK dout0_26 vdout0_26ck39 = 0 time = 200
* CHECK dout0_27 vdout0_27ck39 = 0 time = 200
* CHECK dout0_28 vdout0_28ck39 = 0.95 time = 200
* CHECK dout0_29 vdout0_29ck39 = 0 time = 200
* CHECK dout0_30 vdout0_30ck39 = 0.95 time = 200
* CHECK dout0_31 vdout0_31ck39 = 0 time = 200
* CHECK dout0_0 vdout0_0ck44 = 0 time = 225
* CHECK dout0_1 vdout0_1ck44 = 0 time = 225
* CHECK dout0_2 vdout0_2ck44 = 0 time = 225
* CHECK dout0_3 vdout0_3ck44 = 0.95 time = 225
* CHECK dout0_4 vdout0_4ck44 = 0 time = 225
* CHECK dout0_5 vdout0_5ck44 = 0.95 time = 225
* CHECK dout0_6 vdout0_6ck44 = 0 time = 225
* CHECK dout0_7 vdout0_7ck44 = 0 time = 225
* CHECK dout0_8 vdout0_8ck44 = 0 time = 225
* CHECK dout0_9 vdout0_9ck44 = 0.95 time = 225
* CHECK dout0_10 vdout0_10ck44 = 0 time = 225
* CHECK dout0_11 vdout0_11ck44 = 0 time = 225
* CHECK dout0_12 vdout0_12ck44 = 0 time = 225
* CHECK dout0_13 vdout0_13ck44 = 0.95 time = 225
* CHECK dout0_14 vdout0_14ck44 = 0 time = 225
* CHECK dout0_15 vdout0_15ck44 = 0 time = 225
* CHECK dout0_16 vdout0_16ck44 = 0.95 time = 225
* CHECK dout0_17 vdout0_17ck44 = 0.95 time = 225
* CHECK dout0_18 vdout0_18ck44 = 0.95 time = 225
* CHECK dout0_19 vdout0_19ck44 = 0.95 time = 225
* CHECK dout0_20 vdout0_20ck44 = 0 time = 225
* CHECK dout0_21 vdout0_21ck44 = 0.95 time = 225
* CHECK dout0_22 vdout0_22ck44 = 0 time = 225
* CHECK dout0_23 vdout0_23ck44 = 0 time = 225
* CHECK dout0_24 vdout0_24ck44 = 0.95 time = 225
* CHECK dout0_25 vdout0_25ck44 = 0 time = 225
* CHECK dout0_26 vdout0_26ck44 = 0 time = 225
* CHECK dout0_27 vdout0_27ck44 = 0.95 time = 225
* CHECK dout0_28 vdout0_28ck44 = 0.95 time = 225
* CHECK dout0_29 vdout0_29ck44 = 0.95 time = 225
* CHECK dout0_30 vdout0_30ck44 = 0.95 time = 225
* CHECK dout0_31 vdout0_31ck44 = 0.95 time = 225
* CHECK dout0_0 vdout0_0ck47 = 0 time = 240
* CHECK dout0_1 vdout0_1ck47 = 0.95 time = 240
* CHECK dout0_2 vdout0_2ck47 = 0.95 time = 240
* CHECK dout0_3 vdout0_3ck47 = 0.95 time = 240
* CHECK dout0_4 vdout0_4ck47 = 0 time = 240
* CHECK dout0_5 vdout0_5ck47 = 0 time = 240
* CHECK dout0_6 vdout0_6ck47 = 0 time = 240
* CHECK dout0_7 vdout0_7ck47 = 0.95 time = 240
* CHECK dout0_8 vdout0_8ck47 = 0.95 time = 240
* CHECK dout0_9 vdout0_9ck47 = 0 time = 240
* CHECK dout0_10 vdout0_10ck47 = 0.95 time = 240
* CHECK dout0_11 vdout0_11ck47 = 0 time = 240
* CHECK dout0_12 vdout0_12ck47 = 0.95 time = 240
* CHECK dout0_13 vdout0_13ck47 = 0 time = 240
* CHECK dout0_14 vdout0_14ck47 = 0.95 time = 240
* CHECK dout0_15 vdout0_15ck47 = 0 time = 240
* CHECK dout0_16 vdout0_16ck47 = 0 time = 240
* CHECK dout0_17 vdout0_17ck47 = 0.95 time = 240
* CHECK dout0_18 vdout0_18ck47 = 0 time = 240
* CHECK dout0_19 vdout0_19ck47 = 0 time = 240
* CHECK dout0_20 vdout0_20ck47 = 0.95 time = 240
* CHECK dout0_21 vdout0_21ck47 = 0 time = 240
* CHECK dout0_22 vdout0_22ck47 = 0.95 time = 240
* CHECK dout0_23 vdout0_23ck47 = 0.95 time = 240
* CHECK dout0_24 vdout0_24ck47 = 0.95 time = 240
* CHECK dout0_25 vdout0_25ck47 = 0 time = 240
* CHECK dout0_26 vdout0_26ck47 = 0 time = 240
* CHECK dout0_27 vdout0_27ck47 = 0 time = 240
* CHECK dout0_28 vdout0_28ck47 = 0.95 time = 240
* CHECK dout0_29 vdout0_29ck47 = 0 time = 240
* CHECK dout0_30 vdout0_30ck47 = 0.95 time = 240
* CHECK dout0_31 vdout0_31ck47 = 0 time = 240
* CHECK dout0_0 vdout0_0ck51 = 0.95 time = 260
* CHECK dout0_1 vdout0_1ck51 = 0 time = 260
* CHECK dout0_2 vdout0_2ck51 = 0.95 time = 260
* CHECK dout0_3 vdout0_3ck51 = 0.95 time = 260
* CHECK dout0_4 vdout0_4ck51 = 0 time = 260
* CHECK dout0_5 vdout0_5ck51 = 0 time = 260
* CHECK dout0_6 vdout0_6ck51 = 0 time = 260
* CHECK dout0_7 vdout0_7ck51 = 0 time = 260
* CHECK dout0_8 vdout0_8ck51 = 0.95 time = 260
* CHECK dout0_9 vdout0_9ck51 = 0 time = 260
* CHECK dout0_10 vdout0_10ck51 = 0 time = 260
* CHECK dout0_11 vdout0_11ck51 = 0.95 time = 260
* CHECK dout0_12 vdout0_12ck51 = 0.95 time = 260
* CHECK dout0_13 vdout0_13ck51 = 0 time = 260
* CHECK dout0_14 vdout0_14ck51 = 0 time = 260
* CHECK dout0_15 vdout0_15ck51 = 0.95 time = 260
* CHECK dout0_16 vdout0_16ck51 = 0.95 time = 260
* CHECK dout0_17 vdout0_17ck51 = 0 time = 260
* CHECK dout0_18 vdout0_18ck51 = 0.95 time = 260
* CHECK dout0_19 vdout0_19ck51 = 0.95 time = 260
* CHECK dout0_20 vdout0_20ck51 = 0.95 time = 260
* CHECK dout0_21 vdout0_21ck51 = 0 time = 260
* CHECK dout0_22 vdout0_22ck51 = 0 time = 260
* CHECK dout0_23 vdout0_23ck51 = 0.95 time = 260
* CHECK dout0_24 vdout0_24ck51 = 0 time = 260
* CHECK dout0_25 vdout0_25ck51 = 0 time = 260
* CHECK dout0_26 vdout0_26ck51 = 0 time = 260
* CHECK dout0_27 vdout0_27ck51 = 0.95 time = 260
* CHECK dout0_28 vdout0_28ck51 = 0.95 time = 260
* CHECK dout0_29 vdout0_29ck51 = 0.95 time = 260
* CHECK dout0_30 vdout0_30ck51 = 0 time = 260
* CHECK dout0_31 vdout0_31ck51 = 0.95 time = 260
* CHECK dout0_0 vdout0_0ck52 = 0 time = 265
* CHECK dout0_1 vdout0_1ck52 = 0.95 time = 265
* CHECK dout0_2 vdout0_2ck52 = 0 time = 265
* CHECK dout0_3 vdout0_3ck52 = 0 time = 265
* CHECK dout0_4 vdout0_4ck52 = 0 time = 265
* CHECK dout0_5 vdout0_5ck52 = 0 time = 265
* CHECK dout0_6 vdout0_6ck52 = 0.95 time = 265
* CHECK dout0_7 vdout0_7ck52 = 0 time = 265
* CHECK dout0_8 vdout0_8ck52 = 0.95 time = 265
* CHECK dout0_9 vdout0_9ck52 = 0 time = 265
* CHECK dout0_10 vdout0_10ck52 = 0.95 time = 265
* CHECK dout0_11 vdout0_11ck52 = 0 time = 265
* CHECK dout0_12 vdout0_12ck52 = 0.95 time = 265
* CHECK dout0_13 vdout0_13ck52 = 0.95 time = 265
* CHECK dout0_14 vdout0_14ck52 = 0 time = 265
* CHECK dout0_15 vdout0_15ck52 = 0.95 time = 265
* CHECK dout0_16 vdout0_16ck52 = 0.95 time = 265
* CHECK dout0_17 vdout0_17ck52 = 0 time = 265
* CHECK dout0_18 vdout0_18ck52 = 0.95 time = 265
* CHECK dout0_19 vdout0_19ck52 = 0 time = 265
* CHECK dout0_20 vdout0_20ck52 = 0.95 time = 265
* CHECK dout0_21 vdout0_21ck52 = 0 time = 265
* CHECK dout0_22 vdout0_22ck52 = 0.95 time = 265
* CHECK dout0_23 vdout0_23ck52 = 0.95 time = 265
* CHECK dout0_24 vdout0_24ck52 = 0 time = 265
* CHECK dout0_25 vdout0_25ck52 = 0 time = 265
* CHECK dout0_26 vdout0_26ck52 = 0.95 time = 265
* CHECK dout0_27 vdout0_27ck52 = 0.95 time = 265
* CHECK dout0_28 vdout0_28ck52 = 0.95 time = 265
* CHECK dout0_29 vdout0_29ck52 = 0.95 time = 265
* CHECK dout0_30 vdout0_30ck52 = 0 time = 265
* CHECK dout0_31 vdout0_31ck52 = 0 time = 265
* CHECK dout0_0 vdout0_0ck56 = 0 time = 285
* CHECK dout0_1 vdout0_1ck56 = 0 time = 285
* CHECK dout0_2 vdout0_2ck56 = 0.95 time = 285
* CHECK dout0_3 vdout0_3ck56 = 0 time = 285
* CHECK dout0_4 vdout0_4ck56 = 0.95 time = 285
* CHECK dout0_5 vdout0_5ck56 = 0 time = 285
* CHECK dout0_6 vdout0_6ck56 = 0 time = 285
* CHECK dout0_7 vdout0_7ck56 = 0.95 time = 285
* CHECK dout0_8 vdout0_8ck56 = 0 time = 285
* CHECK dout0_9 vdout0_9ck56 = 0 time = 285
* CHECK dout0_10 vdout0_10ck56 = 0 time = 285
* CHECK dout0_11 vdout0_11ck56 = 0.95 time = 285
* CHECK dout0_12 vdout0_12ck56 = 0.95 time = 285
* CHECK dout0_13 vdout0_13ck56 = 0 time = 285
* CHECK dout0_14 vdout0_14ck56 = 0.95 time = 285
* CHECK dout0_15 vdout0_15ck56 = 0 time = 285
* CHECK dout0_16 vdout0_16ck56 = 0 time = 285
* CHECK dout0_17 vdout0_17ck56 = 0.95 time = 285
* CHECK dout0_18 vdout0_18ck56 = 0 time = 285
* CHECK dout0_19 vdout0_19ck56 = 0 time = 285
* CHECK dout0_20 vdout0_20ck56 = 0.95 time = 285
* CHECK dout0_21 vdout0_21ck56 = 0 time = 285
* CHECK dout0_22 vdout0_22ck56 = 0.95 time = 285
* CHECK dout0_23 vdout0_23ck56 = 0.95 time = 285
* CHECK dout0_24 vdout0_24ck56 = 0.95 time = 285
* CHECK dout0_25 vdout0_25ck56 = 0.95 time = 285
* CHECK dout0_26 vdout0_26ck56 = 0 time = 285
* CHECK dout0_27 vdout0_27ck56 = 0.95 time = 285
* CHECK dout0_28 vdout0_28ck56 = 0.95 time = 285
* CHECK dout0_29 vdout0_29ck56 = 0 time = 285
* CHECK dout0_30 vdout0_30ck56 = 0 time = 285
* CHECK dout0_31 vdout0_31ck56 = 0.95 time = 285
* CHECK dout0_0 vdout0_0ck59 = 0 time = 300
* CHECK dout0_1 vdout0_1ck59 = 0 time = 300
* CHECK dout0_2 vdout0_2ck59 = 0.95 time = 300
* CHECK dout0_3 vdout0_3ck59 = 0.95 time = 300
* CHECK dout0_4 vdout0_4ck59 = 0.95 time = 300
* CHECK dout0_5 vdout0_5ck59 = 0 time = 300
* CHECK dout0_6 vdout0_6ck59 = 0 time = 300
* CHECK dout0_7 vdout0_7ck59 = 0.95 time = 300
* CHECK dout0_8 vdout0_8ck59 = 0 time = 300
* CHECK dout0_9 vdout0_9ck59 = 0 time = 300
* CHECK dout0_10 vdout0_10ck59 = 0.95 time = 300
* CHECK dout0_11 vdout0_11ck59 = 0 time = 300
* CHECK dout0_12 vdout0_12ck59 = 0 time = 300
* CHECK dout0_13 vdout0_13ck59 = 0.95 time = 300
* CHECK dout0_14 vdout0_14ck59 = 0 time = 300
* CHECK dout0_15 vdout0_15ck59 = 0.95 time = 300
* CHECK dout0_16 vdout0_16ck59 = 0.95 time = 300
* CHECK dout0_17 vdout0_17ck59 = 0 time = 300
* CHECK dout0_18 vdout0_18ck59 = 0 time = 300
* CHECK dout0_19 vdout0_19ck59 = 0 time = 300
* CHECK dout0_20 vdout0_20ck59 = 0 time = 300
* CHECK dout0_21 vdout0_21ck59 = 0 time = 300
* CHECK dout0_22 vdout0_22ck59 = 0 time = 300
* CHECK dout0_23 vdout0_23ck59 = 0.95 time = 300
* CHECK dout0_24 vdout0_24ck59 = 0.95 time = 300
* CHECK dout0_25 vdout0_25ck59 = 0 time = 300
* CHECK dout0_26 vdout0_26ck59 = 0 time = 300
* CHECK dout0_27 vdout0_27ck59 = 0 time = 300
* CHECK dout0_28 vdout0_28ck59 = 0 time = 300
* CHECK dout0_29 vdout0_29ck59 = 0.95 time = 300
* CHECK dout0_30 vdout0_30ck59 = 0 time = 300
* CHECK dout0_31 vdout0_31ck59 = 0.95 time = 300
* CHECK dout0_0 vdout0_0ck62 = 0 time = 315
* CHECK dout0_1 vdout0_1ck62 = 0.95 time = 315
* CHECK dout0_2 vdout0_2ck62 = 0.95 time = 315
* CHECK dout0_3 vdout0_3ck62 = 0.95 time = 315
* CHECK dout0_4 vdout0_4ck62 = 0.95 time = 315
* CHECK dout0_5 vdout0_5ck62 = 0 time = 315
* CHECK dout0_6 vdout0_6ck62 = 0.95 time = 315
* CHECK dout0_7 vdout0_7ck62 = 0 time = 315
* CHECK dout0_8 vdout0_8ck62 = 0.95 time = 315
* CHECK dout0_9 vdout0_9ck62 = 0.95 time = 315
* CHECK dout0_10 vdout0_10ck62 = 0.95 time = 315
* CHECK dout0_11 vdout0_11ck62 = 0 time = 315
* CHECK dout0_12 vdout0_12ck62 = 0.95 time = 315
* CHECK dout0_13 vdout0_13ck62 = 0.95 time = 315
* CHECK dout0_14 vdout0_14ck62 = 0.95 time = 315
* CHECK dout0_15 vdout0_15ck62 = 0.95 time = 315
* CHECK dout0_16 vdout0_16ck62 = 0.95 time = 315
* CHECK dout0_17 vdout0_17ck62 = 0 time = 315
* CHECK dout0_18 vdout0_18ck62 = 0.95 time = 315
* CHECK dout0_19 vdout0_19ck62 = 0 time = 315
* CHECK dout0_20 vdout0_20ck62 = 0.95 time = 315
* CHECK dout0_21 vdout0_21ck62 = 0 time = 315
* CHECK dout0_22 vdout0_22ck62 = 0.95 time = 315
* CHECK dout0_23 vdout0_23ck62 = 0.95 time = 315
* CHECK dout0_24 vdout0_24ck62 = 0 time = 315
* CHECK dout0_25 vdout0_25ck62 = 0.95 time = 315
* CHECK dout0_26 vdout0_26ck62 = 0.95 time = 315
* CHECK dout0_27 vdout0_27ck62 = 0.95 time = 315
* CHECK dout0_28 vdout0_28ck62 = 0 time = 315
* CHECK dout0_29 vdout0_29ck62 = 0.95 time = 315
* CHECK dout0_30 vdout0_30ck62 = 0 time = 315
* CHECK dout0_31 vdout0_31ck62 = 0.95 time = 315
* CHECK dout0_0 vdout0_0ck66 = 0 time = 335
* CHECK dout0_1 vdout0_1ck66 = 0 time = 335
* CHECK dout0_2 vdout0_2ck66 = 0.95 time = 335
* CHECK dout0_3 vdout0_3ck66 = 0.95 time = 335
* CHECK dout0_4 vdout0_4ck66 = 0.95 time = 335
* CHECK dout0_5 vdout0_5ck66 = 0 time = 335
* CHECK dout0_6 vdout0_6ck66 = 0 time = 335
* CHECK dout0_7 vdout0_7ck66 = 0 time = 335
* CHECK dout0_8 vdout0_8ck66 = 0.95 time = 335
* CHECK dout0_9 vdout0_9ck66 = 0 time = 335
* CHECK dout0_10 vdout0_10ck66 = 0 time = 335
* CHECK dout0_11 vdout0_11ck66 = 0.95 time = 335
* CHECK dout0_12 vdout0_12ck66 = 0 time = 335
* CHECK dout0_13 vdout0_13ck66 = 0.95 time = 335
* CHECK dout0_14 vdout0_14ck66 = 0 time = 335
* CHECK dout0_15 vdout0_15ck66 = 0.95 time = 335
* CHECK dout0_16 vdout0_16ck66 = 0 time = 335
* CHECK dout0_17 vdout0_17ck66 = 0 time = 335
* CHECK dout0_18 vdout0_18ck66 = 0.95 time = 335
* CHECK dout0_19 vdout0_19ck66 = 0.95 time = 335
* CHECK dout0_20 vdout0_20ck66 = 0 time = 335
* CHECK dout0_21 vdout0_21ck66 = 0.95 time = 335
* CHECK dout0_22 vdout0_22ck66 = 0.95 time = 335
* CHECK dout0_23 vdout0_23ck66 = 0.95 time = 335
* CHECK dout0_24 vdout0_24ck66 = 0 time = 335
* CHECK dout0_25 vdout0_25ck66 = 0.95 time = 335
* CHECK dout0_26 vdout0_26ck66 = 0 time = 335
* CHECK dout0_27 vdout0_27ck66 = 0 time = 335
* CHECK dout0_28 vdout0_28ck66 = 0 time = 335
* CHECK dout0_29 vdout0_29ck66 = 0.95 time = 335
* CHECK dout0_30 vdout0_30ck66 = 0.95 time = 335
* CHECK dout0_31 vdout0_31ck66 = 0.95 time = 335
* CHECK dout0_0 vdout0_0ck67 = 0.95 time = 340
* CHECK dout0_1 vdout0_1ck67 = 0 time = 340
* CHECK dout0_2 vdout0_2ck67 = 0 time = 340
* CHECK dout0_3 vdout0_3ck67 = 0 time = 340
* CHECK dout0_4 vdout0_4ck67 = 0.95 time = 340
* CHECK dout0_5 vdout0_5ck67 = 0.95 time = 340
* CHECK dout0_6 vdout0_6ck67 = 0.95 time = 340
* CHECK dout0_7 vdout0_7ck67 = 0 time = 340
* CHECK dout0_8 vdout0_8ck67 = 0 time = 340
* CHECK dout0_9 vdout0_9ck67 = 0.95 time = 340
* CHECK dout0_10 vdout0_10ck67 = 0 time = 340
* CHECK dout0_11 vdout0_11ck67 = 0.95 time = 340
* CHECK dout0_12 vdout0_12ck67 = 0 time = 340
* CHECK dout0_13 vdout0_13ck67 = 0 time = 340
* CHECK dout0_14 vdout0_14ck67 = 0 time = 340
* CHECK dout0_15 vdout0_15ck67 = 0 time = 340
* CHECK dout0_16 vdout0_16ck67 = 0 time = 340
* CHECK dout0_17 vdout0_17ck67 = 0 time = 340
* CHECK dout0_18 vdout0_18ck67 = 0.95 time = 340
* CHECK dout0_19 vdout0_19ck67 = 0 time = 340
* CHECK dout0_20 vdout0_20ck67 = 0.95 time = 340
* CHECK dout0_21 vdout0_21ck67 = 0.95 time = 340
* CHECK dout0_22 vdout0_22ck67 = 0.95 time = 340
* CHECK dout0_23 vdout0_23ck67 = 0.95 time = 340
* CHECK dout0_24 vdout0_24ck67 = 0.95 time = 340
* CHECK dout0_25 vdout0_25ck67 = 0 time = 340
* CHECK dout0_26 vdout0_26ck67 = 0.95 time = 340
* CHECK dout0_27 vdout0_27ck67 = 0.95 time = 340
* CHECK dout0_28 vdout0_28ck67 = 0 time = 340
* CHECK dout0_29 vdout0_29ck67 = 0.95 time = 340
* CHECK dout0_30 vdout0_30ck67 = 0 time = 340
* CHECK dout0_31 vdout0_31ck67 = 0 time = 340
* CHECK dout0_0 vdout0_0ck68 = 0 time = 345
* CHECK dout0_1 vdout0_1ck68 = 0 time = 345
* CHECK dout0_2 vdout0_2ck68 = 0 time = 345
* CHECK dout0_3 vdout0_3ck68 = 0 time = 345
* CHECK dout0_4 vdout0_4ck68 = 0.95 time = 345
* CHECK dout0_5 vdout0_5ck68 = 0.95 time = 345
* CHECK dout0_6 vdout0_6ck68 = 0 time = 345
* CHECK dout0_7 vdout0_7ck68 = 0 time = 345
* CHECK dout0_8 vdout0_8ck68 = 0.95 time = 345
* CHECK dout0_9 vdout0_9ck68 = 0.95 time = 345
* CHECK dout0_10 vdout0_10ck68 = 0.95 time = 345
* CHECK dout0_11 vdout0_11ck68 = 0.95 time = 345
* CHECK dout0_12 vdout0_12ck68 = 0.95 time = 345
* CHECK dout0_13 vdout0_13ck68 = 0 time = 345
* CHECK dout0_14 vdout0_14ck68 = 0.95 time = 345
* CHECK dout0_15 vdout0_15ck68 = 0 time = 345
* CHECK dout0_16 vdout0_16ck68 = 0.95 time = 345
* CHECK dout0_17 vdout0_17ck68 = 0 time = 345
* CHECK dout0_18 vdout0_18ck68 = 0.95 time = 345
* CHECK dout0_19 vdout0_19ck68 = 0 time = 345
* CHECK dout0_20 vdout0_20ck68 = 0.95 time = 345
* CHECK dout0_21 vdout0_21ck68 = 0.95 time = 345
* CHECK dout0_22 vdout0_22ck68 = 0 time = 345
* CHECK dout0_23 vdout0_23ck68 = 0.95 time = 345
* CHECK dout0_24 vdout0_24ck68 = 0 time = 345
* CHECK dout0_25 vdout0_25ck68 = 0 time = 345
* CHECK dout0_26 vdout0_26ck68 = 0 time = 345
* CHECK dout0_27 vdout0_27ck68 = 0.95 time = 345
* CHECK dout0_28 vdout0_28ck68 = 0 time = 345
* CHECK dout0_29 vdout0_29ck68 = 0.95 time = 345
* CHECK dout0_30 vdout0_30ck68 = 0.95 time = 345
* CHECK dout0_31 vdout0_31ck68 = 0 time = 345
* CHECK dout0_0 vdout0_0ck70 = 0 time = 355
* CHECK dout0_1 vdout0_1ck70 = 0 time = 355
* CHECK dout0_2 vdout0_2ck70 = 0.95 time = 355
* CHECK dout0_3 vdout0_3ck70 = 0.95 time = 355
* CHECK dout0_4 vdout0_4ck70 = 0.95 time = 355
* CHECK dout0_5 vdout0_5ck70 = 0 time = 355
* CHECK dout0_6 vdout0_6ck70 = 0 time = 355
* CHECK dout0_7 vdout0_7ck70 = 0 time = 355
* CHECK dout0_8 vdout0_8ck70 = 0.95 time = 355
* CHECK dout0_9 vdout0_9ck70 = 0 time = 355
* CHECK dout0_10 vdout0_10ck70 = 0 time = 355
* CHECK dout0_11 vdout0_11ck70 = 0.95 time = 355
* CHECK dout0_12 vdout0_12ck70 = 0 time = 355
* CHECK dout0_13 vdout0_13ck70 = 0.95 time = 355
* CHECK dout0_14 vdout0_14ck70 = 0 time = 355
* CHECK dout0_15 vdout0_15ck70 = 0.95 time = 355
* CHECK dout0_16 vdout0_16ck70 = 0 time = 355
* CHECK dout0_17 vdout0_17ck70 = 0 time = 355
* CHECK dout0_18 vdout0_18ck70 = 0.95 time = 355
* CHECK dout0_19 vdout0_19ck70 = 0.95 time = 355
* CHECK dout0_20 vdout0_20ck70 = 0 time = 355
* CHECK dout0_21 vdout0_21ck70 = 0.95 time = 355
* CHECK dout0_22 vdout0_22ck70 = 0.95 time = 355
* CHECK dout0_23 vdout0_23ck70 = 0.95 time = 355
* CHECK dout0_24 vdout0_24ck70 = 0 time = 355
* CHECK dout0_25 vdout0_25ck70 = 0.95 time = 355
* CHECK dout0_26 vdout0_26ck70 = 0 time = 355
* CHECK dout0_27 vdout0_27ck70 = 0 time = 355
* CHECK dout0_28 vdout0_28ck70 = 0 time = 355
* CHECK dout0_29 vdout0_29ck70 = 0.95 time = 355
* CHECK dout0_30 vdout0_30ck70 = 0.95 time = 355
* CHECK dout0_31 vdout0_31ck70 = 0.95 time = 355
* CHECK dout0_0 vdout0_0ck71 = 0 time = 360
* CHECK dout0_1 vdout0_1ck71 = 0 time = 360
* CHECK dout0_2 vdout0_2ck71 = 0.95 time = 360
* CHECK dout0_3 vdout0_3ck71 = 0 time = 360
* CHECK dout0_4 vdout0_4ck71 = 0.95 time = 360
* CHECK dout0_5 vdout0_5ck71 = 0 time = 360
* CHECK dout0_6 vdout0_6ck71 = 0 time = 360
* CHECK dout0_7 vdout0_7ck71 = 0.95 time = 360
* CHECK dout0_8 vdout0_8ck71 = 0 time = 360
* CHECK dout0_9 vdout0_9ck71 = 0 time = 360
* CHECK dout0_10 vdout0_10ck71 = 0 time = 360
* CHECK dout0_11 vdout0_11ck71 = 0.95 time = 360
* CHECK dout0_12 vdout0_12ck71 = 0.95 time = 360
* CHECK dout0_13 vdout0_13ck71 = 0 time = 360
* CHECK dout0_14 vdout0_14ck71 = 0.95 time = 360
* CHECK dout0_15 vdout0_15ck71 = 0 time = 360
* CHECK dout0_16 vdout0_16ck71 = 0 time = 360
* CHECK dout0_17 vdout0_17ck71 = 0.95 time = 360
* CHECK dout0_18 vdout0_18ck71 = 0 time = 360
* CHECK dout0_19 vdout0_19ck71 = 0 time = 360
* CHECK dout0_20 vdout0_20ck71 = 0.95 time = 360
* CHECK dout0_21 vdout0_21ck71 = 0 time = 360
* CHECK dout0_22 vdout0_22ck71 = 0.95 time = 360
* CHECK dout0_23 vdout0_23ck71 = 0.95 time = 360
* CHECK dout0_24 vdout0_24ck71 = 0.95 time = 360
* CHECK dout0_25 vdout0_25ck71 = 0.95 time = 360
* CHECK dout0_26 vdout0_26ck71 = 0 time = 360
* CHECK dout0_27 vdout0_27ck71 = 0.95 time = 360
* CHECK dout0_28 vdout0_28ck71 = 0.95 time = 360
* CHECK dout0_29 vdout0_29ck71 = 0 time = 360
* CHECK dout0_30 vdout0_30ck71 = 0 time = 360
* CHECK dout0_31 vdout0_31ck71 = 0.95 time = 360
* CHECK dout0_0 vdout0_0ck74 = 0 time = 375
* CHECK dout0_1 vdout0_1ck74 = 0 time = 375
* CHECK dout0_2 vdout0_2ck74 = 0.95 time = 375
* CHECK dout0_3 vdout0_3ck74 = 0.95 time = 375
* CHECK dout0_4 vdout0_4ck74 = 0.95 time = 375
* CHECK dout0_5 vdout0_5ck74 = 0 time = 375
* CHECK dout0_6 vdout0_6ck74 = 0 time = 375
* CHECK dout0_7 vdout0_7ck74 = 0 time = 375
* CHECK dout0_8 vdout0_8ck74 = 0.95 time = 375
* CHECK dout0_9 vdout0_9ck74 = 0 time = 375
* CHECK dout0_10 vdout0_10ck74 = 0 time = 375
* CHECK dout0_11 vdout0_11ck74 = 0.95 time = 375
* CHECK dout0_12 vdout0_12ck74 = 0 time = 375
* CHECK dout0_13 vdout0_13ck74 = 0.95 time = 375
* CHECK dout0_14 vdout0_14ck74 = 0 time = 375
* CHECK dout0_15 vdout0_15ck74 = 0.95 time = 375
* CHECK dout0_16 vdout0_16ck74 = 0 time = 375
* CHECK dout0_17 vdout0_17ck74 = 0 time = 375
* CHECK dout0_18 vdout0_18ck74 = 0.95 time = 375
* CHECK dout0_19 vdout0_19ck74 = 0.95 time = 375
* CHECK dout0_20 vdout0_20ck74 = 0 time = 375
* CHECK dout0_21 vdout0_21ck74 = 0.95 time = 375
* CHECK dout0_22 vdout0_22ck74 = 0.95 time = 375
* CHECK dout0_23 vdout0_23ck74 = 0.95 time = 375
* CHECK dout0_24 vdout0_24ck74 = 0 time = 375
* CHECK dout0_25 vdout0_25ck74 = 0.95 time = 375
* CHECK dout0_26 vdout0_26ck74 = 0 time = 375
* CHECK dout0_27 vdout0_27ck74 = 0 time = 375
* CHECK dout0_28 vdout0_28ck74 = 0 time = 375
* CHECK dout0_29 vdout0_29ck74 = 0.95 time = 375
* CHECK dout0_30 vdout0_30ck74 = 0.95 time = 375
* CHECK dout0_31 vdout0_31ck74 = 0.95 time = 375
* CHECK dout0_0 vdout0_0ck75 = 0 time = 380
* CHECK dout0_1 vdout0_1ck75 = 0.95 time = 380
* CHECK dout0_2 vdout0_2ck75 = 0.95 time = 380
* CHECK dout0_3 vdout0_3ck75 = 0.95 time = 380
* CHECK dout0_4 vdout0_4ck75 = 0.95 time = 380
* CHECK dout0_5 vdout0_5ck75 = 0 time = 380
* CHECK dout0_6 vdout0_6ck75 = 0.95 time = 380
* CHECK dout0_7 vdout0_7ck75 = 0 time = 380
* CHECK dout0_8 vdout0_8ck75 = 0.95 time = 380
* CHECK dout0_9 vdout0_9ck75 = 0.95 time = 380
* CHECK dout0_10 vdout0_10ck75 = 0.95 time = 380
* CHECK dout0_11 vdout0_11ck75 = 0 time = 380
* CHECK dout0_12 vdout0_12ck75 = 0.95 time = 380
* CHECK dout0_13 vdout0_13ck75 = 0.95 time = 380
* CHECK dout0_14 vdout0_14ck75 = 0.95 time = 380
* CHECK dout0_15 vdout0_15ck75 = 0.95 time = 380
* CHECK dout0_16 vdout0_16ck75 = 0.95 time = 380
* CHECK dout0_17 vdout0_17ck75 = 0 time = 380
* CHECK dout0_18 vdout0_18ck75 = 0.95 time = 380
* CHECK dout0_19 vdout0_19ck75 = 0 time = 380
* CHECK dout0_20 vdout0_20ck75 = 0.95 time = 380
* CHECK dout0_21 vdout0_21ck75 = 0 time = 380
* CHECK dout0_22 vdout0_22ck75 = 0.95 time = 380
* CHECK dout0_23 vdout0_23ck75 = 0.95 time = 380
* CHECK dout0_24 vdout0_24ck75 = 0.95 time = 380
* CHECK dout0_25 vdout0_25ck75 = 0.95 time = 380
* CHECK dout0_26 vdout0_26ck75 = 0.95 time = 380
* CHECK dout0_27 vdout0_27ck75 = 0.95 time = 380
* CHECK dout0_28 vdout0_28ck75 = 0.95 time = 380
* CHECK dout0_29 vdout0_29ck75 = 0.95 time = 380
* CHECK dout0_30 vdout0_30ck75 = 0.95 time = 380
* CHECK dout0_31 vdout0_31ck75 = 0 time = 380
* CHECK dout0_0 vdout0_0ck76 = 0 time = 385
* CHECK dout0_1 vdout0_1ck76 = 0 time = 385
* CHECK dout0_2 vdout0_2ck76 = 0 time = 385
* CHECK dout0_3 vdout0_3ck76 = 0 time = 385
* CHECK dout0_4 vdout0_4ck76 = 0.95 time = 385
* CHECK dout0_5 vdout0_5ck76 = 0.95 time = 385
* CHECK dout0_6 vdout0_6ck76 = 0 time = 385
* CHECK dout0_7 vdout0_7ck76 = 0 time = 385
* CHECK dout0_8 vdout0_8ck76 = 0.95 time = 385
* CHECK dout0_9 vdout0_9ck76 = 0.95 time = 385
* CHECK dout0_10 vdout0_10ck76 = 0.95 time = 385
* CHECK dout0_11 vdout0_11ck76 = 0.95 time = 385
* CHECK dout0_12 vdout0_12ck76 = 0.95 time = 385
* CHECK dout0_13 vdout0_13ck76 = 0 time = 385
* CHECK dout0_14 vdout0_14ck76 = 0.95 time = 385
* CHECK dout0_15 vdout0_15ck76 = 0 time = 385
* CHECK dout0_16 vdout0_16ck76 = 0.95 time = 385
* CHECK dout0_17 vdout0_17ck76 = 0 time = 385
* CHECK dout0_18 vdout0_18ck76 = 0.95 time = 385
* CHECK dout0_19 vdout0_19ck76 = 0 time = 385
* CHECK dout0_20 vdout0_20ck76 = 0.95 time = 385
* CHECK dout0_21 vdout0_21ck76 = 0.95 time = 385
* CHECK dout0_22 vdout0_22ck76 = 0 time = 385
* CHECK dout0_23 vdout0_23ck76 = 0.95 time = 385
* CHECK dout0_24 vdout0_24ck76 = 0 time = 385
* CHECK dout0_25 vdout0_25ck76 = 0 time = 385
* CHECK dout0_26 vdout0_26ck76 = 0 time = 385
* CHECK dout0_27 vdout0_27ck76 = 0.95 time = 385
* CHECK dout0_28 vdout0_28ck76 = 0 time = 385
* CHECK dout0_29 vdout0_29ck76 = 0.95 time = 385
* CHECK dout0_30 vdout0_30ck76 = 0.95 time = 385
* CHECK dout0_31 vdout0_31ck76 = 0 time = 385
* CHECK dout0_0 vdout0_0ck77 = 0.95 time = 390
* CHECK dout0_1 vdout0_1ck77 = 0 time = 390
* CHECK dout0_2 vdout0_2ck77 = 0 time = 390
* CHECK dout0_3 vdout0_3ck77 = 0 time = 390
* CHECK dout0_4 vdout0_4ck77 = 0.95 time = 390
* CHECK dout0_5 vdout0_5ck77 = 0.95 time = 390
* CHECK dout0_6 vdout0_6ck77 = 0.95 time = 390
* CHECK dout0_7 vdout0_7ck77 = 0 time = 390
* CHECK dout0_8 vdout0_8ck77 = 0 time = 390
* CHECK dout0_9 vdout0_9ck77 = 0.95 time = 390
* CHECK dout0_10 vdout0_10ck77 = 0 time = 390
* CHECK dout0_11 vdout0_11ck77 = 0.95 time = 390
* CHECK dout0_12 vdout0_12ck77 = 0 time = 390
* CHECK dout0_13 vdout0_13ck77 = 0 time = 390
* CHECK dout0_14 vdout0_14ck77 = 0 time = 390
* CHECK dout0_15 vdout0_15ck77 = 0 time = 390
* CHECK dout0_16 vdout0_16ck77 = 0 time = 390
* CHECK dout0_17 vdout0_17ck77 = 0 time = 390
* CHECK dout0_18 vdout0_18ck77 = 0.95 time = 390
* CHECK dout0_19 vdout0_19ck77 = 0 time = 390
* CHECK dout0_20 vdout0_20ck77 = 0.95 time = 390
* CHECK dout0_21 vdout0_21ck77 = 0.95 time = 390
* CHECK dout0_22 vdout0_22ck77 = 0.95 time = 390
* CHECK dout0_23 vdout0_23ck77 = 0.95 time = 390
* CHECK dout0_24 vdout0_24ck77 = 0.95 time = 390
* CHECK dout0_25 vdout0_25ck77 = 0 time = 390
* CHECK dout0_26 vdout0_26ck77 = 0.95 time = 390
* CHECK dout0_27 vdout0_27ck77 = 0.95 time = 390
* CHECK dout0_28 vdout0_28ck77 = 0 time = 390
* CHECK dout0_29 vdout0_29ck77 = 0.95 time = 390
* CHECK dout0_30 vdout0_30ck77 = 0 time = 390
* CHECK dout0_31 vdout0_31ck77 = 0 time = 390
* CHECK dout0_0 vdout0_0ck79 = 0 time = 400
* CHECK dout0_1 vdout0_1ck79 = 0 time = 400
* CHECK dout0_2 vdout0_2ck79 = 0.95 time = 400
* CHECK dout0_3 vdout0_3ck79 = 0.95 time = 400
* CHECK dout0_4 vdout0_4ck79 = 0.95 time = 400
* CHECK dout0_5 vdout0_5ck79 = 0 time = 400
* CHECK dout0_6 vdout0_6ck79 = 0 time = 400
* CHECK dout0_7 vdout0_7ck79 = 0.95 time = 400
* CHECK dout0_8 vdout0_8ck79 = 0 time = 400
* CHECK dout0_9 vdout0_9ck79 = 0 time = 400
* CHECK dout0_10 vdout0_10ck79 = 0.95 time = 400
* CHECK dout0_11 vdout0_11ck79 = 0 time = 400
* CHECK dout0_12 vdout0_12ck79 = 0 time = 400
* CHECK dout0_13 vdout0_13ck79 = 0.95 time = 400
* CHECK dout0_14 vdout0_14ck79 = 0 time = 400
* CHECK dout0_15 vdout0_15ck79 = 0.95 time = 400
* CHECK dout0_16 vdout0_16ck79 = 0.95 time = 400
* CHECK dout0_17 vdout0_17ck79 = 0 time = 400
* CHECK dout0_18 vdout0_18ck79 = 0 time = 400
* CHECK dout0_19 vdout0_19ck79 = 0 time = 400
* CHECK dout0_20 vdout0_20ck79 = 0 time = 400
* CHECK dout0_21 vdout0_21ck79 = 0 time = 400
* CHECK dout0_22 vdout0_22ck79 = 0 time = 400
* CHECK dout0_23 vdout0_23ck79 = 0.95 time = 400
* CHECK dout0_24 vdout0_24ck79 = 0.95 time = 400
* CHECK dout0_25 vdout0_25ck79 = 0 time = 400
* CHECK dout0_26 vdout0_26ck79 = 0 time = 400
* CHECK dout0_27 vdout0_27ck79 = 0 time = 400
* CHECK dout0_28 vdout0_28ck79 = 0 time = 400
* CHECK dout0_29 vdout0_29ck79 = 0.95 time = 400
* CHECK dout0_30 vdout0_30ck79 = 0 time = 400
* CHECK dout0_31 vdout0_31ck79 = 0.95 time = 400
* CHECK dout0_0 vdout0_0ck80 = 0.95 time = 405
* CHECK dout0_1 vdout0_1ck80 = 0 time = 405
* CHECK dout0_2 vdout0_2ck80 = 0.95 time = 405
* CHECK dout0_3 vdout0_3ck80 = 0.95 time = 405
* CHECK dout0_4 vdout0_4ck80 = 0 time = 405
* CHECK dout0_5 vdout0_5ck80 = 0 time = 405
* CHECK dout0_6 vdout0_6ck80 = 0 time = 405
* CHECK dout0_7 vdout0_7ck80 = 0.95 time = 405
* CHECK dout0_8 vdout0_8ck80 = 0.95 time = 405
* CHECK dout0_9 vdout0_9ck80 = 0.95 time = 405
* CHECK dout0_10 vdout0_10ck80 = 0.95 time = 405
* CHECK dout0_11 vdout0_11ck80 = 0 time = 405
* CHECK dout0_12 vdout0_12ck80 = 0.95 time = 405
* CHECK dout0_13 vdout0_13ck80 = 0 time = 405
* CHECK dout0_14 vdout0_14ck80 = 0.95 time = 405
* CHECK dout0_15 vdout0_15ck80 = 0 time = 405
* CHECK dout0_16 vdout0_16ck80 = 0.95 time = 405
* CHECK dout0_17 vdout0_17ck80 = 0.95 time = 405
* CHECK dout0_18 vdout0_18ck80 = 0.95 time = 405
* CHECK dout0_19 vdout0_19ck80 = 0 time = 405
* CHECK dout0_20 vdout0_20ck80 = 0.95 time = 405
* CHECK dout0_21 vdout0_21ck80 = 0 time = 405
* CHECK dout0_22 vdout0_22ck80 = 0.95 time = 405
* CHECK dout0_23 vdout0_23ck80 = 0 time = 405
* CHECK dout0_24 vdout0_24ck80 = 0.95 time = 405
* CHECK dout0_25 vdout0_25ck80 = 0 time = 405
* CHECK dout0_26 vdout0_26ck80 = 0 time = 405
* CHECK dout0_27 vdout0_27ck80 = 0 time = 405
* CHECK dout0_28 vdout0_28ck80 = 0.95 time = 405
* CHECK dout0_29 vdout0_29ck80 = 0 time = 405
* CHECK dout0_30 vdout0_30ck80 = 0 time = 405
* CHECK dout0_31 vdout0_31ck80 = 0.95 time = 405
* CHECK dout0_0 vdout0_0ck81 = 0.95 time = 410
* CHECK dout0_1 vdout0_1ck81 = 0 time = 410
* CHECK dout0_2 vdout0_2ck81 = 0.95 time = 410
* CHECK dout0_3 vdout0_3ck81 = 0.95 time = 410
* CHECK dout0_4 vdout0_4ck81 = 0 time = 410
* CHECK dout0_5 vdout0_5ck81 = 0 time = 410
* CHECK dout0_6 vdout0_6ck81 = 0 time = 410
* CHECK dout0_7 vdout0_7ck81 = 0.95 time = 410
* CHECK dout0_8 vdout0_8ck81 = 0.95 time = 410
* CHECK dout0_9 vdout0_9ck81 = 0.95 time = 410
* CHECK dout0_10 vdout0_10ck81 = 0.95 time = 410
* CHECK dout0_11 vdout0_11ck81 = 0 time = 410
* CHECK dout0_12 vdout0_12ck81 = 0.95 time = 410
* CHECK dout0_13 vdout0_13ck81 = 0 time = 410
* CHECK dout0_14 vdout0_14ck81 = 0.95 time = 410
* CHECK dout0_15 vdout0_15ck81 = 0 time = 410
* CHECK dout0_16 vdout0_16ck81 = 0.95 time = 410
* CHECK dout0_17 vdout0_17ck81 = 0.95 time = 410
* CHECK dout0_18 vdout0_18ck81 = 0.95 time = 410
* CHECK dout0_19 vdout0_19ck81 = 0 time = 410
* CHECK dout0_20 vdout0_20ck81 = 0.95 time = 410
* CHECK dout0_21 vdout0_21ck81 = 0 time = 410
* CHECK dout0_22 vdout0_22ck81 = 0.95 time = 410
* CHECK dout0_23 vdout0_23ck81 = 0 time = 410
* CHECK dout0_24 vdout0_24ck81 = 0.95 time = 410
* CHECK dout0_25 vdout0_25ck81 = 0 time = 410
* CHECK dout0_26 vdout0_26ck81 = 0 time = 410
* CHECK dout0_27 vdout0_27ck81 = 0 time = 410
* CHECK dout0_28 vdout0_28ck81 = 0.95 time = 410
* CHECK dout0_29 vdout0_29ck81 = 0 time = 410
* CHECK dout0_30 vdout0_30ck81 = 0 time = 410
* CHECK dout0_31 vdout0_31ck81 = 0.95 time = 410
* CHECK dout0_0 vdout0_0ck84 = 0 time = 425
* CHECK dout0_1 vdout0_1ck84 = 0 time = 425
* CHECK dout0_2 vdout0_2ck84 = 0.95 time = 425
* CHECK dout0_3 vdout0_3ck84 = 0.95 time = 425
* CHECK dout0_4 vdout0_4ck84 = 0.95 time = 425
* CHECK dout0_5 vdout0_5ck84 = 0 time = 425
* CHECK dout0_6 vdout0_6ck84 = 0 time = 425
* CHECK dout0_7 vdout0_7ck84 = 0 time = 425
* CHECK dout0_8 vdout0_8ck84 = 0.95 time = 425
* CHECK dout0_9 vdout0_9ck84 = 0 time = 425
* CHECK dout0_10 vdout0_10ck84 = 0.95 time = 425
* CHECK dout0_11 vdout0_11ck84 = 0.95 time = 425
* CHECK dout0_12 vdout0_12ck84 = 0.95 time = 425
* CHECK dout0_13 vdout0_13ck84 = 0.95 time = 425
* CHECK dout0_14 vdout0_14ck84 = 0 time = 425
* CHECK dout0_15 vdout0_15ck84 = 0 time = 425
* CHECK dout0_16 vdout0_16ck84 = 0.95 time = 425
* CHECK dout0_17 vdout0_17ck84 = 0.95 time = 425
* CHECK dout0_18 vdout0_18ck84 = 0.95 time = 425
* CHECK dout0_19 vdout0_19ck84 = 0.95 time = 425
* CHECK dout0_20 vdout0_20ck84 = 0 time = 425
* CHECK dout0_21 vdout0_21ck84 = 0 time = 425
* CHECK dout0_22 vdout0_22ck84 = 0 time = 425
* CHECK dout0_23 vdout0_23ck84 = 0 time = 425
* CHECK dout0_24 vdout0_24ck84 = 0.95 time = 425
* CHECK dout0_25 vdout0_25ck84 = 0.95 time = 425
* CHECK dout0_26 vdout0_26ck84 = 0 time = 425
* CHECK dout0_27 vdout0_27ck84 = 0.95 time = 425
* CHECK dout0_28 vdout0_28ck84 = 0 time = 425
* CHECK dout0_29 vdout0_29ck84 = 0.95 time = 425
* CHECK dout0_30 vdout0_30ck84 = 0 time = 425
* CHECK dout0_31 vdout0_31ck84 = 0 time = 425
* CHECK dout0_0 vdout0_0ck86 = 0.95 time = 435
* CHECK dout0_1 vdout0_1ck86 = 0 time = 435
* CHECK dout0_2 vdout0_2ck86 = 0 time = 435
* CHECK dout0_3 vdout0_3ck86 = 0 time = 435
* CHECK dout0_4 vdout0_4ck86 = 0.95 time = 435
* CHECK dout0_5 vdout0_5ck86 = 0.95 time = 435
* CHECK dout0_6 vdout0_6ck86 = 0.95 time = 435
* CHECK dout0_7 vdout0_7ck86 = 0 time = 435
* CHECK dout0_8 vdout0_8ck86 = 0 time = 435
* CHECK dout0_9 vdout0_9ck86 = 0.95 time = 435
* CHECK dout0_10 vdout0_10ck86 = 0 time = 435
* CHECK dout0_11 vdout0_11ck86 = 0.95 time = 435
* CHECK dout0_12 vdout0_12ck86 = 0 time = 435
* CHECK dout0_13 vdout0_13ck86 = 0 time = 435
* CHECK dout0_14 vdout0_14ck86 = 0 time = 435
* CHECK dout0_15 vdout0_15ck86 = 0 time = 435
* CHECK dout0_16 vdout0_16ck86 = 0 time = 435
* CHECK dout0_17 vdout0_17ck86 = 0 time = 435
* CHECK dout0_18 vdout0_18ck86 = 0.95 time = 435
* CHECK dout0_19 vdout0_19ck86 = 0 time = 435
* CHECK dout0_20 vdout0_20ck86 = 0.95 time = 435
* CHECK dout0_21 vdout0_21ck86 = 0.95 time = 435
* CHECK dout0_22 vdout0_22ck86 = 0.95 time = 435
* CHECK dout0_23 vdout0_23ck86 = 0.95 time = 435
* CHECK dout0_24 vdout0_24ck86 = 0.95 time = 435
* CHECK dout0_25 vdout0_25ck86 = 0 time = 435
* CHECK dout0_26 vdout0_26ck86 = 0.95 time = 435
* CHECK dout0_27 vdout0_27ck86 = 0.95 time = 435
* CHECK dout0_28 vdout0_28ck86 = 0 time = 435
* CHECK dout0_29 vdout0_29ck86 = 0.95 time = 435
* CHECK dout0_30 vdout0_30ck86 = 0 time = 435
* CHECK dout0_31 vdout0_31ck86 = 0 time = 435
* CHECK dout0_0 vdout0_0ck91 = 0 time = 460
* CHECK dout0_1 vdout0_1ck91 = 0 time = 460
* CHECK dout0_2 vdout0_2ck91 = 0.95 time = 460
* CHECK dout0_3 vdout0_3ck91 = 0.95 time = 460
* CHECK dout0_4 vdout0_4ck91 = 0.95 time = 460
* CHECK dout0_5 vdout0_5ck91 = 0 time = 460
* CHECK dout0_6 vdout0_6ck91 = 0 time = 460
* CHECK dout0_7 vdout0_7ck91 = 0 time = 460
* CHECK dout0_8 vdout0_8ck91 = 0.95 time = 460
* CHECK dout0_9 vdout0_9ck91 = 0 time = 460
* CHECK dout0_10 vdout0_10ck91 = 0.95 time = 460
* CHECK dout0_11 vdout0_11ck91 = 0.95 time = 460
* CHECK dout0_12 vdout0_12ck91 = 0.95 time = 460
* CHECK dout0_13 vdout0_13ck91 = 0.95 time = 460
* CHECK dout0_14 vdout0_14ck91 = 0 time = 460
* CHECK dout0_15 vdout0_15ck91 = 0 time = 460
* CHECK dout0_16 vdout0_16ck91 = 0.95 time = 460
* CHECK dout0_17 vdout0_17ck91 = 0.95 time = 460
* CHECK dout0_18 vdout0_18ck91 = 0.95 time = 460
* CHECK dout0_19 vdout0_19ck91 = 0.95 time = 460
* CHECK dout0_20 vdout0_20ck91 = 0 time = 460
* CHECK dout0_21 vdout0_21ck91 = 0 time = 460
* CHECK dout0_22 vdout0_22ck91 = 0 time = 460
* CHECK dout0_23 vdout0_23ck91 = 0 time = 460
* CHECK dout0_24 vdout0_24ck91 = 0.95 time = 460
* CHECK dout0_25 vdout0_25ck91 = 0.95 time = 460
* CHECK dout0_26 vdout0_26ck91 = 0 time = 460
* CHECK dout0_27 vdout0_27ck91 = 0.95 time = 460
* CHECK dout0_28 vdout0_28ck91 = 0 time = 460
* CHECK dout0_29 vdout0_29ck91 = 0.95 time = 460
* CHECK dout0_30 vdout0_30ck91 = 0 time = 460
* CHECK dout0_31 vdout0_31ck91 = 0 time = 460
* CHECK dout0_0 vdout0_0ck94 = 0 time = 475
* CHECK dout0_1 vdout0_1ck94 = 0 time = 475
* CHECK dout0_2 vdout0_2ck94 = 0.95 time = 475
* CHECK dout0_3 vdout0_3ck94 = 0.95 time = 475
* CHECK dout0_4 vdout0_4ck94 = 0.95 time = 475
* CHECK dout0_5 vdout0_5ck94 = 0 time = 475
* CHECK dout0_6 vdout0_6ck94 = 0 time = 475
* CHECK dout0_7 vdout0_7ck94 = 0 time = 475
* CHECK dout0_8 vdout0_8ck94 = 0 time = 475
* CHECK dout0_9 vdout0_9ck94 = 0 time = 475
* CHECK dout0_10 vdout0_10ck94 = 0.95 time = 475
* CHECK dout0_11 vdout0_11ck94 = 0 time = 475
* CHECK dout0_12 vdout0_12ck94 = 0.95 time = 475
* CHECK dout0_13 vdout0_13ck94 = 0.95 time = 475
* CHECK dout0_14 vdout0_14ck94 = 0.95 time = 475
* CHECK dout0_15 vdout0_15ck94 = 0 time = 475
* CHECK dout0_16 vdout0_16ck94 = 0.95 time = 475
* CHECK dout0_17 vdout0_17ck94 = 0.95 time = 475
* CHECK dout0_18 vdout0_18ck94 = 0.95 time = 475
* CHECK dout0_19 vdout0_19ck94 = 0 time = 475
* CHECK dout0_20 vdout0_20ck94 = 0.95 time = 475
* CHECK dout0_21 vdout0_21ck94 = 0.95 time = 475
* CHECK dout0_22 vdout0_22ck94 = 0.95 time = 475
* CHECK dout0_23 vdout0_23ck94 = 0 time = 475
* CHECK dout0_24 vdout0_24ck94 = 0 time = 475
* CHECK dout0_25 vdout0_25ck94 = 0.95 time = 475
* CHECK dout0_26 vdout0_26ck94 = 0 time = 475
* CHECK dout0_27 vdout0_27ck94 = 0.95 time = 475
* CHECK dout0_28 vdout0_28ck94 = 0.95 time = 475
* CHECK dout0_29 vdout0_29ck94 = 0.95 time = 475
* CHECK dout0_30 vdout0_30ck94 = 0 time = 475
* CHECK dout0_31 vdout0_31ck94 = 0.95 time = 475
* CHECK dout0_0 vdout0_0ck99 = 0 time = 500
* CHECK dout0_1 vdout0_1ck99 = 0 time = 500
* CHECK dout0_2 vdout0_2ck99 = 0.95 time = 500
* CHECK dout0_3 vdout0_3ck99 = 0.95 time = 500
* CHECK dout0_4 vdout0_4ck99 = 0.95 time = 500
* CHECK dout0_5 vdout0_5ck99 = 0 time = 500
* CHECK dout0_6 vdout0_6ck99 = 0 time = 500
* CHECK dout0_7 vdout0_7ck99 = 0 time = 500
* CHECK dout0_8 vdout0_8ck99 = 0.95 time = 500
* CHECK dout0_9 vdout0_9ck99 = 0 time = 500
* CHECK dout0_10 vdout0_10ck99 = 0.95 time = 500
* CHECK dout0_11 vdout0_11ck99 = 0.95 time = 500
* CHECK dout0_12 vdout0_12ck99 = 0.95 time = 500
* CHECK dout0_13 vdout0_13ck99 = 0.95 time = 500
* CHECK dout0_14 vdout0_14ck99 = 0 time = 500
* CHECK dout0_15 vdout0_15ck99 = 0 time = 500
* CHECK dout0_16 vdout0_16ck99 = 0.95 time = 500
* CHECK dout0_17 vdout0_17ck99 = 0.95 time = 500
* CHECK dout0_18 vdout0_18ck99 = 0.95 time = 500
* CHECK dout0_19 vdout0_19ck99 = 0.95 time = 500
* CHECK dout0_20 vdout0_20ck99 = 0 time = 500
* CHECK dout0_21 vdout0_21ck99 = 0 time = 500
* CHECK dout0_22 vdout0_22ck99 = 0 time = 500
* CHECK dout0_23 vdout0_23ck99 = 0 time = 500
* CHECK dout0_24 vdout0_24ck99 = 0.95 time = 500
* CHECK dout0_25 vdout0_25ck99 = 0.95 time = 500
* CHECK dout0_26 vdout0_26ck99 = 0 time = 500
* CHECK dout0_27 vdout0_27ck99 = 0.95 time = 500
* CHECK dout0_28 vdout0_28ck99 = 0 time = 500
* CHECK dout0_29 vdout0_29ck99 = 0.95 time = 500
* CHECK dout0_30 vdout0_30ck99 = 0 time = 500
* CHECK dout0_31 vdout0_31ck99 = 0 time = 500
* CHECK dout0_0 vdout0_0ck101 = 0 time = 510
* CHECK dout0_1 vdout0_1ck101 = 0 time = 510
* CHECK dout0_2 vdout0_2ck101 = 0 time = 510
* CHECK dout0_3 vdout0_3ck101 = 0 time = 510
* CHECK dout0_4 vdout0_4ck101 = 0.95 time = 510
* CHECK dout0_5 vdout0_5ck101 = 0.95 time = 510
* CHECK dout0_6 vdout0_6ck101 = 0 time = 510
* CHECK dout0_7 vdout0_7ck101 = 0 time = 510
* CHECK dout0_8 vdout0_8ck101 = 0.95 time = 510
* CHECK dout0_9 vdout0_9ck101 = 0.95 time = 510
* CHECK dout0_10 vdout0_10ck101 = 0.95 time = 510
* CHECK dout0_11 vdout0_11ck101 = 0.95 time = 510
* CHECK dout0_12 vdout0_12ck101 = 0.95 time = 510
* CHECK dout0_13 vdout0_13ck101 = 0 time = 510
* CHECK dout0_14 vdout0_14ck101 = 0.95 time = 510
* CHECK dout0_15 vdout0_15ck101 = 0 time = 510
* CHECK dout0_16 vdout0_16ck101 = 0.95 time = 510
* CHECK dout0_17 vdout0_17ck101 = 0 time = 510
* CHECK dout0_18 vdout0_18ck101 = 0.95 time = 510
* CHECK dout0_19 vdout0_19ck101 = 0 time = 510
* CHECK dout0_20 vdout0_20ck101 = 0.95 time = 510
* CHECK dout0_21 vdout0_21ck101 = 0.95 time = 510
* CHECK dout0_22 vdout0_22ck101 = 0 time = 510
* CHECK dout0_23 vdout0_23ck101 = 0.95 time = 510
* CHECK dout0_24 vdout0_24ck101 = 0 time = 510
* CHECK dout0_25 vdout0_25ck101 = 0 time = 510
* CHECK dout0_26 vdout0_26ck101 = 0 time = 510
* CHECK dout0_27 vdout0_27ck101 = 0.95 time = 510
* CHECK dout0_28 vdout0_28ck101 = 0 time = 510
* CHECK dout0_29 vdout0_29ck101 = 0.95 time = 510
* CHECK dout0_30 vdout0_30ck101 = 0.95 time = 510
* CHECK dout0_31 vdout0_31ck101 = 0 time = 510
* CHECK dout0_0 vdout0_0ck103 = 0 time = 520
* CHECK dout0_1 vdout0_1ck103 = 0 time = 520
* CHECK dout0_2 vdout0_2ck103 = 0 time = 520
* CHECK dout0_3 vdout0_3ck103 = 0 time = 520
* CHECK dout0_4 vdout0_4ck103 = 0.95 time = 520
* CHECK dout0_5 vdout0_5ck103 = 0 time = 520
* CHECK dout0_6 vdout0_6ck103 = 0.95 time = 520
* CHECK dout0_7 vdout0_7ck103 = 0 time = 520
* CHECK dout0_8 vdout0_8ck103 = 0.95 time = 520
* CHECK dout0_9 vdout0_9ck103 = 0.95 time = 520
* CHECK dout0_10 vdout0_10ck103 = 0 time = 520
* CHECK dout0_11 vdout0_11ck103 = 0 time = 520
* CHECK dout0_12 vdout0_12ck103 = 0.95 time = 520
* CHECK dout0_13 vdout0_13ck103 = 0.95 time = 520
* CHECK dout0_14 vdout0_14ck103 = 0.95 time = 520
* CHECK dout0_15 vdout0_15ck103 = 0 time = 520
* CHECK dout0_16 vdout0_16ck103 = 0 time = 520
* CHECK dout0_17 vdout0_17ck103 = 0.95 time = 520
* CHECK dout0_18 vdout0_18ck103 = 0 time = 520
* CHECK dout0_19 vdout0_19ck103 = 0 time = 520
* CHECK dout0_20 vdout0_20ck103 = 0.95 time = 520
* CHECK dout0_21 vdout0_21ck103 = 0 time = 520
* CHECK dout0_22 vdout0_22ck103 = 0.95 time = 520
* CHECK dout0_23 vdout0_23ck103 = 0.95 time = 520
* CHECK dout0_24 vdout0_24ck103 = 0 time = 520
* CHECK dout0_25 vdout0_25ck103 = 0 time = 520
* CHECK dout0_26 vdout0_26ck103 = 0 time = 520
* CHECK dout0_27 vdout0_27ck103 = 0.95 time = 520
* CHECK dout0_28 vdout0_28ck103 = 0.95 time = 520
* CHECK dout0_29 vdout0_29ck103 = 0.95 time = 520
* CHECK dout0_30 vdout0_30ck103 = 0 time = 520
* CHECK dout0_31 vdout0_31ck103 = 0 time = 520
* CHECK dout0_0 vdout0_0ck105 = 0 time = 530
* CHECK dout0_1 vdout0_1ck105 = 0 time = 530
* CHECK dout0_2 vdout0_2ck105 = 0.95 time = 530
* CHECK dout0_3 vdout0_3ck105 = 0 time = 530
* CHECK dout0_4 vdout0_4ck105 = 0 time = 530
* CHECK dout0_5 vdout0_5ck105 = 0 time = 530
* CHECK dout0_6 vdout0_6ck105 = 0.95 time = 530
* CHECK dout0_7 vdout0_7ck105 = 0.95 time = 530
* CHECK dout0_8 vdout0_8ck105 = 0.95 time = 530
* CHECK dout0_9 vdout0_9ck105 = 0.95 time = 530
* CHECK dout0_10 vdout0_10ck105 = 0 time = 530
* CHECK dout0_11 vdout0_11ck105 = 0.95 time = 530
* CHECK dout0_12 vdout0_12ck105 = 0.95 time = 530
* CHECK dout0_13 vdout0_13ck105 = 0 time = 530
* CHECK dout0_14 vdout0_14ck105 = 0 time = 530
* CHECK dout0_15 vdout0_15ck105 = 0.95 time = 530
* CHECK dout0_16 vdout0_16ck105 = 0.95 time = 530
* CHECK dout0_17 vdout0_17ck105 = 0.95 time = 530
* CHECK dout0_18 vdout0_18ck105 = 0 time = 530
* CHECK dout0_19 vdout0_19ck105 = 0 time = 530
* CHECK dout0_20 vdout0_20ck105 = 0.95 time = 530
* CHECK dout0_21 vdout0_21ck105 = 0.95 time = 530
* CHECK dout0_22 vdout0_22ck105 = 0.95 time = 530
* CHECK dout0_23 vdout0_23ck105 = 0 time = 530
* CHECK dout0_24 vdout0_24ck105 = 0 time = 530
* CHECK dout0_25 vdout0_25ck105 = 0.95 time = 530
* CHECK dout0_26 vdout0_26ck105 = 0.95 time = 530
* CHECK dout0_27 vdout0_27ck105 = 0.95 time = 530
* CHECK dout0_28 vdout0_28ck105 = 0 time = 530
* CHECK dout0_29 vdout0_29ck105 = 0.95 time = 530
* CHECK dout0_30 vdout0_30ck105 = 0.95 time = 530
* CHECK dout0_31 vdout0_31ck105 = 0.95 time = 530
* CHECK dout0_0 vdout0_0ck109 = 0 time = 550
* CHECK dout0_1 vdout0_1ck109 = 0 time = 550
* CHECK dout0_2 vdout0_2ck109 = 0 time = 550
* CHECK dout0_3 vdout0_3ck109 = 0 time = 550
* CHECK dout0_4 vdout0_4ck109 = 0.95 time = 550
* CHECK dout0_5 vdout0_5ck109 = 0 time = 550
* CHECK dout0_6 vdout0_6ck109 = 0.95 time = 550
* CHECK dout0_7 vdout0_7ck109 = 0 time = 550
* CHECK dout0_8 vdout0_8ck109 = 0.95 time = 550
* CHECK dout0_9 vdout0_9ck109 = 0.95 time = 550
* CHECK dout0_10 vdout0_10ck109 = 0 time = 550
* CHECK dout0_11 vdout0_11ck109 = 0 time = 550
* CHECK dout0_12 vdout0_12ck109 = 0.95 time = 550
* CHECK dout0_13 vdout0_13ck109 = 0.95 time = 550
* CHECK dout0_14 vdout0_14ck109 = 0.95 time = 550
* CHECK dout0_15 vdout0_15ck109 = 0 time = 550
* CHECK dout0_16 vdout0_16ck109 = 0 time = 550
* CHECK dout0_17 vdout0_17ck109 = 0.95 time = 550
* CHECK dout0_18 vdout0_18ck109 = 0 time = 550
* CHECK dout0_19 vdout0_19ck109 = 0 time = 550
* CHECK dout0_20 vdout0_20ck109 = 0.95 time = 550
* CHECK dout0_21 vdout0_21ck109 = 0 time = 550
* CHECK dout0_22 vdout0_22ck109 = 0.95 time = 550
* CHECK dout0_23 vdout0_23ck109 = 0.95 time = 550
* CHECK dout0_24 vdout0_24ck109 = 0 time = 550
* CHECK dout0_25 vdout0_25ck109 = 0 time = 550
* CHECK dout0_26 vdout0_26ck109 = 0 time = 550
* CHECK dout0_27 vdout0_27ck109 = 0.95 time = 550
* CHECK dout0_28 vdout0_28ck109 = 0.95 time = 550
* CHECK dout0_29 vdout0_29ck109 = 0.95 time = 550
* CHECK dout0_30 vdout0_30ck109 = 0 time = 550
* CHECK dout0_31 vdout0_31ck109 = 0 time = 550
* CHECK dout0_0 vdout0_0ck113 = 0 time = 570
* CHECK dout0_1 vdout0_1ck113 = 0 time = 570
* CHECK dout0_2 vdout0_2ck113 = 0.95 time = 570
* CHECK dout0_3 vdout0_3ck113 = 0 time = 570
* CHECK dout0_4 vdout0_4ck113 = 0 time = 570
* CHECK dout0_5 vdout0_5ck113 = 0 time = 570
* CHECK dout0_6 vdout0_6ck113 = 0.95 time = 570
* CHECK dout0_7 vdout0_7ck113 = 0.95 time = 570
* CHECK dout0_8 vdout0_8ck113 = 0.95 time = 570
* CHECK dout0_9 vdout0_9ck113 = 0.95 time = 570
* CHECK dout0_10 vdout0_10ck113 = 0 time = 570
* CHECK dout0_11 vdout0_11ck113 = 0.95 time = 570
* CHECK dout0_12 vdout0_12ck113 = 0.95 time = 570
* CHECK dout0_13 vdout0_13ck113 = 0 time = 570
* CHECK dout0_14 vdout0_14ck113 = 0 time = 570
* CHECK dout0_15 vdout0_15ck113 = 0.95 time = 570
* CHECK dout0_16 vdout0_16ck113 = 0.95 time = 570
* CHECK dout0_17 vdout0_17ck113 = 0.95 time = 570
* CHECK dout0_18 vdout0_18ck113 = 0 time = 570
* CHECK dout0_19 vdout0_19ck113 = 0 time = 570
* CHECK dout0_20 vdout0_20ck113 = 0.95 time = 570
* CHECK dout0_21 vdout0_21ck113 = 0.95 time = 570
* CHECK dout0_22 vdout0_22ck113 = 0.95 time = 570
* CHECK dout0_23 vdout0_23ck113 = 0 time = 570
* CHECK dout0_24 vdout0_24ck113 = 0 time = 570
* CHECK dout0_25 vdout0_25ck113 = 0.95 time = 570
* CHECK dout0_26 vdout0_26ck113 = 0.95 time = 570
* CHECK dout0_27 vdout0_27ck113 = 0.95 time = 570
* CHECK dout0_28 vdout0_28ck113 = 0 time = 570
* CHECK dout0_29 vdout0_29ck113 = 0.95 time = 570
* CHECK dout0_30 vdout0_30ck113 = 0.95 time = 570
* CHECK dout0_31 vdout0_31ck113 = 0.95 time = 570
* CHECK dout0_0 vdout0_0ck116 = 0 time = 585
* CHECK dout0_1 vdout0_1ck116 = 0 time = 585
* CHECK dout0_2 vdout0_2ck116 = 0 time = 585
* CHECK dout0_3 vdout0_3ck116 = 0 time = 585
* CHECK dout0_4 vdout0_4ck116 = 0.95 time = 585
* CHECK dout0_5 vdout0_5ck116 = 0 time = 585
* CHECK dout0_6 vdout0_6ck116 = 0.95 time = 585
* CHECK dout0_7 vdout0_7ck116 = 0 time = 585
* CHECK dout0_8 vdout0_8ck116 = 0.95 time = 585
* CHECK dout0_9 vdout0_9ck116 = 0.95 time = 585
* CHECK dout0_10 vdout0_10ck116 = 0 time = 585
* CHECK dout0_11 vdout0_11ck116 = 0 time = 585
* CHECK dout0_12 vdout0_12ck116 = 0.95 time = 585
* CHECK dout0_13 vdout0_13ck116 = 0.95 time = 585
* CHECK dout0_14 vdout0_14ck116 = 0.95 time = 585
* CHECK dout0_15 vdout0_15ck116 = 0 time = 585
* CHECK dout0_16 vdout0_16ck116 = 0 time = 585
* CHECK dout0_17 vdout0_17ck116 = 0.95 time = 585
* CHECK dout0_18 vdout0_18ck116 = 0 time = 585
* CHECK dout0_19 vdout0_19ck116 = 0 time = 585
* CHECK dout0_20 vdout0_20ck116 = 0.95 time = 585
* CHECK dout0_21 vdout0_21ck116 = 0 time = 585
* CHECK dout0_22 vdout0_22ck116 = 0.95 time = 585
* CHECK dout0_23 vdout0_23ck116 = 0.95 time = 585
* CHECK dout0_24 vdout0_24ck116 = 0 time = 585
* CHECK dout0_25 vdout0_25ck116 = 0 time = 585
* CHECK dout0_26 vdout0_26ck116 = 0 time = 585
* CHECK dout0_27 vdout0_27ck116 = 0.95 time = 585
* CHECK dout0_28 vdout0_28ck116 = 0.95 time = 585
* CHECK dout0_29 vdout0_29ck116 = 0.95 time = 585
* CHECK dout0_30 vdout0_30ck116 = 0 time = 585
* CHECK dout0_31 vdout0_31ck116 = 0 time = 585
* CHECK dout0_0 vdout0_0ck118 = 0 time = 595
* CHECK dout0_1 vdout0_1ck118 = 0 time = 595
* CHECK dout0_2 vdout0_2ck118 = 0.95 time = 595
* CHECK dout0_3 vdout0_3ck118 = 0 time = 595
* CHECK dout0_4 vdout0_4ck118 = 0.95 time = 595
* CHECK dout0_5 vdout0_5ck118 = 0 time = 595
* CHECK dout0_6 vdout0_6ck118 = 0.95 time = 595
* CHECK dout0_7 vdout0_7ck118 = 0 time = 595
* CHECK dout0_8 vdout0_8ck118 = 0 time = 595
* CHECK dout0_9 vdout0_9ck118 = 0.95 time = 595
* CHECK dout0_10 vdout0_10ck118 = 0.95 time = 595
* CHECK dout0_11 vdout0_11ck118 = 0 time = 595
* CHECK dout0_12 vdout0_12ck118 = 0 time = 595
* CHECK dout0_13 vdout0_13ck118 = 0.95 time = 595
* CHECK dout0_14 vdout0_14ck118 = 0 time = 595
* CHECK dout0_15 vdout0_15ck118 = 0 time = 595
* CHECK dout0_16 vdout0_16ck118 = 0 time = 595
* CHECK dout0_17 vdout0_17ck118 = 0.95 time = 595
* CHECK dout0_18 vdout0_18ck118 = 0.95 time = 595
* CHECK dout0_19 vdout0_19ck118 = 0.95 time = 595
* CHECK dout0_20 vdout0_20ck118 = 0.95 time = 595
* CHECK dout0_21 vdout0_21ck118 = 0.95 time = 595
* CHECK dout0_22 vdout0_22ck118 = 0.95 time = 595
* CHECK dout0_23 vdout0_23ck118 = 0 time = 595
* CHECK dout0_24 vdout0_24ck118 = 0.95 time = 595
* CHECK dout0_25 vdout0_25ck118 = 0 time = 595
* CHECK dout0_26 vdout0_26ck118 = 0 time = 595
* CHECK dout0_27 vdout0_27ck118 = 0.95 time = 595
* CHECK dout0_28 vdout0_28ck118 = 0 time = 595
* CHECK dout0_29 vdout0_29ck118 = 0 time = 595
* CHECK dout0_30 vdout0_30ck118 = 0.95 time = 595
* CHECK dout0_31 vdout0_31ck118 = 0.95 time = 595
* CHECK dout0_0 vdout0_0ck121 = 0 time = 610
* CHECK dout0_1 vdout0_1ck121 = 0 time = 610
* CHECK dout0_2 vdout0_2ck121 = 0 time = 610
* CHECK dout0_3 vdout0_3ck121 = 0 time = 610
* CHECK dout0_4 vdout0_4ck121 = 0.95 time = 610
* CHECK dout0_5 vdout0_5ck121 = 0 time = 610
* CHECK dout0_6 vdout0_6ck121 = 0.95 time = 610
* CHECK dout0_7 vdout0_7ck121 = 0 time = 610
* CHECK dout0_8 vdout0_8ck121 = 0.95 time = 610
* CHECK dout0_9 vdout0_9ck121 = 0.95 time = 610
* CHECK dout0_10 vdout0_10ck121 = 0 time = 610
* CHECK dout0_11 vdout0_11ck121 = 0 time = 610
* CHECK dout0_12 vdout0_12ck121 = 0.95 time = 610
* CHECK dout0_13 vdout0_13ck121 = 0.95 time = 610
* CHECK dout0_14 vdout0_14ck121 = 0.95 time = 610
* CHECK dout0_15 vdout0_15ck121 = 0 time = 610
* CHECK dout0_16 vdout0_16ck121 = 0 time = 610
* CHECK dout0_17 vdout0_17ck121 = 0.95 time = 610
* CHECK dout0_18 vdout0_18ck121 = 0 time = 610
* CHECK dout0_19 vdout0_19ck121 = 0 time = 610
* CHECK dout0_20 vdout0_20ck121 = 0.95 time = 610
* CHECK dout0_21 vdout0_21ck121 = 0 time = 610
* CHECK dout0_22 vdout0_22ck121 = 0.95 time = 610
* CHECK dout0_23 vdout0_23ck121 = 0.95 time = 610
* CHECK dout0_24 vdout0_24ck121 = 0 time = 610
* CHECK dout0_25 vdout0_25ck121 = 0 time = 610
* CHECK dout0_26 vdout0_26ck121 = 0 time = 610
* CHECK dout0_27 vdout0_27ck121 = 0.95 time = 610
* CHECK dout0_28 vdout0_28ck121 = 0.95 time = 610
* CHECK dout0_29 vdout0_29ck121 = 0.95 time = 610
* CHECK dout0_30 vdout0_30ck121 = 0 time = 610
* CHECK dout0_31 vdout0_31ck121 = 0 time = 610
* CHECK dout0_0 vdout0_0ck122 = 0.95 time = 615
* CHECK dout0_1 vdout0_1ck122 = 0 time = 615
* CHECK dout0_2 vdout0_2ck122 = 0.95 time = 615
* CHECK dout0_3 vdout0_3ck122 = 0.95 time = 615
* CHECK dout0_4 vdout0_4ck122 = 0.95 time = 615
* CHECK dout0_5 vdout0_5ck122 = 0.95 time = 615
* CHECK dout0_6 vdout0_6ck122 = 0.95 time = 615
* CHECK dout0_7 vdout0_7ck122 = 0.95 time = 615
* CHECK dout0_8 vdout0_8ck122 = 0 time = 615
* CHECK dout0_9 vdout0_9ck122 = 0.95 time = 615
* CHECK dout0_10 vdout0_10ck122 = 0 time = 615
* CHECK dout0_11 vdout0_11ck122 = 0.95 time = 615
* CHECK dout0_12 vdout0_12ck122 = 0.95 time = 615
* CHECK dout0_13 vdout0_13ck122 = 0.95 time = 615
* CHECK dout0_14 vdout0_14ck122 = 0.95 time = 615
* CHECK dout0_15 vdout0_15ck122 = 0.95 time = 615
* CHECK dout0_16 vdout0_16ck122 = 0.95 time = 615
* CHECK dout0_17 vdout0_17ck122 = 0.95 time = 615
* CHECK dout0_18 vdout0_18ck122 = 0 time = 615
* CHECK dout0_19 vdout0_19ck122 = 0 time = 615
* CHECK dout0_20 vdout0_20ck122 = 0 time = 615
* CHECK dout0_21 vdout0_21ck122 = 0.95 time = 615
* CHECK dout0_22 vdout0_22ck122 = 0.95 time = 615
* CHECK dout0_23 vdout0_23ck122 = 0.95 time = 615
* CHECK dout0_24 vdout0_24ck122 = 0.95 time = 615
* CHECK dout0_25 vdout0_25ck122 = 0.95 time = 615
* CHECK dout0_26 vdout0_26ck122 = 0 time = 615
* CHECK dout0_27 vdout0_27ck122 = 0 time = 615
* CHECK dout0_28 vdout0_28ck122 = 0.95 time = 615
* CHECK dout0_29 vdout0_29ck122 = 0.95 time = 615
* CHECK dout0_30 vdout0_30ck122 = 0.95 time = 615
* CHECK dout0_31 vdout0_31ck122 = 0 time = 615
* CHECK dout0_0 vdout0_0ck123 = 0 time = 620
* CHECK dout0_1 vdout0_1ck123 = 0 time = 620
* CHECK dout0_2 vdout0_2ck123 = 0.95 time = 620
* CHECK dout0_3 vdout0_3ck123 = 0 time = 620
* CHECK dout0_4 vdout0_4ck123 = 0.95 time = 620
* CHECK dout0_5 vdout0_5ck123 = 0 time = 620
* CHECK dout0_6 vdout0_6ck123 = 0.95 time = 620
* CHECK dout0_7 vdout0_7ck123 = 0 time = 620
* CHECK dout0_8 vdout0_8ck123 = 0 time = 620
* CHECK dout0_9 vdout0_9ck123 = 0.95 time = 620
* CHECK dout0_10 vdout0_10ck123 = 0.95 time = 620
* CHECK dout0_11 vdout0_11ck123 = 0 time = 620
* CHECK dout0_12 vdout0_12ck123 = 0 time = 620
* CHECK dout0_13 vdout0_13ck123 = 0.95 time = 620
* CHECK dout0_14 vdout0_14ck123 = 0 time = 620
* CHECK dout0_15 vdout0_15ck123 = 0 time = 620
* CHECK dout0_16 vdout0_16ck123 = 0 time = 620
* CHECK dout0_17 vdout0_17ck123 = 0.95 time = 620
* CHECK dout0_18 vdout0_18ck123 = 0.95 time = 620
* CHECK dout0_19 vdout0_19ck123 = 0.95 time = 620
* CHECK dout0_20 vdout0_20ck123 = 0.95 time = 620
* CHECK dout0_21 vdout0_21ck123 = 0.95 time = 620
* CHECK dout0_22 vdout0_22ck123 = 0.95 time = 620
* CHECK dout0_23 vdout0_23ck123 = 0 time = 620
* CHECK dout0_24 vdout0_24ck123 = 0.95 time = 620
* CHECK dout0_25 vdout0_25ck123 = 0 time = 620
* CHECK dout0_26 vdout0_26ck123 = 0 time = 620
* CHECK dout0_27 vdout0_27ck123 = 0.95 time = 620
* CHECK dout0_28 vdout0_28ck123 = 0 time = 620
* CHECK dout0_29 vdout0_29ck123 = 0 time = 620
* CHECK dout0_30 vdout0_30ck123 = 0.95 time = 620
* CHECK dout0_31 vdout0_31ck123 = 0.95 time = 620
* CHECK dout0_0 vdout0_0ck124 = 0 time = 625
* CHECK dout0_1 vdout0_1ck124 = 0 time = 625
* CHECK dout0_2 vdout0_2ck124 = 0.95 time = 625
* CHECK dout0_3 vdout0_3ck124 = 0 time = 625
* CHECK dout0_4 vdout0_4ck124 = 0.95 time = 625
* CHECK dout0_5 vdout0_5ck124 = 0 time = 625
* CHECK dout0_6 vdout0_6ck124 = 0.95 time = 625
* CHECK dout0_7 vdout0_7ck124 = 0 time = 625
* CHECK dout0_8 vdout0_8ck124 = 0 time = 625
* CHECK dout0_9 vdout0_9ck124 = 0.95 time = 625
* CHECK dout0_10 vdout0_10ck124 = 0.95 time = 625
* CHECK dout0_11 vdout0_11ck124 = 0 time = 625
* CHECK dout0_12 vdout0_12ck124 = 0 time = 625
* CHECK dout0_13 vdout0_13ck124 = 0.95 time = 625
* CHECK dout0_14 vdout0_14ck124 = 0 time = 625
* CHECK dout0_15 vdout0_15ck124 = 0 time = 625
* CHECK dout0_16 vdout0_16ck124 = 0 time = 625
* CHECK dout0_17 vdout0_17ck124 = 0.95 time = 625
* CHECK dout0_18 vdout0_18ck124 = 0.95 time = 625
* CHECK dout0_19 vdout0_19ck124 = 0.95 time = 625
* CHECK dout0_20 vdout0_20ck124 = 0.95 time = 625
* CHECK dout0_21 vdout0_21ck124 = 0.95 time = 625
* CHECK dout0_22 vdout0_22ck124 = 0.95 time = 625
* CHECK dout0_23 vdout0_23ck124 = 0 time = 625
* CHECK dout0_24 vdout0_24ck124 = 0.95 time = 625
* CHECK dout0_25 vdout0_25ck124 = 0 time = 625
* CHECK dout0_26 vdout0_26ck124 = 0 time = 625
* CHECK dout0_27 vdout0_27ck124 = 0.95 time = 625
* CHECK dout0_28 vdout0_28ck124 = 0 time = 625
* CHECK dout0_29 vdout0_29ck124 = 0 time = 625
* CHECK dout0_30 vdout0_30ck124 = 0.95 time = 625
* CHECK dout0_31 vdout0_31ck124 = 0.95 time = 625
* CHECK dout0_0 vdout0_0ck125 = 0 time = 630
* CHECK dout0_1 vdout0_1ck125 = 0 time = 630
* CHECK dout0_2 vdout0_2ck125 = 0 time = 630
* CHECK dout0_3 vdout0_3ck125 = 0 time = 630
* CHECK dout0_4 vdout0_4ck125 = 0.95 time = 630
* CHECK dout0_5 vdout0_5ck125 = 0 time = 630
* CHECK dout0_6 vdout0_6ck125 = 0.95 time = 630
* CHECK dout0_7 vdout0_7ck125 = 0 time = 630
* CHECK dout0_8 vdout0_8ck125 = 0.95 time = 630
* CHECK dout0_9 vdout0_9ck125 = 0.95 time = 630
* CHECK dout0_10 vdout0_10ck125 = 0 time = 630
* CHECK dout0_11 vdout0_11ck125 = 0 time = 630
* CHECK dout0_12 vdout0_12ck125 = 0.95 time = 630
* CHECK dout0_13 vdout0_13ck125 = 0.95 time = 630
* CHECK dout0_14 vdout0_14ck125 = 0.95 time = 630
* CHECK dout0_15 vdout0_15ck125 = 0 time = 630
* CHECK dout0_16 vdout0_16ck125 = 0 time = 630
* CHECK dout0_17 vdout0_17ck125 = 0.95 time = 630
* CHECK dout0_18 vdout0_18ck125 = 0 time = 630
* CHECK dout0_19 vdout0_19ck125 = 0 time = 630
* CHECK dout0_20 vdout0_20ck125 = 0.95 time = 630
* CHECK dout0_21 vdout0_21ck125 = 0 time = 630
* CHECK dout0_22 vdout0_22ck125 = 0.95 time = 630
* CHECK dout0_23 vdout0_23ck125 = 0.95 time = 630
* CHECK dout0_24 vdout0_24ck125 = 0 time = 630
* CHECK dout0_25 vdout0_25ck125 = 0 time = 630
* CHECK dout0_26 vdout0_26ck125 = 0 time = 630
* CHECK dout0_27 vdout0_27ck125 = 0.95 time = 630
* CHECK dout0_28 vdout0_28ck125 = 0.95 time = 630
* CHECK dout0_29 vdout0_29ck125 = 0.95 time = 630
* CHECK dout0_30 vdout0_30ck125 = 0 time = 630
* CHECK dout0_31 vdout0_31ck125 = 0 time = 630
* CHECK dout0_0 vdout0_0ck126 = 0.95 time = 635
* CHECK dout0_1 vdout0_1ck126 = 0 time = 635
* CHECK dout0_2 vdout0_2ck126 = 0.95 time = 635
* CHECK dout0_3 vdout0_3ck126 = 0.95 time = 635
* CHECK dout0_4 vdout0_4ck126 = 0.95 time = 635
* CHECK dout0_5 vdout0_5ck126 = 0.95 time = 635
* CHECK dout0_6 vdout0_6ck126 = 0.95 time = 635
* CHECK dout0_7 vdout0_7ck126 = 0.95 time = 635
* CHECK dout0_8 vdout0_8ck126 = 0 time = 635
* CHECK dout0_9 vdout0_9ck126 = 0.95 time = 635
* CHECK dout0_10 vdout0_10ck126 = 0 time = 635
* CHECK dout0_11 vdout0_11ck126 = 0.95 time = 635
* CHECK dout0_12 vdout0_12ck126 = 0.95 time = 635
* CHECK dout0_13 vdout0_13ck126 = 0.95 time = 635
* CHECK dout0_14 vdout0_14ck126 = 0.95 time = 635
* CHECK dout0_15 vdout0_15ck126 = 0.95 time = 635
* CHECK dout0_16 vdout0_16ck126 = 0.95 time = 635
* CHECK dout0_17 vdout0_17ck126 = 0.95 time = 635
* CHECK dout0_18 vdout0_18ck126 = 0 time = 635
* CHECK dout0_19 vdout0_19ck126 = 0 time = 635
* CHECK dout0_20 vdout0_20ck126 = 0 time = 635
* CHECK dout0_21 vdout0_21ck126 = 0.95 time = 635
* CHECK dout0_22 vdout0_22ck126 = 0.95 time = 635
* CHECK dout0_23 vdout0_23ck126 = 0.95 time = 635
* CHECK dout0_24 vdout0_24ck126 = 0.95 time = 635
* CHECK dout0_25 vdout0_25ck126 = 0.95 time = 635
* CHECK dout0_26 vdout0_26ck126 = 0 time = 635
* CHECK dout0_27 vdout0_27ck126 = 0 time = 635
* CHECK dout0_28 vdout0_28ck126 = 0.95 time = 635
* CHECK dout0_29 vdout0_29ck126 = 0.95 time = 635
* CHECK dout0_30 vdout0_30ck126 = 0.95 time = 635
* CHECK dout0_31 vdout0_31ck126 = 0 time = 635
* CHECK dout0_0 vdout0_0ck130 = 0 time = 655
* CHECK dout0_1 vdout0_1ck130 = 0 time = 655
* CHECK dout0_2 vdout0_2ck130 = 0 time = 655
* CHECK dout0_3 vdout0_3ck130 = 0 time = 655
* CHECK dout0_4 vdout0_4ck130 = 0 time = 655
* CHECK dout0_5 vdout0_5ck130 = 0.95 time = 655
* CHECK dout0_6 vdout0_6ck130 = 0 time = 655
* CHECK dout0_7 vdout0_7ck130 = 0 time = 655
* CHECK dout0_8 vdout0_8ck130 = 0 time = 655
* CHECK dout0_9 vdout0_9ck130 = 0 time = 655
* CHECK dout0_10 vdout0_10ck130 = 0 time = 655
* CHECK dout0_11 vdout0_11ck130 = 0 time = 655
* CHECK dout0_12 vdout0_12ck130 = 0 time = 655
* CHECK dout0_13 vdout0_13ck130 = 0.95 time = 655
* CHECK dout0_14 vdout0_14ck130 = 0 time = 655
* CHECK dout0_15 vdout0_15ck130 = 0 time = 655
* CHECK dout0_16 vdout0_16ck130 = 0 time = 655
* CHECK dout0_17 vdout0_17ck130 = 0.95 time = 655
* CHECK dout0_18 vdout0_18ck130 = 0.95 time = 655
* CHECK dout0_19 vdout0_19ck130 = 0 time = 655
* CHECK dout0_20 vdout0_20ck130 = 0 time = 655
* CHECK dout0_21 vdout0_21ck130 = 0.95 time = 655
* CHECK dout0_22 vdout0_22ck130 = 0.95 time = 655
* CHECK dout0_23 vdout0_23ck130 = 0.95 time = 655
* CHECK dout0_24 vdout0_24ck130 = 0.95 time = 655
* CHECK dout0_25 vdout0_25ck130 = 0 time = 655
* CHECK dout0_26 vdout0_26ck130 = 0 time = 655
* CHECK dout0_27 vdout0_27ck130 = 0 time = 655
* CHECK dout0_28 vdout0_28ck130 = 0.95 time = 655
* CHECK dout0_29 vdout0_29ck130 = 0.95 time = 655
* CHECK dout0_30 vdout0_30ck130 = 0.95 time = 655
* CHECK dout0_31 vdout0_31ck130 = 0.95 time = 655
* CHECK dout0_0 vdout0_0ck132 = 0.95 time = 665
* CHECK dout0_1 vdout0_1ck132 = 0 time = 665
* CHECK dout0_2 vdout0_2ck132 = 0.95 time = 665
* CHECK dout0_3 vdout0_3ck132 = 0.95 time = 665
* CHECK dout0_4 vdout0_4ck132 = 0.95 time = 665
* CHECK dout0_5 vdout0_5ck132 = 0.95 time = 665
* CHECK dout0_6 vdout0_6ck132 = 0.95 time = 665
* CHECK dout0_7 vdout0_7ck132 = 0.95 time = 665
* CHECK dout0_8 vdout0_8ck132 = 0 time = 665
* CHECK dout0_9 vdout0_9ck132 = 0.95 time = 665
* CHECK dout0_10 vdout0_10ck132 = 0 time = 665
* CHECK dout0_11 vdout0_11ck132 = 0.95 time = 665
* CHECK dout0_12 vdout0_12ck132 = 0.95 time = 665
* CHECK dout0_13 vdout0_13ck132 = 0.95 time = 665
* CHECK dout0_14 vdout0_14ck132 = 0.95 time = 665
* CHECK dout0_15 vdout0_15ck132 = 0.95 time = 665
* CHECK dout0_16 vdout0_16ck132 = 0.95 time = 665
* CHECK dout0_17 vdout0_17ck132 = 0.95 time = 665
* CHECK dout0_18 vdout0_18ck132 = 0 time = 665
* CHECK dout0_19 vdout0_19ck132 = 0 time = 665
* CHECK dout0_20 vdout0_20ck132 = 0 time = 665
* CHECK dout0_21 vdout0_21ck132 = 0.95 time = 665
* CHECK dout0_22 vdout0_22ck132 = 0.95 time = 665
* CHECK dout0_23 vdout0_23ck132 = 0.95 time = 665
* CHECK dout0_24 vdout0_24ck132 = 0.95 time = 665
* CHECK dout0_25 vdout0_25ck132 = 0.95 time = 665
* CHECK dout0_26 vdout0_26ck132 = 0 time = 665
* CHECK dout0_27 vdout0_27ck132 = 0 time = 665
* CHECK dout0_28 vdout0_28ck132 = 0.95 time = 665
* CHECK dout0_29 vdout0_29ck132 = 0.95 time = 665
* CHECK dout0_30 vdout0_30ck132 = 0.95 time = 665
* CHECK dout0_31 vdout0_31ck132 = 0 time = 665
* CHECK dout0_0 vdout0_0ck136 = 0 time = 685
* CHECK dout0_1 vdout0_1ck136 = 0.95 time = 685
* CHECK dout0_2 vdout0_2ck136 = 0.95 time = 685
* CHECK dout0_3 vdout0_3ck136 = 0.95 time = 685
* CHECK dout0_4 vdout0_4ck136 = 0.95 time = 685
* CHECK dout0_5 vdout0_5ck136 = 0 time = 685
* CHECK dout0_6 vdout0_6ck136 = 0.95 time = 685
* CHECK dout0_7 vdout0_7ck136 = 0.95 time = 685
* CHECK dout0_8 vdout0_8ck136 = 0.95 time = 685
* CHECK dout0_9 vdout0_9ck136 = 0.95 time = 685
* CHECK dout0_10 vdout0_10ck136 = 0.95 time = 685
* CHECK dout0_11 vdout0_11ck136 = 0 time = 685
* CHECK dout0_12 vdout0_12ck136 = 0.95 time = 685
* CHECK dout0_13 vdout0_13ck136 = 0.95 time = 685
* CHECK dout0_14 vdout0_14ck136 = 0.95 time = 685
* CHECK dout0_15 vdout0_15ck136 = 0 time = 685
* CHECK dout0_16 vdout0_16ck136 = 0.95 time = 685
* CHECK dout0_17 vdout0_17ck136 = 0 time = 685
* CHECK dout0_18 vdout0_18ck136 = 0 time = 685
* CHECK dout0_19 vdout0_19ck136 = 0 time = 685
* CHECK dout0_20 vdout0_20ck136 = 0 time = 685
* CHECK dout0_21 vdout0_21ck136 = 0.95 time = 685
* CHECK dout0_22 vdout0_22ck136 = 0 time = 685
* CHECK dout0_23 vdout0_23ck136 = 0.95 time = 685
* CHECK dout0_24 vdout0_24ck136 = 0 time = 685
* CHECK dout0_25 vdout0_25ck136 = 0 time = 685
* CHECK dout0_26 vdout0_26ck136 = 0 time = 685
* CHECK dout0_27 vdout0_27ck136 = 0 time = 685
* CHECK dout0_28 vdout0_28ck136 = 0 time = 685
* CHECK dout0_29 vdout0_29ck136 = 0.95 time = 685
* CHECK dout0_30 vdout0_30ck136 = 0.95 time = 685
* CHECK dout0_31 vdout0_31ck136 = 0 time = 685
* CHECK dout0_0 vdout0_0ck139 = 0 time = 700
* CHECK dout0_1 vdout0_1ck139 = 0 time = 700
* CHECK dout0_2 vdout0_2ck139 = 0.95 time = 700
* CHECK dout0_3 vdout0_3ck139 = 0 time = 700
* CHECK dout0_4 vdout0_4ck139 = 0 time = 700
* CHECK dout0_5 vdout0_5ck139 = 0.95 time = 700
* CHECK dout0_6 vdout0_6ck139 = 0.95 time = 700
* CHECK dout0_7 vdout0_7ck139 = 0 time = 700
* CHECK dout0_8 vdout0_8ck139 = 0.95 time = 700
* CHECK dout0_9 vdout0_9ck139 = 0 time = 700
* CHECK dout0_10 vdout0_10ck139 = 0 time = 700
* CHECK dout0_11 vdout0_11ck139 = 0.95 time = 700
* CHECK dout0_12 vdout0_12ck139 = 0 time = 700
* CHECK dout0_13 vdout0_13ck139 = 0.95 time = 700
* CHECK dout0_14 vdout0_14ck139 = 0 time = 700
* CHECK dout0_15 vdout0_15ck139 = 0 time = 700
* CHECK dout0_16 vdout0_16ck139 = 0.95 time = 700
* CHECK dout0_17 vdout0_17ck139 = 0.95 time = 700
* CHECK dout0_18 vdout0_18ck139 = 0.95 time = 700
* CHECK dout0_19 vdout0_19ck139 = 0.95 time = 700
* CHECK dout0_20 vdout0_20ck139 = 0 time = 700
* CHECK dout0_21 vdout0_21ck139 = 0.95 time = 700
* CHECK dout0_22 vdout0_22ck139 = 0 time = 700
* CHECK dout0_23 vdout0_23ck139 = 0.95 time = 700
* CHECK dout0_24 vdout0_24ck139 = 0.95 time = 700
* CHECK dout0_25 vdout0_25ck139 = 0 time = 700
* CHECK dout0_26 vdout0_26ck139 = 0.95 time = 700
* CHECK dout0_27 vdout0_27ck139 = 0 time = 700
* CHECK dout0_28 vdout0_28ck139 = 0 time = 700
* CHECK dout0_29 vdout0_29ck139 = 0.95 time = 700
* CHECK dout0_30 vdout0_30ck139 = 0.95 time = 700
* CHECK dout0_31 vdout0_31ck139 = 0 time = 700
* CHECK dout0_0 vdout0_0ck142 = 0.95 time = 715
* CHECK dout0_1 vdout0_1ck142 = 0 time = 715
* CHECK dout0_2 vdout0_2ck142 = 0.95 time = 715
* CHECK dout0_3 vdout0_3ck142 = 0.95 time = 715
* CHECK dout0_4 vdout0_4ck142 = 0.95 time = 715
* CHECK dout0_5 vdout0_5ck142 = 0.95 time = 715
* CHECK dout0_6 vdout0_6ck142 = 0.95 time = 715
* CHECK dout0_7 vdout0_7ck142 = 0.95 time = 715
* CHECK dout0_8 vdout0_8ck142 = 0 time = 715
* CHECK dout0_9 vdout0_9ck142 = 0.95 time = 715
* CHECK dout0_10 vdout0_10ck142 = 0 time = 715
* CHECK dout0_11 vdout0_11ck142 = 0.95 time = 715
* CHECK dout0_12 vdout0_12ck142 = 0.95 time = 715
* CHECK dout0_13 vdout0_13ck142 = 0.95 time = 715
* CHECK dout0_14 vdout0_14ck142 = 0.95 time = 715
* CHECK dout0_15 vdout0_15ck142 = 0.95 time = 715
* CHECK dout0_16 vdout0_16ck142 = 0.95 time = 715
* CHECK dout0_17 vdout0_17ck142 = 0.95 time = 715
* CHECK dout0_18 vdout0_18ck142 = 0 time = 715
* CHECK dout0_19 vdout0_19ck142 = 0 time = 715
* CHECK dout0_20 vdout0_20ck142 = 0 time = 715
* CHECK dout0_21 vdout0_21ck142 = 0.95 time = 715
* CHECK dout0_22 vdout0_22ck142 = 0.95 time = 715
* CHECK dout0_23 vdout0_23ck142 = 0.95 time = 715
* CHECK dout0_24 vdout0_24ck142 = 0.95 time = 715
* CHECK dout0_25 vdout0_25ck142 = 0.95 time = 715
* CHECK dout0_26 vdout0_26ck142 = 0 time = 715
* CHECK dout0_27 vdout0_27ck142 = 0 time = 715
* CHECK dout0_28 vdout0_28ck142 = 0.95 time = 715
* CHECK dout0_29 vdout0_29ck142 = 0.95 time = 715
* CHECK dout0_30 vdout0_30ck142 = 0.95 time = 715
* CHECK dout0_31 vdout0_31ck142 = 0 time = 715
* CHECK dout0_0 vdout0_0ck143 = 0 time = 720
* CHECK dout0_1 vdout0_1ck143 = 0 time = 720
* CHECK dout0_2 vdout0_2ck143 = 0 time = 720
* CHECK dout0_3 vdout0_3ck143 = 0 time = 720
* CHECK dout0_4 vdout0_4ck143 = 0.95 time = 720
* CHECK dout0_5 vdout0_5ck143 = 0 time = 720
* CHECK dout0_6 vdout0_6ck143 = 0.95 time = 720
* CHECK dout0_7 vdout0_7ck143 = 0 time = 720
* CHECK dout0_8 vdout0_8ck143 = 0.95 time = 720
* CHECK dout0_9 vdout0_9ck143 = 0.95 time = 720
* CHECK dout0_10 vdout0_10ck143 = 0 time = 720
* CHECK dout0_11 vdout0_11ck143 = 0 time = 720
* CHECK dout0_12 vdout0_12ck143 = 0.95 time = 720
* CHECK dout0_13 vdout0_13ck143 = 0.95 time = 720
* CHECK dout0_14 vdout0_14ck143 = 0.95 time = 720
* CHECK dout0_15 vdout0_15ck143 = 0 time = 720
* CHECK dout0_16 vdout0_16ck143 = 0 time = 720
* CHECK dout0_17 vdout0_17ck143 = 0.95 time = 720
* CHECK dout0_18 vdout0_18ck143 = 0 time = 720
* CHECK dout0_19 vdout0_19ck143 = 0 time = 720
* CHECK dout0_20 vdout0_20ck143 = 0.95 time = 720
* CHECK dout0_21 vdout0_21ck143 = 0 time = 720
* CHECK dout0_22 vdout0_22ck143 = 0.95 time = 720
* CHECK dout0_23 vdout0_23ck143 = 0.95 time = 720
* CHECK dout0_24 vdout0_24ck143 = 0 time = 720
* CHECK dout0_25 vdout0_25ck143 = 0 time = 720
* CHECK dout0_26 vdout0_26ck143 = 0 time = 720
* CHECK dout0_27 vdout0_27ck143 = 0.95 time = 720
* CHECK dout0_28 vdout0_28ck143 = 0.95 time = 720
* CHECK dout0_29 vdout0_29ck143 = 0.95 time = 720
* CHECK dout0_30 vdout0_30ck143 = 0 time = 720
* CHECK dout0_31 vdout0_31ck143 = 0 time = 720
* CHECK dout0_0 vdout0_0ck145 = 0 time = 730
* CHECK dout0_1 vdout0_1ck145 = 0 time = 730
* CHECK dout0_2 vdout0_2ck145 = 0.95 time = 730
* CHECK dout0_3 vdout0_3ck145 = 0 time = 730
* CHECK dout0_4 vdout0_4ck145 = 0 time = 730
* CHECK dout0_5 vdout0_5ck145 = 0.95 time = 730
* CHECK dout0_6 vdout0_6ck145 = 0.95 time = 730
* CHECK dout0_7 vdout0_7ck145 = 0 time = 730
* CHECK dout0_8 vdout0_8ck145 = 0.95 time = 730
* CHECK dout0_9 vdout0_9ck145 = 0 time = 730
* CHECK dout0_10 vdout0_10ck145 = 0 time = 730
* CHECK dout0_11 vdout0_11ck145 = 0.95 time = 730
* CHECK dout0_12 vdout0_12ck145 = 0 time = 730
* CHECK dout0_13 vdout0_13ck145 = 0.95 time = 730
* CHECK dout0_14 vdout0_14ck145 = 0 time = 730
* CHECK dout0_15 vdout0_15ck145 = 0 time = 730
* CHECK dout0_16 vdout0_16ck145 = 0.95 time = 730
* CHECK dout0_17 vdout0_17ck145 = 0.95 time = 730
* CHECK dout0_18 vdout0_18ck145 = 0.95 time = 730
* CHECK dout0_19 vdout0_19ck145 = 0.95 time = 730
* CHECK dout0_20 vdout0_20ck145 = 0 time = 730
* CHECK dout0_21 vdout0_21ck145 = 0.95 time = 730
* CHECK dout0_22 vdout0_22ck145 = 0 time = 730
* CHECK dout0_23 vdout0_23ck145 = 0.95 time = 730
* CHECK dout0_24 vdout0_24ck145 = 0.95 time = 730
* CHECK dout0_25 vdout0_25ck145 = 0 time = 730
* CHECK dout0_26 vdout0_26ck145 = 0.95 time = 730
* CHECK dout0_27 vdout0_27ck145 = 0 time = 730
* CHECK dout0_28 vdout0_28ck145 = 0 time = 730
* CHECK dout0_29 vdout0_29ck145 = 0.95 time = 730
* CHECK dout0_30 vdout0_30ck145 = 0.95 time = 730
* CHECK dout0_31 vdout0_31ck145 = 0 time = 730
* CHECK dout0_0 vdout0_0ck148 = 0.95 time = 745
* CHECK dout0_1 vdout0_1ck148 = 0.95 time = 745
* CHECK dout0_2 vdout0_2ck148 = 0.95 time = 745
* CHECK dout0_3 vdout0_3ck148 = 0.95 time = 745
* CHECK dout0_4 vdout0_4ck148 = 0 time = 745
* CHECK dout0_5 vdout0_5ck148 = 0.95 time = 745
* CHECK dout0_6 vdout0_6ck148 = 0.95 time = 745
* CHECK dout0_7 vdout0_7ck148 = 0.95 time = 745
* CHECK dout0_8 vdout0_8ck148 = 0 time = 745
* CHECK dout0_9 vdout0_9ck148 = 0 time = 745
* CHECK dout0_10 vdout0_10ck148 = 0 time = 745
* CHECK dout0_11 vdout0_11ck148 = 0.95 time = 745
* CHECK dout0_12 vdout0_12ck148 = 0 time = 745
* CHECK dout0_13 vdout0_13ck148 = 0.95 time = 745
* CHECK dout0_14 vdout0_14ck148 = 0 time = 745
* CHECK dout0_15 vdout0_15ck148 = 0.95 time = 745
* CHECK dout0_16 vdout0_16ck148 = 0 time = 745
* CHECK dout0_17 vdout0_17ck148 = 0 time = 745
* CHECK dout0_18 vdout0_18ck148 = 0.95 time = 745
* CHECK dout0_19 vdout0_19ck148 = 0.95 time = 745
* CHECK dout0_20 vdout0_20ck148 = 0.95 time = 745
* CHECK dout0_21 vdout0_21ck148 = 0.95 time = 745
* CHECK dout0_22 vdout0_22ck148 = 0.95 time = 745
* CHECK dout0_23 vdout0_23ck148 = 0 time = 745
* CHECK dout0_24 vdout0_24ck148 = 0.95 time = 745
* CHECK dout0_25 vdout0_25ck148 = 0.95 time = 745
* CHECK dout0_26 vdout0_26ck148 = 0 time = 745
* CHECK dout0_27 vdout0_27ck148 = 0 time = 745
* CHECK dout0_28 vdout0_28ck148 = 0.95 time = 745
* CHECK dout0_29 vdout0_29ck148 = 0 time = 745
* CHECK dout0_30 vdout0_30ck148 = 0.95 time = 745
* CHECK dout0_31 vdout0_31ck148 = 0.95 time = 745
* CHECK dout0_0 vdout0_0ck150 = 0.95 time = 755
* CHECK dout0_1 vdout0_1ck150 = 0 time = 755
* CHECK dout0_2 vdout0_2ck150 = 0 time = 755
* CHECK dout0_3 vdout0_3ck150 = 0.95 time = 755
* CHECK dout0_4 vdout0_4ck150 = 0 time = 755
* CHECK dout0_5 vdout0_5ck150 = 0 time = 755
* CHECK dout0_6 vdout0_6ck150 = 0.95 time = 755
* CHECK dout0_7 vdout0_7ck150 = 0.95 time = 755
* CHECK dout0_8 vdout0_8ck150 = 0 time = 755
* CHECK dout0_9 vdout0_9ck150 = 0 time = 755
* CHECK dout0_10 vdout0_10ck150 = 0 time = 755
* CHECK dout0_11 vdout0_11ck150 = 0.95 time = 755
* CHECK dout0_12 vdout0_12ck150 = 0 time = 755
* CHECK dout0_13 vdout0_13ck150 = 0.95 time = 755
* CHECK dout0_14 vdout0_14ck150 = 0 time = 755
* CHECK dout0_15 vdout0_15ck150 = 0.95 time = 755
* CHECK dout0_16 vdout0_16ck150 = 0.95 time = 755
* CHECK dout0_17 vdout0_17ck150 = 0.95 time = 755
* CHECK dout0_18 vdout0_18ck150 = 0.95 time = 755
* CHECK dout0_19 vdout0_19ck150 = 0 time = 755
* CHECK dout0_20 vdout0_20ck150 = 0.95 time = 755
* CHECK dout0_21 vdout0_21ck150 = 0.95 time = 755
* CHECK dout0_22 vdout0_22ck150 = 0 time = 755
* CHECK dout0_23 vdout0_23ck150 = 0.95 time = 755
* CHECK dout0_24 vdout0_24ck150 = 0 time = 755
* CHECK dout0_25 vdout0_25ck150 = 0.95 time = 755
* CHECK dout0_26 vdout0_26ck150 = 0 time = 755
* CHECK dout0_27 vdout0_27ck150 = 0 time = 755
* CHECK dout0_28 vdout0_28ck150 = 0.95 time = 755
* CHECK dout0_29 vdout0_29ck150 = 0.95 time = 755
* CHECK dout0_30 vdout0_30ck150 = 0 time = 755
* CHECK dout0_31 vdout0_31ck150 = 0.95 time = 755
* CHECK dout0_0 vdout0_0ck151 = 0 time = 760
* CHECK dout0_1 vdout0_1ck151 = 0 time = 760
* CHECK dout0_2 vdout0_2ck151 = 0 time = 760
* CHECK dout0_3 vdout0_3ck151 = 0 time = 760
* CHECK dout0_4 vdout0_4ck151 = 0.95 time = 760
* CHECK dout0_5 vdout0_5ck151 = 0 time = 760
* CHECK dout0_6 vdout0_6ck151 = 0.95 time = 760
* CHECK dout0_7 vdout0_7ck151 = 0 time = 760
* CHECK dout0_8 vdout0_8ck151 = 0.95 time = 760
* CHECK dout0_9 vdout0_9ck151 = 0.95 time = 760
* CHECK dout0_10 vdout0_10ck151 = 0 time = 760
* CHECK dout0_11 vdout0_11ck151 = 0 time = 760
* CHECK dout0_12 vdout0_12ck151 = 0.95 time = 760
* CHECK dout0_13 vdout0_13ck151 = 0.95 time = 760
* CHECK dout0_14 vdout0_14ck151 = 0.95 time = 760
* CHECK dout0_15 vdout0_15ck151 = 0 time = 760
* CHECK dout0_16 vdout0_16ck151 = 0 time = 760
* CHECK dout0_17 vdout0_17ck151 = 0.95 time = 760
* CHECK dout0_18 vdout0_18ck151 = 0 time = 760
* CHECK dout0_19 vdout0_19ck151 = 0 time = 760
* CHECK dout0_20 vdout0_20ck151 = 0.95 time = 760
* CHECK dout0_21 vdout0_21ck151 = 0 time = 760
* CHECK dout0_22 vdout0_22ck151 = 0.95 time = 760
* CHECK dout0_23 vdout0_23ck151 = 0.95 time = 760
* CHECK dout0_24 vdout0_24ck151 = 0 time = 760
* CHECK dout0_25 vdout0_25ck151 = 0 time = 760
* CHECK dout0_26 vdout0_26ck151 = 0 time = 760
* CHECK dout0_27 vdout0_27ck151 = 0.95 time = 760
* CHECK dout0_28 vdout0_28ck151 = 0.95 time = 760
* CHECK dout0_29 vdout0_29ck151 = 0.95 time = 760
* CHECK dout0_30 vdout0_30ck151 = 0 time = 760
* CHECK dout0_31 vdout0_31ck151 = 0 time = 760
* CHECK dout0_0 vdout0_0ck152 = 0 time = 765
* CHECK dout0_1 vdout0_1ck152 = 0 time = 765
* CHECK dout0_2 vdout0_2ck152 = 0 time = 765
* CHECK dout0_3 vdout0_3ck152 = 0 time = 765
* CHECK dout0_4 vdout0_4ck152 = 0.95 time = 765
* CHECK dout0_5 vdout0_5ck152 = 0 time = 765
* CHECK dout0_6 vdout0_6ck152 = 0.95 time = 765
* CHECK dout0_7 vdout0_7ck152 = 0 time = 765
* CHECK dout0_8 vdout0_8ck152 = 0.95 time = 765
* CHECK dout0_9 vdout0_9ck152 = 0.95 time = 765
* CHECK dout0_10 vdout0_10ck152 = 0 time = 765
* CHECK dout0_11 vdout0_11ck152 = 0 time = 765
* CHECK dout0_12 vdout0_12ck152 = 0.95 time = 765
* CHECK dout0_13 vdout0_13ck152 = 0.95 time = 765
* CHECK dout0_14 vdout0_14ck152 = 0.95 time = 765
* CHECK dout0_15 vdout0_15ck152 = 0 time = 765
* CHECK dout0_16 vdout0_16ck152 = 0 time = 765
* CHECK dout0_17 vdout0_17ck152 = 0.95 time = 765
* CHECK dout0_18 vdout0_18ck152 = 0 time = 765
* CHECK dout0_19 vdout0_19ck152 = 0 time = 765
* CHECK dout0_20 vdout0_20ck152 = 0.95 time = 765
* CHECK dout0_21 vdout0_21ck152 = 0 time = 765
* CHECK dout0_22 vdout0_22ck152 = 0.95 time = 765
* CHECK dout0_23 vdout0_23ck152 = 0.95 time = 765
* CHECK dout0_24 vdout0_24ck152 = 0 time = 765
* CHECK dout0_25 vdout0_25ck152 = 0 time = 765
* CHECK dout0_26 vdout0_26ck152 = 0 time = 765
* CHECK dout0_27 vdout0_27ck152 = 0.95 time = 765
* CHECK dout0_28 vdout0_28ck152 = 0.95 time = 765
* CHECK dout0_29 vdout0_29ck152 = 0.95 time = 765
* CHECK dout0_30 vdout0_30ck152 = 0 time = 765
* CHECK dout0_31 vdout0_31ck152 = 0 time = 765
* CHECK dout0_0 vdout0_0ck154 = 0 time = 775
* CHECK dout0_1 vdout0_1ck154 = 0.95 time = 775
* CHECK dout0_2 vdout0_2ck154 = 0.95 time = 775
* CHECK dout0_3 vdout0_3ck154 = 0 time = 775
* CHECK dout0_4 vdout0_4ck154 = 0 time = 775
* CHECK dout0_5 vdout0_5ck154 = 0.95 time = 775
* CHECK dout0_6 vdout0_6ck154 = 0.95 time = 775
* CHECK dout0_7 vdout0_7ck154 = 0.95 time = 775
* CHECK dout0_8 vdout0_8ck154 = 0.95 time = 775
* CHECK dout0_9 vdout0_9ck154 = 0.95 time = 775
* CHECK dout0_10 vdout0_10ck154 = 0 time = 775
* CHECK dout0_11 vdout0_11ck154 = 0.95 time = 775
* CHECK dout0_12 vdout0_12ck154 = 0 time = 775
* CHECK dout0_13 vdout0_13ck154 = 0 time = 775
* CHECK dout0_14 vdout0_14ck154 = 0 time = 775
* CHECK dout0_15 vdout0_15ck154 = 0 time = 775
* CHECK dout0_16 vdout0_16ck154 = 0.95 time = 775
* CHECK dout0_17 vdout0_17ck154 = 0 time = 775
* CHECK dout0_18 vdout0_18ck154 = 0.95 time = 775
* CHECK dout0_19 vdout0_19ck154 = 0.95 time = 775
* CHECK dout0_20 vdout0_20ck154 = 0.95 time = 775
* CHECK dout0_21 vdout0_21ck154 = 0 time = 775
* CHECK dout0_22 vdout0_22ck154 = 0.95 time = 775
* CHECK dout0_23 vdout0_23ck154 = 0 time = 775
* CHECK dout0_24 vdout0_24ck154 = 0.95 time = 775
* CHECK dout0_25 vdout0_25ck154 = 0 time = 775
* CHECK dout0_26 vdout0_26ck154 = 0 time = 775
* CHECK dout0_27 vdout0_27ck154 = 0 time = 775
* CHECK dout0_28 vdout0_28ck154 = 0 time = 775
* CHECK dout0_29 vdout0_29ck154 = 0.95 time = 775
* CHECK dout0_30 vdout0_30ck154 = 0.95 time = 775
* CHECK dout0_31 vdout0_31ck154 = 0 time = 775
* CHECK dout0_0 vdout0_0ck155 = 0 time = 780
* CHECK dout0_1 vdout0_1ck155 = 0 time = 780
* CHECK dout0_2 vdout0_2ck155 = 0 time = 780
* CHECK dout0_3 vdout0_3ck155 = 0 time = 780
* CHECK dout0_4 vdout0_4ck155 = 0.95 time = 780
* CHECK dout0_5 vdout0_5ck155 = 0.95 time = 780
* CHECK dout0_6 vdout0_6ck155 = 0 time = 780
* CHECK dout0_7 vdout0_7ck155 = 0 time = 780
* CHECK dout0_8 vdout0_8ck155 = 0 time = 780
* CHECK dout0_9 vdout0_9ck155 = 0.95 time = 780
* CHECK dout0_10 vdout0_10ck155 = 0 time = 780
* CHECK dout0_11 vdout0_11ck155 = 0 time = 780
* CHECK dout0_12 vdout0_12ck155 = 0.95 time = 780
* CHECK dout0_13 vdout0_13ck155 = 0.95 time = 780
* CHECK dout0_14 vdout0_14ck155 = 0 time = 780
* CHECK dout0_15 vdout0_15ck155 = 0.95 time = 780
* CHECK dout0_16 vdout0_16ck155 = 0 time = 780
* CHECK dout0_17 vdout0_17ck155 = 0 time = 780
* CHECK dout0_18 vdout0_18ck155 = 0 time = 780
* CHECK dout0_19 vdout0_19ck155 = 0 time = 780
* CHECK dout0_20 vdout0_20ck155 = 0.95 time = 780
* CHECK dout0_21 vdout0_21ck155 = 0.95 time = 780
* CHECK dout0_22 vdout0_22ck155 = 0.95 time = 780
* CHECK dout0_23 vdout0_23ck155 = 0 time = 780
* CHECK dout0_24 vdout0_24ck155 = 0.95 time = 780
* CHECK dout0_25 vdout0_25ck155 = 0 time = 780
* CHECK dout0_26 vdout0_26ck155 = 0.95 time = 780
* CHECK dout0_27 vdout0_27ck155 = 0 time = 780
* CHECK dout0_28 vdout0_28ck155 = 0.95 time = 780
* CHECK dout0_29 vdout0_29ck155 = 0 time = 780
* CHECK dout0_30 vdout0_30ck155 = 0.95 time = 780
* CHECK dout0_31 vdout0_31ck155 = 0 time = 780
* CHECK dout0_0 vdout0_0ck156 = 0 time = 785
* CHECK dout0_1 vdout0_1ck156 = 0.95 time = 785
* CHECK dout0_2 vdout0_2ck156 = 0.95 time = 785
* CHECK dout0_3 vdout0_3ck156 = 0 time = 785
* CHECK dout0_4 vdout0_4ck156 = 0 time = 785
* CHECK dout0_5 vdout0_5ck156 = 0.95 time = 785
* CHECK dout0_6 vdout0_6ck156 = 0.95 time = 785
* CHECK dout0_7 vdout0_7ck156 = 0.95 time = 785
* CHECK dout0_8 vdout0_8ck156 = 0.95 time = 785
* CHECK dout0_9 vdout0_9ck156 = 0.95 time = 785
* CHECK dout0_10 vdout0_10ck156 = 0 time = 785
* CHECK dout0_11 vdout0_11ck156 = 0.95 time = 785
* CHECK dout0_12 vdout0_12ck156 = 0 time = 785
* CHECK dout0_13 vdout0_13ck156 = 0 time = 785
* CHECK dout0_14 vdout0_14ck156 = 0 time = 785
* CHECK dout0_15 vdout0_15ck156 = 0 time = 785
* CHECK dout0_16 vdout0_16ck156 = 0.95 time = 785
* CHECK dout0_17 vdout0_17ck156 = 0 time = 785
* CHECK dout0_18 vdout0_18ck156 = 0.95 time = 785
* CHECK dout0_19 vdout0_19ck156 = 0.95 time = 785
* CHECK dout0_20 vdout0_20ck156 = 0.95 time = 785
* CHECK dout0_21 vdout0_21ck156 = 0 time = 785
* CHECK dout0_22 vdout0_22ck156 = 0.95 time = 785
* CHECK dout0_23 vdout0_23ck156 = 0 time = 785
* CHECK dout0_24 vdout0_24ck156 = 0.95 time = 785
* CHECK dout0_25 vdout0_25ck156 = 0 time = 785
* CHECK dout0_26 vdout0_26ck156 = 0 time = 785
* CHECK dout0_27 vdout0_27ck156 = 0 time = 785
* CHECK dout0_28 vdout0_28ck156 = 0 time = 785
* CHECK dout0_29 vdout0_29ck156 = 0.95 time = 785
* CHECK dout0_30 vdout0_30ck156 = 0.95 time = 785
* CHECK dout0_31 vdout0_31ck156 = 0 time = 785
* CHECK dout0_0 vdout0_0ck157 = 0 time = 790
* CHECK dout0_1 vdout0_1ck157 = 0 time = 790
* CHECK dout0_2 vdout0_2ck157 = 0 time = 790
* CHECK dout0_3 vdout0_3ck157 = 0 time = 790
* CHECK dout0_4 vdout0_4ck157 = 0.95 time = 790
* CHECK dout0_5 vdout0_5ck157 = 0.95 time = 790
* CHECK dout0_6 vdout0_6ck157 = 0 time = 790
* CHECK dout0_7 vdout0_7ck157 = 0 time = 790
* CHECK dout0_8 vdout0_8ck157 = 0 time = 790
* CHECK dout0_9 vdout0_9ck157 = 0.95 time = 790
* CHECK dout0_10 vdout0_10ck157 = 0 time = 790
* CHECK dout0_11 vdout0_11ck157 = 0 time = 790
* CHECK dout0_12 vdout0_12ck157 = 0.95 time = 790
* CHECK dout0_13 vdout0_13ck157 = 0.95 time = 790
* CHECK dout0_14 vdout0_14ck157 = 0 time = 790
* CHECK dout0_15 vdout0_15ck157 = 0.95 time = 790
* CHECK dout0_16 vdout0_16ck157 = 0 time = 790
* CHECK dout0_17 vdout0_17ck157 = 0 time = 790
* CHECK dout0_18 vdout0_18ck157 = 0 time = 790
* CHECK dout0_19 vdout0_19ck157 = 0 time = 790
* CHECK dout0_20 vdout0_20ck157 = 0.95 time = 790
* CHECK dout0_21 vdout0_21ck157 = 0.95 time = 790
* CHECK dout0_22 vdout0_22ck157 = 0.95 time = 790
* CHECK dout0_23 vdout0_23ck157 = 0 time = 790
* CHECK dout0_24 vdout0_24ck157 = 0.95 time = 790
* CHECK dout0_25 vdout0_25ck157 = 0 time = 790
* CHECK dout0_26 vdout0_26ck157 = 0.95 time = 790
* CHECK dout0_27 vdout0_27ck157 = 0 time = 790
* CHECK dout0_28 vdout0_28ck157 = 0.95 time = 790
* CHECK dout0_29 vdout0_29ck157 = 0 time = 790
* CHECK dout0_30 vdout0_30ck157 = 0.95 time = 790
* CHECK dout0_31 vdout0_31ck157 = 0 time = 790
* CHECK dout0_0 vdout0_0ck158 = 0 time = 795
* CHECK dout0_1 vdout0_1ck158 = 0 time = 795
* CHECK dout0_2 vdout0_2ck158 = 0 time = 795
* CHECK dout0_3 vdout0_3ck158 = 0 time = 795
* CHECK dout0_4 vdout0_4ck158 = 0 time = 795
* CHECK dout0_5 vdout0_5ck158 = 0.95 time = 795
* CHECK dout0_6 vdout0_6ck158 = 0 time = 795
* CHECK dout0_7 vdout0_7ck158 = 0 time = 795
* CHECK dout0_8 vdout0_8ck158 = 0 time = 795
* CHECK dout0_9 vdout0_9ck158 = 0 time = 795
* CHECK dout0_10 vdout0_10ck158 = 0 time = 795
* CHECK dout0_11 vdout0_11ck158 = 0 time = 795
* CHECK dout0_12 vdout0_12ck158 = 0 time = 795
* CHECK dout0_13 vdout0_13ck158 = 0.95 time = 795
* CHECK dout0_14 vdout0_14ck158 = 0 time = 795
* CHECK dout0_15 vdout0_15ck158 = 0 time = 795
* CHECK dout0_16 vdout0_16ck158 = 0 time = 795
* CHECK dout0_17 vdout0_17ck158 = 0.95 time = 795
* CHECK dout0_18 vdout0_18ck158 = 0.95 time = 795
* CHECK dout0_19 vdout0_19ck158 = 0 time = 795
* CHECK dout0_20 vdout0_20ck158 = 0 time = 795
* CHECK dout0_21 vdout0_21ck158 = 0.95 time = 795
* CHECK dout0_22 vdout0_22ck158 = 0.95 time = 795
* CHECK dout0_23 vdout0_23ck158 = 0.95 time = 795
* CHECK dout0_24 vdout0_24ck158 = 0.95 time = 795
* CHECK dout0_25 vdout0_25ck158 = 0 time = 795
* CHECK dout0_26 vdout0_26ck158 = 0 time = 795
* CHECK dout0_27 vdout0_27ck158 = 0 time = 795
* CHECK dout0_28 vdout0_28ck158 = 0.95 time = 795
* CHECK dout0_29 vdout0_29ck158 = 0.95 time = 795
* CHECK dout0_30 vdout0_30ck158 = 0.95 time = 795
* CHECK dout0_31 vdout0_31ck158 = 0.95 time = 795
* CHECK dout0_0 vdout0_0ck161 = 0 time = 810
* CHECK dout0_1 vdout0_1ck161 = 0 time = 810
* CHECK dout0_2 vdout0_2ck161 = 0 time = 810
* CHECK dout0_3 vdout0_3ck161 = 0 time = 810
* CHECK dout0_4 vdout0_4ck161 = 0 time = 810
* CHECK dout0_5 vdout0_5ck161 = 0.95 time = 810
* CHECK dout0_6 vdout0_6ck161 = 0 time = 810
* CHECK dout0_7 vdout0_7ck161 = 0 time = 810
* CHECK dout0_8 vdout0_8ck161 = 0 time = 810
* CHECK dout0_9 vdout0_9ck161 = 0 time = 810
* CHECK dout0_10 vdout0_10ck161 = 0 time = 810
* CHECK dout0_11 vdout0_11ck161 = 0 time = 810
* CHECK dout0_12 vdout0_12ck161 = 0 time = 810
* CHECK dout0_13 vdout0_13ck161 = 0.95 time = 810
* CHECK dout0_14 vdout0_14ck161 = 0 time = 810
* CHECK dout0_15 vdout0_15ck161 = 0 time = 810
* CHECK dout0_16 vdout0_16ck161 = 0 time = 810
* CHECK dout0_17 vdout0_17ck161 = 0.95 time = 810
* CHECK dout0_18 vdout0_18ck161 = 0.95 time = 810
* CHECK dout0_19 vdout0_19ck161 = 0 time = 810
* CHECK dout0_20 vdout0_20ck161 = 0 time = 810
* CHECK dout0_21 vdout0_21ck161 = 0.95 time = 810
* CHECK dout0_22 vdout0_22ck161 = 0.95 time = 810
* CHECK dout0_23 vdout0_23ck161 = 0.95 time = 810
* CHECK dout0_24 vdout0_24ck161 = 0.95 time = 810
* CHECK dout0_25 vdout0_25ck161 = 0 time = 810
* CHECK dout0_26 vdout0_26ck161 = 0 time = 810
* CHECK dout0_27 vdout0_27ck161 = 0 time = 810
* CHECK dout0_28 vdout0_28ck161 = 0.95 time = 810
* CHECK dout0_29 vdout0_29ck161 = 0.95 time = 810
* CHECK dout0_30 vdout0_30ck161 = 0.95 time = 810
* CHECK dout0_31 vdout0_31ck161 = 0.95 time = 810
* CHECK dout0_0 vdout0_0ck162 = 0 time = 815
* CHECK dout0_1 vdout0_1ck162 = 0 time = 815
* CHECK dout0_2 vdout0_2ck162 = 0.95 time = 815
* CHECK dout0_3 vdout0_3ck162 = 0 time = 815
* CHECK dout0_4 vdout0_4ck162 = 0 time = 815
* CHECK dout0_5 vdout0_5ck162 = 0.95 time = 815
* CHECK dout0_6 vdout0_6ck162 = 0.95 time = 815
* CHECK dout0_7 vdout0_7ck162 = 0 time = 815
* CHECK dout0_8 vdout0_8ck162 = 0.95 time = 815
* CHECK dout0_9 vdout0_9ck162 = 0 time = 815
* CHECK dout0_10 vdout0_10ck162 = 0 time = 815
* CHECK dout0_11 vdout0_11ck162 = 0.95 time = 815
* CHECK dout0_12 vdout0_12ck162 = 0 time = 815
* CHECK dout0_13 vdout0_13ck162 = 0.95 time = 815
* CHECK dout0_14 vdout0_14ck162 = 0 time = 815
* CHECK dout0_15 vdout0_15ck162 = 0 time = 815
* CHECK dout0_16 vdout0_16ck162 = 0.95 time = 815
* CHECK dout0_17 vdout0_17ck162 = 0.95 time = 815
* CHECK dout0_18 vdout0_18ck162 = 0.95 time = 815
* CHECK dout0_19 vdout0_19ck162 = 0.95 time = 815
* CHECK dout0_20 vdout0_20ck162 = 0 time = 815
* CHECK dout0_21 vdout0_21ck162 = 0.95 time = 815
* CHECK dout0_22 vdout0_22ck162 = 0 time = 815
* CHECK dout0_23 vdout0_23ck162 = 0.95 time = 815
* CHECK dout0_24 vdout0_24ck162 = 0.95 time = 815
* CHECK dout0_25 vdout0_25ck162 = 0 time = 815
* CHECK dout0_26 vdout0_26ck162 = 0.95 time = 815
* CHECK dout0_27 vdout0_27ck162 = 0 time = 815
* CHECK dout0_28 vdout0_28ck162 = 0 time = 815
* CHECK dout0_29 vdout0_29ck162 = 0.95 time = 815
* CHECK dout0_30 vdout0_30ck162 = 0.95 time = 815
* CHECK dout0_31 vdout0_31ck162 = 0 time = 815
* CHECK dout0_0 vdout0_0ck164 = 0 time = 825
* CHECK dout0_1 vdout0_1ck164 = 0.95 time = 825
* CHECK dout0_2 vdout0_2ck164 = 0.95 time = 825
* CHECK dout0_3 vdout0_3ck164 = 0 time = 825
* CHECK dout0_4 vdout0_4ck164 = 0 time = 825
* CHECK dout0_5 vdout0_5ck164 = 0.95 time = 825
* CHECK dout0_6 vdout0_6ck164 = 0.95 time = 825
* CHECK dout0_7 vdout0_7ck164 = 0.95 time = 825
* CHECK dout0_8 vdout0_8ck164 = 0.95 time = 825
* CHECK dout0_9 vdout0_9ck164 = 0.95 time = 825
* CHECK dout0_10 vdout0_10ck164 = 0 time = 825
* CHECK dout0_11 vdout0_11ck164 = 0.95 time = 825
* CHECK dout0_12 vdout0_12ck164 = 0 time = 825
* CHECK dout0_13 vdout0_13ck164 = 0 time = 825
* CHECK dout0_14 vdout0_14ck164 = 0 time = 825
* CHECK dout0_15 vdout0_15ck164 = 0 time = 825
* CHECK dout0_16 vdout0_16ck164 = 0.95 time = 825
* CHECK dout0_17 vdout0_17ck164 = 0 time = 825
* CHECK dout0_18 vdout0_18ck164 = 0.95 time = 825
* CHECK dout0_19 vdout0_19ck164 = 0.95 time = 825
* CHECK dout0_20 vdout0_20ck164 = 0.95 time = 825
* CHECK dout0_21 vdout0_21ck164 = 0 time = 825
* CHECK dout0_22 vdout0_22ck164 = 0.95 time = 825
* CHECK dout0_23 vdout0_23ck164 = 0 time = 825
* CHECK dout0_24 vdout0_24ck164 = 0.95 time = 825
* CHECK dout0_25 vdout0_25ck164 = 0 time = 825
* CHECK dout0_26 vdout0_26ck164 = 0 time = 825
* CHECK dout0_27 vdout0_27ck164 = 0 time = 825
* CHECK dout0_28 vdout0_28ck164 = 0 time = 825
* CHECK dout0_29 vdout0_29ck164 = 0.95 time = 825
* CHECK dout0_30 vdout0_30ck164 = 0.95 time = 825
* CHECK dout0_31 vdout0_31ck164 = 0 time = 825
* CHECK dout0_0 vdout0_0ck165 = 0.95 time = 830
* CHECK dout0_1 vdout0_1ck165 = 0 time = 830
* CHECK dout0_2 vdout0_2ck165 = 0 time = 830
* CHECK dout0_3 vdout0_3ck165 = 0.95 time = 830
* CHECK dout0_4 vdout0_4ck165 = 0 time = 830
* CHECK dout0_5 vdout0_5ck165 = 0 time = 830
* CHECK dout0_6 vdout0_6ck165 = 0.95 time = 830
* CHECK dout0_7 vdout0_7ck165 = 0.95 time = 830
* CHECK dout0_8 vdout0_8ck165 = 0 time = 830
* CHECK dout0_9 vdout0_9ck165 = 0 time = 830
* CHECK dout0_10 vdout0_10ck165 = 0 time = 830
* CHECK dout0_11 vdout0_11ck165 = 0.95 time = 830
* CHECK dout0_12 vdout0_12ck165 = 0 time = 830
* CHECK dout0_13 vdout0_13ck165 = 0.95 time = 830
* CHECK dout0_14 vdout0_14ck165 = 0 time = 830
* CHECK dout0_15 vdout0_15ck165 = 0.95 time = 830
* CHECK dout0_16 vdout0_16ck165 = 0.95 time = 830
* CHECK dout0_17 vdout0_17ck165 = 0.95 time = 830
* CHECK dout0_18 vdout0_18ck165 = 0.95 time = 830
* CHECK dout0_19 vdout0_19ck165 = 0 time = 830
* CHECK dout0_20 vdout0_20ck165 = 0.95 time = 830
* CHECK dout0_21 vdout0_21ck165 = 0.95 time = 830
* CHECK dout0_22 vdout0_22ck165 = 0 time = 830
* CHECK dout0_23 vdout0_23ck165 = 0.95 time = 830
* CHECK dout0_24 vdout0_24ck165 = 0 time = 830
* CHECK dout0_25 vdout0_25ck165 = 0.95 time = 830
* CHECK dout0_26 vdout0_26ck165 = 0 time = 830
* CHECK dout0_27 vdout0_27ck165 = 0 time = 830
* CHECK dout0_28 vdout0_28ck165 = 0.95 time = 830
* CHECK dout0_29 vdout0_29ck165 = 0.95 time = 830
* CHECK dout0_30 vdout0_30ck165 = 0 time = 830
* CHECK dout0_31 vdout0_31ck165 = 0.95 time = 830
* CHECK dout0_0 vdout0_0ck167 = 0.95 time = 840
* CHECK dout0_1 vdout0_1ck167 = 0 time = 840
* CHECK dout0_2 vdout0_2ck167 = 0 time = 840
* CHECK dout0_3 vdout0_3ck167 = 0.95 time = 840
* CHECK dout0_4 vdout0_4ck167 = 0 time = 840
* CHECK dout0_5 vdout0_5ck167 = 0 time = 840
* CHECK dout0_6 vdout0_6ck167 = 0.95 time = 840
* CHECK dout0_7 vdout0_7ck167 = 0.95 time = 840
* CHECK dout0_8 vdout0_8ck167 = 0 time = 840
* CHECK dout0_9 vdout0_9ck167 = 0 time = 840
* CHECK dout0_10 vdout0_10ck167 = 0 time = 840
* CHECK dout0_11 vdout0_11ck167 = 0.95 time = 840
* CHECK dout0_12 vdout0_12ck167 = 0 time = 840
* CHECK dout0_13 vdout0_13ck167 = 0.95 time = 840
* CHECK dout0_14 vdout0_14ck167 = 0 time = 840
* CHECK dout0_15 vdout0_15ck167 = 0.95 time = 840
* CHECK dout0_16 vdout0_16ck167 = 0.95 time = 840
* CHECK dout0_17 vdout0_17ck167 = 0.95 time = 840
* CHECK dout0_18 vdout0_18ck167 = 0.95 time = 840
* CHECK dout0_19 vdout0_19ck167 = 0 time = 840
* CHECK dout0_20 vdout0_20ck167 = 0.95 time = 840
* CHECK dout0_21 vdout0_21ck167 = 0.95 time = 840
* CHECK dout0_22 vdout0_22ck167 = 0 time = 840
* CHECK dout0_23 vdout0_23ck167 = 0.95 time = 840
* CHECK dout0_24 vdout0_24ck167 = 0 time = 840
* CHECK dout0_25 vdout0_25ck167 = 0.95 time = 840
* CHECK dout0_26 vdout0_26ck167 = 0 time = 840
* CHECK dout0_27 vdout0_27ck167 = 0 time = 840
* CHECK dout0_28 vdout0_28ck167 = 0.95 time = 840
* CHECK dout0_29 vdout0_29ck167 = 0.95 time = 840
* CHECK dout0_30 vdout0_30ck167 = 0 time = 840
* CHECK dout0_31 vdout0_31ck167 = 0.95 time = 840
* CHECK dout0_0 vdout0_0ck172 = 0 time = 865
* CHECK dout0_1 vdout0_1ck172 = 0 time = 865
* CHECK dout0_2 vdout0_2ck172 = 0 time = 865
* CHECK dout0_3 vdout0_3ck172 = 0 time = 865
* CHECK dout0_4 vdout0_4ck172 = 0 time = 865
* CHECK dout0_5 vdout0_5ck172 = 0.95 time = 865
* CHECK dout0_6 vdout0_6ck172 = 0 time = 865
* CHECK dout0_7 vdout0_7ck172 = 0 time = 865
* CHECK dout0_8 vdout0_8ck172 = 0 time = 865
* CHECK dout0_9 vdout0_9ck172 = 0 time = 865
* CHECK dout0_10 vdout0_10ck172 = 0 time = 865
* CHECK dout0_11 vdout0_11ck172 = 0 time = 865
* CHECK dout0_12 vdout0_12ck172 = 0 time = 865
* CHECK dout0_13 vdout0_13ck172 = 0.95 time = 865
* CHECK dout0_14 vdout0_14ck172 = 0 time = 865
* CHECK dout0_15 vdout0_15ck172 = 0 time = 865
* CHECK dout0_16 vdout0_16ck172 = 0 time = 865
* CHECK dout0_17 vdout0_17ck172 = 0.95 time = 865
* CHECK dout0_18 vdout0_18ck172 = 0.95 time = 865
* CHECK dout0_19 vdout0_19ck172 = 0 time = 865
* CHECK dout0_20 vdout0_20ck172 = 0 time = 865
* CHECK dout0_21 vdout0_21ck172 = 0.95 time = 865
* CHECK dout0_22 vdout0_22ck172 = 0.95 time = 865
* CHECK dout0_23 vdout0_23ck172 = 0.95 time = 865
* CHECK dout0_24 vdout0_24ck172 = 0.95 time = 865
* CHECK dout0_25 vdout0_25ck172 = 0 time = 865
* CHECK dout0_26 vdout0_26ck172 = 0 time = 865
* CHECK dout0_27 vdout0_27ck172 = 0 time = 865
* CHECK dout0_28 vdout0_28ck172 = 0.95 time = 865
* CHECK dout0_29 vdout0_29ck172 = 0.95 time = 865
* CHECK dout0_30 vdout0_30ck172 = 0.95 time = 865
* CHECK dout0_31 vdout0_31ck172 = 0.95 time = 865
* CHECK dout0_0 vdout0_0ck175 = 0.95 time = 880
* CHECK dout0_1 vdout0_1ck175 = 0.95 time = 880
* CHECK dout0_2 vdout0_2ck175 = 0 time = 880
* CHECK dout0_3 vdout0_3ck175 = 0.95 time = 880
* CHECK dout0_4 vdout0_4ck175 = 0.95 time = 880
* CHECK dout0_5 vdout0_5ck175 = 0 time = 880
* CHECK dout0_6 vdout0_6ck175 = 0.95 time = 880
* CHECK dout0_7 vdout0_7ck175 = 0 time = 880
* CHECK dout0_8 vdout0_8ck175 = 0.95 time = 880
* CHECK dout0_9 vdout0_9ck175 = 0 time = 880
* CHECK dout0_10 vdout0_10ck175 = 0 time = 880
* CHECK dout0_11 vdout0_11ck175 = 0 time = 880
* CHECK dout0_12 vdout0_12ck175 = 0 time = 880
* CHECK dout0_13 vdout0_13ck175 = 0.95 time = 880
* CHECK dout0_14 vdout0_14ck175 = 0 time = 880
* CHECK dout0_15 vdout0_15ck175 = 0.95 time = 880
* CHECK dout0_16 vdout0_16ck175 = 0.95 time = 880
* CHECK dout0_17 vdout0_17ck175 = 0 time = 880
* CHECK dout0_18 vdout0_18ck175 = 0 time = 880
* CHECK dout0_19 vdout0_19ck175 = 0.95 time = 880
* CHECK dout0_20 vdout0_20ck175 = 0 time = 880
* CHECK dout0_21 vdout0_21ck175 = 0 time = 880
* CHECK dout0_22 vdout0_22ck175 = 0.95 time = 880
* CHECK dout0_23 vdout0_23ck175 = 0.95 time = 880
* CHECK dout0_24 vdout0_24ck175 = 0.95 time = 880
* CHECK dout0_25 vdout0_25ck175 = 0.95 time = 880
* CHECK dout0_26 vdout0_26ck175 = 0 time = 880
* CHECK dout0_27 vdout0_27ck175 = 0.95 time = 880
* CHECK dout0_28 vdout0_28ck175 = 0.95 time = 880
* CHECK dout0_29 vdout0_29ck175 = 0 time = 880
* CHECK dout0_30 vdout0_30ck175 = 0 time = 880
* CHECK dout0_31 vdout0_31ck175 = 0.95 time = 880
* CHECK dout0_0 vdout0_0ck176 = 0 time = 885
* CHECK dout0_1 vdout0_1ck176 = 0 time = 885
* CHECK dout0_2 vdout0_2ck176 = 0.95 time = 885
* CHECK dout0_3 vdout0_3ck176 = 0 time = 885
* CHECK dout0_4 vdout0_4ck176 = 0 time = 885
* CHECK dout0_5 vdout0_5ck176 = 0 time = 885
* CHECK dout0_6 vdout0_6ck176 = 0.95 time = 885
* CHECK dout0_7 vdout0_7ck176 = 0.95 time = 885
* CHECK dout0_8 vdout0_8ck176 = 0.95 time = 885
* CHECK dout0_9 vdout0_9ck176 = 0.95 time = 885
* CHECK dout0_10 vdout0_10ck176 = 0 time = 885
* CHECK dout0_11 vdout0_11ck176 = 0.95 time = 885
* CHECK dout0_12 vdout0_12ck176 = 0.95 time = 885
* CHECK dout0_13 vdout0_13ck176 = 0 time = 885
* CHECK dout0_14 vdout0_14ck176 = 0 time = 885
* CHECK dout0_15 vdout0_15ck176 = 0.95 time = 885
* CHECK dout0_16 vdout0_16ck176 = 0.95 time = 885
* CHECK dout0_17 vdout0_17ck176 = 0.95 time = 885
* CHECK dout0_18 vdout0_18ck176 = 0 time = 885
* CHECK dout0_19 vdout0_19ck176 = 0 time = 885
* CHECK dout0_20 vdout0_20ck176 = 0.95 time = 885
* CHECK dout0_21 vdout0_21ck176 = 0.95 time = 885
* CHECK dout0_22 vdout0_22ck176 = 0.95 time = 885
* CHECK dout0_23 vdout0_23ck176 = 0 time = 885
* CHECK dout0_24 vdout0_24ck176 = 0 time = 885
* CHECK dout0_25 vdout0_25ck176 = 0.95 time = 885
* CHECK dout0_26 vdout0_26ck176 = 0 time = 885
* CHECK dout0_27 vdout0_27ck176 = 0 time = 885
* CHECK dout0_28 vdout0_28ck176 = 0 time = 885
* CHECK dout0_29 vdout0_29ck176 = 0 time = 885
* CHECK dout0_30 vdout0_30ck176 = 0.95 time = 885
* CHECK dout0_31 vdout0_31ck176 = 0 time = 885
* CHECK dout0_0 vdout0_0ck179 = 0 time = 900
* CHECK dout0_1 vdout0_1ck179 = 0 time = 900
* CHECK dout0_2 vdout0_2ck179 = 0.95 time = 900
* CHECK dout0_3 vdout0_3ck179 = 0.95 time = 900
* CHECK dout0_4 vdout0_4ck179 = 0.95 time = 900
* CHECK dout0_5 vdout0_5ck179 = 0.95 time = 900
* CHECK dout0_6 vdout0_6ck179 = 0 time = 900
* CHECK dout0_7 vdout0_7ck179 = 0 time = 900
* CHECK dout0_8 vdout0_8ck179 = 0.95 time = 900
* CHECK dout0_9 vdout0_9ck179 = 0 time = 900
* CHECK dout0_10 vdout0_10ck179 = 0.95 time = 900
* CHECK dout0_11 vdout0_11ck179 = 0 time = 900
* CHECK dout0_12 vdout0_12ck179 = 0.95 time = 900
* CHECK dout0_13 vdout0_13ck179 = 0 time = 900
* CHECK dout0_14 vdout0_14ck179 = 0 time = 900
* CHECK dout0_15 vdout0_15ck179 = 0.95 time = 900
* CHECK dout0_16 vdout0_16ck179 = 0 time = 900
* CHECK dout0_17 vdout0_17ck179 = 0.95 time = 900
* CHECK dout0_18 vdout0_18ck179 = 0.95 time = 900
* CHECK dout0_19 vdout0_19ck179 = 0.95 time = 900
* CHECK dout0_20 vdout0_20ck179 = 0 time = 900
* CHECK dout0_21 vdout0_21ck179 = 0.95 time = 900
* CHECK dout0_22 vdout0_22ck179 = 0 time = 900
* CHECK dout0_23 vdout0_23ck179 = 0.95 time = 900
* CHECK dout0_24 vdout0_24ck179 = 0 time = 900
* CHECK dout0_25 vdout0_25ck179 = 0 time = 900
* CHECK dout0_26 vdout0_26ck179 = 0.95 time = 900
* CHECK dout0_27 vdout0_27ck179 = 0.95 time = 900
* CHECK dout0_28 vdout0_28ck179 = 0 time = 900
* CHECK dout0_29 vdout0_29ck179 = 0 time = 900
* CHECK dout0_30 vdout0_30ck179 = 0 time = 900
* CHECK dout0_31 vdout0_31ck179 = 0.95 time = 900
* CHECK dout0_0 vdout0_0ck183 = 0 time = 920
* CHECK dout0_1 vdout0_1ck183 = 0 time = 920
* CHECK dout0_2 vdout0_2ck183 = 0.95 time = 920
* CHECK dout0_3 vdout0_3ck183 = 0.95 time = 920
* CHECK dout0_4 vdout0_4ck183 = 0.95 time = 920
* CHECK dout0_5 vdout0_5ck183 = 0.95 time = 920
* CHECK dout0_6 vdout0_6ck183 = 0 time = 920
* CHECK dout0_7 vdout0_7ck183 = 0 time = 920
* CHECK dout0_8 vdout0_8ck183 = 0.95 time = 920
* CHECK dout0_9 vdout0_9ck183 = 0 time = 920
* CHECK dout0_10 vdout0_10ck183 = 0.95 time = 920
* CHECK dout0_11 vdout0_11ck183 = 0 time = 920
* CHECK dout0_12 vdout0_12ck183 = 0.95 time = 920
* CHECK dout0_13 vdout0_13ck183 = 0 time = 920
* CHECK dout0_14 vdout0_14ck183 = 0 time = 920
* CHECK dout0_15 vdout0_15ck183 = 0.95 time = 920
* CHECK dout0_16 vdout0_16ck183 = 0 time = 920
* CHECK dout0_17 vdout0_17ck183 = 0.95 time = 920
* CHECK dout0_18 vdout0_18ck183 = 0.95 time = 920
* CHECK dout0_19 vdout0_19ck183 = 0.95 time = 920
* CHECK dout0_20 vdout0_20ck183 = 0 time = 920
* CHECK dout0_21 vdout0_21ck183 = 0.95 time = 920
* CHECK dout0_22 vdout0_22ck183 = 0 time = 920
* CHECK dout0_23 vdout0_23ck183 = 0.95 time = 920
* CHECK dout0_24 vdout0_24ck183 = 0 time = 920
* CHECK dout0_25 vdout0_25ck183 = 0 time = 920
* CHECK dout0_26 vdout0_26ck183 = 0.95 time = 920
* CHECK dout0_27 vdout0_27ck183 = 0.95 time = 920
* CHECK dout0_28 vdout0_28ck183 = 0 time = 920
* CHECK dout0_29 vdout0_29ck183 = 0 time = 920
* CHECK dout0_30 vdout0_30ck183 = 0 time = 920
* CHECK dout0_31 vdout0_31ck183 = 0.95 time = 920
* CHECK dout0_0 vdout0_0ck186 = 0 time = 935
* CHECK dout0_1 vdout0_1ck186 = 0 time = 935
* CHECK dout0_2 vdout0_2ck186 = 0 time = 935
* CHECK dout0_3 vdout0_3ck186 = 0 time = 935
* CHECK dout0_4 vdout0_4ck186 = 0 time = 935
* CHECK dout0_5 vdout0_5ck186 = 0.95 time = 935
* CHECK dout0_6 vdout0_6ck186 = 0 time = 935
* CHECK dout0_7 vdout0_7ck186 = 0 time = 935
* CHECK dout0_8 vdout0_8ck186 = 0 time = 935
* CHECK dout0_9 vdout0_9ck186 = 0 time = 935
* CHECK dout0_10 vdout0_10ck186 = 0 time = 935
* CHECK dout0_11 vdout0_11ck186 = 0 time = 935
* CHECK dout0_12 vdout0_12ck186 = 0 time = 935
* CHECK dout0_13 vdout0_13ck186 = 0.95 time = 935
* CHECK dout0_14 vdout0_14ck186 = 0 time = 935
* CHECK dout0_15 vdout0_15ck186 = 0 time = 935
* CHECK dout0_16 vdout0_16ck186 = 0 time = 935
* CHECK dout0_17 vdout0_17ck186 = 0.95 time = 935
* CHECK dout0_18 vdout0_18ck186 = 0.95 time = 935
* CHECK dout0_19 vdout0_19ck186 = 0 time = 935
* CHECK dout0_20 vdout0_20ck186 = 0 time = 935
* CHECK dout0_21 vdout0_21ck186 = 0.95 time = 935
* CHECK dout0_22 vdout0_22ck186 = 0.95 time = 935
* CHECK dout0_23 vdout0_23ck186 = 0.95 time = 935
* CHECK dout0_24 vdout0_24ck186 = 0.95 time = 935
* CHECK dout0_25 vdout0_25ck186 = 0 time = 935
* CHECK dout0_26 vdout0_26ck186 = 0 time = 935
* CHECK dout0_27 vdout0_27ck186 = 0 time = 935
* CHECK dout0_28 vdout0_28ck186 = 0.95 time = 935
* CHECK dout0_29 vdout0_29ck186 = 0.95 time = 935
* CHECK dout0_30 vdout0_30ck186 = 0.95 time = 935
* CHECK dout0_31 vdout0_31ck186 = 0.95 time = 935
* CHECK dout0_0 vdout0_0ck188 = 0.95 time = 945
* CHECK dout0_1 vdout0_1ck188 = 0 time = 945
* CHECK dout0_2 vdout0_2ck188 = 0.95 time = 945
* CHECK dout0_3 vdout0_3ck188 = 0 time = 945
* CHECK dout0_4 vdout0_4ck188 = 0.95 time = 945
* CHECK dout0_5 vdout0_5ck188 = 0.95 time = 945
* CHECK dout0_6 vdout0_6ck188 = 0 time = 945
* CHECK dout0_7 vdout0_7ck188 = 0.95 time = 945
* CHECK dout0_8 vdout0_8ck188 = 0.95 time = 945
* CHECK dout0_9 vdout0_9ck188 = 0 time = 945
* CHECK dout0_10 vdout0_10ck188 = 0 time = 945
* CHECK dout0_11 vdout0_11ck188 = 0 time = 945
* CHECK dout0_12 vdout0_12ck188 = 0.95 time = 945
* CHECK dout0_13 vdout0_13ck188 = 0 time = 945
* CHECK dout0_14 vdout0_14ck188 = 0.95 time = 945
* CHECK dout0_15 vdout0_15ck188 = 0 time = 945
* CHECK dout0_16 vdout0_16ck188 = 0.95 time = 945
* CHECK dout0_17 vdout0_17ck188 = 0 time = 945
* CHECK dout0_18 vdout0_18ck188 = 0.95 time = 945
* CHECK dout0_19 vdout0_19ck188 = 0.95 time = 945
* CHECK dout0_20 vdout0_20ck188 = 0 time = 945
* CHECK dout0_21 vdout0_21ck188 = 0 time = 945
* CHECK dout0_22 vdout0_22ck188 = 0.95 time = 945
* CHECK dout0_23 vdout0_23ck188 = 0.95 time = 945
* CHECK dout0_24 vdout0_24ck188 = 0 time = 945
* CHECK dout0_25 vdout0_25ck188 = 0.95 time = 945
* CHECK dout0_26 vdout0_26ck188 = 0 time = 945
* CHECK dout0_27 vdout0_27ck188 = 0 time = 945
* CHECK dout0_28 vdout0_28ck188 = 0.95 time = 945
* CHECK dout0_29 vdout0_29ck188 = 0.95 time = 945
* CHECK dout0_30 vdout0_30ck188 = 0.95 time = 945
* CHECK dout0_31 vdout0_31ck188 = 0.95 time = 945
* CHECK dout0_0 vdout0_0ck192 = 0 time = 965
* CHECK dout0_1 vdout0_1ck192 = 0 time = 965
* CHECK dout0_2 vdout0_2ck192 = 0.95 time = 965
* CHECK dout0_3 vdout0_3ck192 = 0 time = 965
* CHECK dout0_4 vdout0_4ck192 = 0.95 time = 965
* CHECK dout0_5 vdout0_5ck192 = 0 time = 965
* CHECK dout0_6 vdout0_6ck192 = 0 time = 965
* CHECK dout0_7 vdout0_7ck192 = 0.95 time = 965
* CHECK dout0_8 vdout0_8ck192 = 0 time = 965
* CHECK dout0_9 vdout0_9ck192 = 0 time = 965
* CHECK dout0_10 vdout0_10ck192 = 0 time = 965
* CHECK dout0_11 vdout0_11ck192 = 0.95 time = 965
* CHECK dout0_12 vdout0_12ck192 = 0 time = 965
* CHECK dout0_13 vdout0_13ck192 = 0 time = 965
* CHECK dout0_14 vdout0_14ck192 = 0 time = 965
* CHECK dout0_15 vdout0_15ck192 = 0.95 time = 965
* CHECK dout0_16 vdout0_16ck192 = 0 time = 965
* CHECK dout0_17 vdout0_17ck192 = 0.95 time = 965
* CHECK dout0_18 vdout0_18ck192 = 0 time = 965
* CHECK dout0_19 vdout0_19ck192 = 0 time = 965
* CHECK dout0_20 vdout0_20ck192 = 0 time = 965
* CHECK dout0_21 vdout0_21ck192 = 0 time = 965
* CHECK dout0_22 vdout0_22ck192 = 0 time = 965
* CHECK dout0_23 vdout0_23ck192 = 0.95 time = 965
* CHECK dout0_24 vdout0_24ck192 = 0.95 time = 965
* CHECK dout0_25 vdout0_25ck192 = 0 time = 965
* CHECK dout0_26 vdout0_26ck192 = 0 time = 965
* CHECK dout0_27 vdout0_27ck192 = 0 time = 965
* CHECK dout0_28 vdout0_28ck192 = 0 time = 965
* CHECK dout0_29 vdout0_29ck192 = 0 time = 965
* CHECK dout0_30 vdout0_30ck192 = 0 time = 965
* CHECK dout0_31 vdout0_31ck192 = 0 time = 965
* CHECK dout0_0 vdout0_0ck193 = 0 time = 970
* CHECK dout0_1 vdout0_1ck193 = 0.95 time = 970
* CHECK dout0_2 vdout0_2ck193 = 0 time = 970
* CHECK dout0_3 vdout0_3ck193 = 0 time = 970
* CHECK dout0_4 vdout0_4ck193 = 0.95 time = 970
* CHECK dout0_5 vdout0_5ck193 = 0 time = 970
* CHECK dout0_6 vdout0_6ck193 = 0 time = 970
* CHECK dout0_7 vdout0_7ck193 = 0 time = 970
* CHECK dout0_8 vdout0_8ck193 = 0 time = 970
* CHECK dout0_9 vdout0_9ck193 = 0.95 time = 970
* CHECK dout0_10 vdout0_10ck193 = 0 time = 970
* CHECK dout0_11 vdout0_11ck193 = 0.95 time = 970
* CHECK dout0_12 vdout0_12ck193 = 0.95 time = 970
* CHECK dout0_13 vdout0_13ck193 = 0.95 time = 970
* CHECK dout0_14 vdout0_14ck193 = 0.95 time = 970
* CHECK dout0_15 vdout0_15ck193 = 0.95 time = 970
* CHECK dout0_16 vdout0_16ck193 = 0.95 time = 970
* CHECK dout0_17 vdout0_17ck193 = 0 time = 970
* CHECK dout0_18 vdout0_18ck193 = 0 time = 970
* CHECK dout0_19 vdout0_19ck193 = 0.95 time = 970
* CHECK dout0_20 vdout0_20ck193 = 0 time = 970
* CHECK dout0_21 vdout0_21ck193 = 0.95 time = 970
* CHECK dout0_22 vdout0_22ck193 = 0 time = 970
* CHECK dout0_23 vdout0_23ck193 = 0.95 time = 970
* CHECK dout0_24 vdout0_24ck193 = 0.95 time = 970
* CHECK dout0_25 vdout0_25ck193 = 0.95 time = 970
* CHECK dout0_26 vdout0_26ck193 = 0.95 time = 970
* CHECK dout0_27 vdout0_27ck193 = 0.95 time = 970
* CHECK dout0_28 vdout0_28ck193 = 0 time = 970
* CHECK dout0_29 vdout0_29ck193 = 0.95 time = 970
* CHECK dout0_30 vdout0_30ck193 = 0.95 time = 970
* CHECK dout0_31 vdout0_31ck193 = 0.95 time = 970
* CHECK dout0_0 vdout0_0ck195 = 0 time = 980
* CHECK dout0_1 vdout0_1ck195 = 0 time = 980
* CHECK dout0_2 vdout0_2ck195 = 0.95 time = 980
* CHECK dout0_3 vdout0_3ck195 = 0.95 time = 980
* CHECK dout0_4 vdout0_4ck195 = 0.95 time = 980
* CHECK dout0_5 vdout0_5ck195 = 0.95 time = 980
* CHECK dout0_6 vdout0_6ck195 = 0 time = 980
* CHECK dout0_7 vdout0_7ck195 = 0 time = 980
* CHECK dout0_8 vdout0_8ck195 = 0.95 time = 980
* CHECK dout0_9 vdout0_9ck195 = 0 time = 980
* CHECK dout0_10 vdout0_10ck195 = 0.95 time = 980
* CHECK dout0_11 vdout0_11ck195 = 0 time = 980
* CHECK dout0_12 vdout0_12ck195 = 0.95 time = 980
* CHECK dout0_13 vdout0_13ck195 = 0 time = 980
* CHECK dout0_14 vdout0_14ck195 = 0 time = 980
* CHECK dout0_15 vdout0_15ck195 = 0.95 time = 980
* CHECK dout0_16 vdout0_16ck195 = 0 time = 980
* CHECK dout0_17 vdout0_17ck195 = 0.95 time = 980
* CHECK dout0_18 vdout0_18ck195 = 0.95 time = 980
* CHECK dout0_19 vdout0_19ck195 = 0.95 time = 980
* CHECK dout0_20 vdout0_20ck195 = 0 time = 980
* CHECK dout0_21 vdout0_21ck195 = 0.95 time = 980
* CHECK dout0_22 vdout0_22ck195 = 0 time = 980
* CHECK dout0_23 vdout0_23ck195 = 0.95 time = 980
* CHECK dout0_24 vdout0_24ck195 = 0.95 time = 980
* CHECK dout0_25 vdout0_25ck195 = 0 time = 980
* CHECK dout0_26 vdout0_26ck195 = 0.95 time = 980
* CHECK dout0_27 vdout0_27ck195 = 0.95 time = 980
* CHECK dout0_28 vdout0_28ck195 = 0.95 time = 980
* CHECK dout0_29 vdout0_29ck195 = 0 time = 980
* CHECK dout0_30 vdout0_30ck195 = 0.95 time = 980
* CHECK dout0_31 vdout0_31ck195 = 0 time = 980
* CHECK dout0_0 vdout0_0ck199 = 0 time = 1000
* CHECK dout0_1 vdout0_1ck199 = 0 time = 1000
* CHECK dout0_2 vdout0_2ck199 = 0 time = 1000
* CHECK dout0_3 vdout0_3ck199 = 0 time = 1000
* CHECK dout0_4 vdout0_4ck199 = 0 time = 1000
* CHECK dout0_5 vdout0_5ck199 = 0.95 time = 1000
* CHECK dout0_6 vdout0_6ck199 = 0 time = 1000
* CHECK dout0_7 vdout0_7ck199 = 0 time = 1000
* CHECK dout0_8 vdout0_8ck199 = 0 time = 1000
* CHECK dout0_9 vdout0_9ck199 = 0 time = 1000
* CHECK dout0_10 vdout0_10ck199 = 0 time = 1000
* CHECK dout0_11 vdout0_11ck199 = 0 time = 1000
* CHECK dout0_12 vdout0_12ck199 = 0 time = 1000
* CHECK dout0_13 vdout0_13ck199 = 0.95 time = 1000
* CHECK dout0_14 vdout0_14ck199 = 0 time = 1000
* CHECK dout0_15 vdout0_15ck199 = 0 time = 1000
* CHECK dout0_16 vdout0_16ck199 = 0 time = 1000
* CHECK dout0_17 vdout0_17ck199 = 0.95 time = 1000
* CHECK dout0_18 vdout0_18ck199 = 0.95 time = 1000
* CHECK dout0_19 vdout0_19ck199 = 0 time = 1000
* CHECK dout0_20 vdout0_20ck199 = 0 time = 1000
* CHECK dout0_21 vdout0_21ck199 = 0.95 time = 1000
* CHECK dout0_22 vdout0_22ck199 = 0.95 time = 1000
* CHECK dout0_23 vdout0_23ck199 = 0.95 time = 1000
* CHECK dout0_24 vdout0_24ck199 = 0.95 time = 1000
* CHECK dout0_25 vdout0_25ck199 = 0 time = 1000
* CHECK dout0_26 vdout0_26ck199 = 0 time = 1000
* CHECK dout0_27 vdout0_27ck199 = 0 time = 1000
* CHECK dout0_28 vdout0_28ck199 = 0.95 time = 1000
* CHECK dout0_29 vdout0_29ck199 = 0.95 time = 1000
* CHECK dout0_30 vdout0_30ck199 = 0.95 time = 1000
* CHECK dout0_31 vdout0_31ck199 = 0.95 time = 1000
.include /home/discontentBoron/OpenRAM/../orion-rv/sram/dcache_data_sram_1rw0r0w_32_512_freepdk45/functional_meas.sp
.OPTIONS DEVICE TEMP=125
.OPTIONS MEASURE MEASFAIL=1
.OPTIONS LINSOL type=klu
.OPTIONS TIMEINT RELTOL=1e-3 ABSTOL=1e-6 method=gear minorder=2
.TRAN 10p 1030n 0n 10p
* probe is used for hspice/xa, while plot is used in ngspice
.end
