.meas tran vdout0_0ck40 FIND v(dout0_0) AT=25.025n

.meas tran vdout0_1ck40 FIND v(dout0_1) AT=25.025n

.meas tran vdout0_2ck40 FIND v(dout0_2) AT=25.025n

.meas tran vdout0_3ck40 FIND v(dout0_3) AT=25.025n

.meas tran vdout0_4ck40 FIND v(dout0_4) AT=25.025n

.meas tran vdout0_5ck40 FIND v(dout0_5) AT=25.025n

.meas tran vdout0_6ck40 FIND v(dout0_6) AT=25.025n

.meas tran vdout0_7ck40 FIND v(dout0_7) AT=25.025n

.meas tran vdout0_8ck40 FIND v(dout0_8) AT=25.025n

.meas tran vdout0_9ck40 FIND v(dout0_9) AT=25.025n

.meas tran vdout0_10ck40 FIND v(dout0_10) AT=25.025n

.meas tran vdout0_11ck40 FIND v(dout0_11) AT=25.025n

.meas tran vdout0_12ck40 FIND v(dout0_12) AT=25.025n

.meas tran vdout0_13ck40 FIND v(dout0_13) AT=25.025n

.meas tran vdout0_14ck40 FIND v(dout0_14) AT=25.025n

.meas tran vdout0_15ck40 FIND v(dout0_15) AT=25.025n

.meas tran vdout0_16ck40 FIND v(dout0_16) AT=25.025n

.meas tran vdout0_17ck40 FIND v(dout0_17) AT=25.025n

.meas tran vdout0_18ck40 FIND v(dout0_18) AT=25.025n

.meas tran vdout0_19ck40 FIND v(dout0_19) AT=25.025n

.meas tran vdout0_20ck40 FIND v(dout0_20) AT=25.025n

.meas tran vdout0_0ck100 FIND v(dout0_0) AT=55.025n

.meas tran vdout0_1ck100 FIND v(dout0_1) AT=55.025n

.meas tran vdout0_2ck100 FIND v(dout0_2) AT=55.025n

.meas tran vdout0_3ck100 FIND v(dout0_3) AT=55.025n

.meas tran vdout0_4ck100 FIND v(dout0_4) AT=55.025n

.meas tran vdout0_5ck100 FIND v(dout0_5) AT=55.025n

.meas tran vdout0_6ck100 FIND v(dout0_6) AT=55.025n

.meas tran vdout0_7ck100 FIND v(dout0_7) AT=55.025n

.meas tran vdout0_8ck100 FIND v(dout0_8) AT=55.025n

.meas tran vdout0_9ck100 FIND v(dout0_9) AT=55.025n

.meas tran vdout0_10ck100 FIND v(dout0_10) AT=55.025n

.meas tran vdout0_11ck100 FIND v(dout0_11) AT=55.025n

.meas tran vdout0_12ck100 FIND v(dout0_12) AT=55.025n

.meas tran vdout0_13ck100 FIND v(dout0_13) AT=55.025n

.meas tran vdout0_14ck100 FIND v(dout0_14) AT=55.025n

.meas tran vdout0_15ck100 FIND v(dout0_15) AT=55.025n

.meas tran vdout0_16ck100 FIND v(dout0_16) AT=55.025n

.meas tran vdout0_17ck100 FIND v(dout0_17) AT=55.025n

.meas tran vdout0_18ck100 FIND v(dout0_18) AT=55.025n

.meas tran vdout0_19ck100 FIND v(dout0_19) AT=55.025n

.meas tran vdout0_20ck100 FIND v(dout0_20) AT=55.025n

.meas tran vdout0_0ck110 FIND v(dout0_0) AT=60.025n

.meas tran vdout0_1ck110 FIND v(dout0_1) AT=60.025n

.meas tran vdout0_2ck110 FIND v(dout0_2) AT=60.025n

.meas tran vdout0_3ck110 FIND v(dout0_3) AT=60.025n

.meas tran vdout0_4ck110 FIND v(dout0_4) AT=60.025n

.meas tran vdout0_5ck110 FIND v(dout0_5) AT=60.025n

.meas tran vdout0_6ck110 FIND v(dout0_6) AT=60.025n

.meas tran vdout0_7ck110 FIND v(dout0_7) AT=60.025n

.meas tran vdout0_8ck110 FIND v(dout0_8) AT=60.025n

.meas tran vdout0_9ck110 FIND v(dout0_9) AT=60.025n

.meas tran vdout0_10ck110 FIND v(dout0_10) AT=60.025n

.meas tran vdout0_11ck110 FIND v(dout0_11) AT=60.025n

.meas tran vdout0_12ck110 FIND v(dout0_12) AT=60.025n

.meas tran vdout0_13ck110 FIND v(dout0_13) AT=60.025n

.meas tran vdout0_14ck110 FIND v(dout0_14) AT=60.025n

.meas tran vdout0_15ck110 FIND v(dout0_15) AT=60.025n

.meas tran vdout0_16ck110 FIND v(dout0_16) AT=60.025n

.meas tran vdout0_17ck110 FIND v(dout0_17) AT=60.025n

.meas tran vdout0_18ck110 FIND v(dout0_18) AT=60.025n

.meas tran vdout0_19ck110 FIND v(dout0_19) AT=60.025n

.meas tran vdout0_20ck110 FIND v(dout0_20) AT=60.025n

.meas tran vdout0_0ck120 FIND v(dout0_0) AT=65.025n

.meas tran vdout0_1ck120 FIND v(dout0_1) AT=65.025n

.meas tran vdout0_2ck120 FIND v(dout0_2) AT=65.025n

.meas tran vdout0_3ck120 FIND v(dout0_3) AT=65.025n

.meas tran vdout0_4ck120 FIND v(dout0_4) AT=65.025n

.meas tran vdout0_5ck120 FIND v(dout0_5) AT=65.025n

.meas tran vdout0_6ck120 FIND v(dout0_6) AT=65.025n

.meas tran vdout0_7ck120 FIND v(dout0_7) AT=65.025n

.meas tran vdout0_8ck120 FIND v(dout0_8) AT=65.025n

.meas tran vdout0_9ck120 FIND v(dout0_9) AT=65.025n

.meas tran vdout0_10ck120 FIND v(dout0_10) AT=65.025n

.meas tran vdout0_11ck120 FIND v(dout0_11) AT=65.025n

.meas tran vdout0_12ck120 FIND v(dout0_12) AT=65.025n

.meas tran vdout0_13ck120 FIND v(dout0_13) AT=65.025n

.meas tran vdout0_14ck120 FIND v(dout0_14) AT=65.025n

.meas tran vdout0_15ck120 FIND v(dout0_15) AT=65.025n

.meas tran vdout0_16ck120 FIND v(dout0_16) AT=65.025n

.meas tran vdout0_17ck120 FIND v(dout0_17) AT=65.025n

.meas tran vdout0_18ck120 FIND v(dout0_18) AT=65.025n

.meas tran vdout0_19ck120 FIND v(dout0_19) AT=65.025n

.meas tran vdout0_20ck120 FIND v(dout0_20) AT=65.025n

.meas tran vdout0_0ck140 FIND v(dout0_0) AT=75.025n

.meas tran vdout0_1ck140 FIND v(dout0_1) AT=75.025n

.meas tran vdout0_2ck140 FIND v(dout0_2) AT=75.025n

.meas tran vdout0_3ck140 FIND v(dout0_3) AT=75.025n

.meas tran vdout0_4ck140 FIND v(dout0_4) AT=75.025n

.meas tran vdout0_5ck140 FIND v(dout0_5) AT=75.025n

.meas tran vdout0_6ck140 FIND v(dout0_6) AT=75.025n

.meas tran vdout0_7ck140 FIND v(dout0_7) AT=75.025n

.meas tran vdout0_8ck140 FIND v(dout0_8) AT=75.025n

.meas tran vdout0_9ck140 FIND v(dout0_9) AT=75.025n

.meas tran vdout0_10ck140 FIND v(dout0_10) AT=75.025n

.meas tran vdout0_11ck140 FIND v(dout0_11) AT=75.025n

.meas tran vdout0_12ck140 FIND v(dout0_12) AT=75.025n

.meas tran vdout0_13ck140 FIND v(dout0_13) AT=75.025n

.meas tran vdout0_14ck140 FIND v(dout0_14) AT=75.025n

.meas tran vdout0_15ck140 FIND v(dout0_15) AT=75.025n

.meas tran vdout0_16ck140 FIND v(dout0_16) AT=75.025n

.meas tran vdout0_17ck140 FIND v(dout0_17) AT=75.025n

.meas tran vdout0_18ck140 FIND v(dout0_18) AT=75.025n

.meas tran vdout0_19ck140 FIND v(dout0_19) AT=75.025n

.meas tran vdout0_20ck140 FIND v(dout0_20) AT=75.025n

.meas tran vdout0_0ck150 FIND v(dout0_0) AT=80.025n

.meas tran vdout0_1ck150 FIND v(dout0_1) AT=80.025n

.meas tran vdout0_2ck150 FIND v(dout0_2) AT=80.025n

.meas tran vdout0_3ck150 FIND v(dout0_3) AT=80.025n

.meas tran vdout0_4ck150 FIND v(dout0_4) AT=80.025n

.meas tran vdout0_5ck150 FIND v(dout0_5) AT=80.025n

.meas tran vdout0_6ck150 FIND v(dout0_6) AT=80.025n

.meas tran vdout0_7ck150 FIND v(dout0_7) AT=80.025n

.meas tran vdout0_8ck150 FIND v(dout0_8) AT=80.025n

.meas tran vdout0_9ck150 FIND v(dout0_9) AT=80.025n

.meas tran vdout0_10ck150 FIND v(dout0_10) AT=80.025n

.meas tran vdout0_11ck150 FIND v(dout0_11) AT=80.025n

.meas tran vdout0_12ck150 FIND v(dout0_12) AT=80.025n

.meas tran vdout0_13ck150 FIND v(dout0_13) AT=80.025n

.meas tran vdout0_14ck150 FIND v(dout0_14) AT=80.025n

.meas tran vdout0_15ck150 FIND v(dout0_15) AT=80.025n

.meas tran vdout0_16ck150 FIND v(dout0_16) AT=80.025n

.meas tran vdout0_17ck150 FIND v(dout0_17) AT=80.025n

.meas tran vdout0_18ck150 FIND v(dout0_18) AT=80.025n

.meas tran vdout0_19ck150 FIND v(dout0_19) AT=80.025n

.meas tran vdout0_20ck150 FIND v(dout0_20) AT=80.025n

.meas tran vdout0_0ck160 FIND v(dout0_0) AT=85.025n

.meas tran vdout0_1ck160 FIND v(dout0_1) AT=85.025n

.meas tran vdout0_2ck160 FIND v(dout0_2) AT=85.025n

.meas tran vdout0_3ck160 FIND v(dout0_3) AT=85.025n

.meas tran vdout0_4ck160 FIND v(dout0_4) AT=85.025n

.meas tran vdout0_5ck160 FIND v(dout0_5) AT=85.025n

.meas tran vdout0_6ck160 FIND v(dout0_6) AT=85.025n

.meas tran vdout0_7ck160 FIND v(dout0_7) AT=85.025n

.meas tran vdout0_8ck160 FIND v(dout0_8) AT=85.025n

.meas tran vdout0_9ck160 FIND v(dout0_9) AT=85.025n

.meas tran vdout0_10ck160 FIND v(dout0_10) AT=85.025n

.meas tran vdout0_11ck160 FIND v(dout0_11) AT=85.025n

.meas tran vdout0_12ck160 FIND v(dout0_12) AT=85.025n

.meas tran vdout0_13ck160 FIND v(dout0_13) AT=85.025n

.meas tran vdout0_14ck160 FIND v(dout0_14) AT=85.025n

.meas tran vdout0_15ck160 FIND v(dout0_15) AT=85.025n

.meas tran vdout0_16ck160 FIND v(dout0_16) AT=85.025n

.meas tran vdout0_17ck160 FIND v(dout0_17) AT=85.025n

.meas tran vdout0_18ck160 FIND v(dout0_18) AT=85.025n

.meas tran vdout0_19ck160 FIND v(dout0_19) AT=85.025n

.meas tran vdout0_20ck160 FIND v(dout0_20) AT=85.025n

.meas tran vdout0_0ck170 FIND v(dout0_0) AT=90.025n

.meas tran vdout0_1ck170 FIND v(dout0_1) AT=90.025n

.meas tran vdout0_2ck170 FIND v(dout0_2) AT=90.025n

.meas tran vdout0_3ck170 FIND v(dout0_3) AT=90.025n

.meas tran vdout0_4ck170 FIND v(dout0_4) AT=90.025n

.meas tran vdout0_5ck170 FIND v(dout0_5) AT=90.025n

.meas tran vdout0_6ck170 FIND v(dout0_6) AT=90.025n

.meas tran vdout0_7ck170 FIND v(dout0_7) AT=90.025n

.meas tran vdout0_8ck170 FIND v(dout0_8) AT=90.025n

.meas tran vdout0_9ck170 FIND v(dout0_9) AT=90.025n

.meas tran vdout0_10ck170 FIND v(dout0_10) AT=90.025n

.meas tran vdout0_11ck170 FIND v(dout0_11) AT=90.025n

.meas tran vdout0_12ck170 FIND v(dout0_12) AT=90.025n

.meas tran vdout0_13ck170 FIND v(dout0_13) AT=90.025n

.meas tran vdout0_14ck170 FIND v(dout0_14) AT=90.025n

.meas tran vdout0_15ck170 FIND v(dout0_15) AT=90.025n

.meas tran vdout0_16ck170 FIND v(dout0_16) AT=90.025n

.meas tran vdout0_17ck170 FIND v(dout0_17) AT=90.025n

.meas tran vdout0_18ck170 FIND v(dout0_18) AT=90.025n

.meas tran vdout0_19ck170 FIND v(dout0_19) AT=90.025n

.meas tran vdout0_20ck170 FIND v(dout0_20) AT=90.025n

.meas tran vdout0_0ck180 FIND v(dout0_0) AT=95.025n

.meas tran vdout0_1ck180 FIND v(dout0_1) AT=95.025n

.meas tran vdout0_2ck180 FIND v(dout0_2) AT=95.025n

.meas tran vdout0_3ck180 FIND v(dout0_3) AT=95.025n

.meas tran vdout0_4ck180 FIND v(dout0_4) AT=95.025n

.meas tran vdout0_5ck180 FIND v(dout0_5) AT=95.025n

.meas tran vdout0_6ck180 FIND v(dout0_6) AT=95.025n

.meas tran vdout0_7ck180 FIND v(dout0_7) AT=95.025n

.meas tran vdout0_8ck180 FIND v(dout0_8) AT=95.025n

.meas tran vdout0_9ck180 FIND v(dout0_9) AT=95.025n

.meas tran vdout0_10ck180 FIND v(dout0_10) AT=95.025n

.meas tran vdout0_11ck180 FIND v(dout0_11) AT=95.025n

.meas tran vdout0_12ck180 FIND v(dout0_12) AT=95.025n

.meas tran vdout0_13ck180 FIND v(dout0_13) AT=95.025n

.meas tran vdout0_14ck180 FIND v(dout0_14) AT=95.025n

.meas tran vdout0_15ck180 FIND v(dout0_15) AT=95.025n

.meas tran vdout0_16ck180 FIND v(dout0_16) AT=95.025n

.meas tran vdout0_17ck180 FIND v(dout0_17) AT=95.025n

.meas tran vdout0_18ck180 FIND v(dout0_18) AT=95.025n

.meas tran vdout0_19ck180 FIND v(dout0_19) AT=95.025n

.meas tran vdout0_20ck180 FIND v(dout0_20) AT=95.025n

.meas tran vdout0_0ck190 FIND v(dout0_0) AT=100.025n

.meas tran vdout0_1ck190 FIND v(dout0_1) AT=100.025n

.meas tran vdout0_2ck190 FIND v(dout0_2) AT=100.025n

.meas tran vdout0_3ck190 FIND v(dout0_3) AT=100.025n

.meas tran vdout0_4ck190 FIND v(dout0_4) AT=100.025n

.meas tran vdout0_5ck190 FIND v(dout0_5) AT=100.025n

.meas tran vdout0_6ck190 FIND v(dout0_6) AT=100.025n

.meas tran vdout0_7ck190 FIND v(dout0_7) AT=100.025n

.meas tran vdout0_8ck190 FIND v(dout0_8) AT=100.025n

.meas tran vdout0_9ck190 FIND v(dout0_9) AT=100.025n

.meas tran vdout0_10ck190 FIND v(dout0_10) AT=100.025n

.meas tran vdout0_11ck190 FIND v(dout0_11) AT=100.025n

.meas tran vdout0_12ck190 FIND v(dout0_12) AT=100.025n

.meas tran vdout0_13ck190 FIND v(dout0_13) AT=100.025n

.meas tran vdout0_14ck190 FIND v(dout0_14) AT=100.025n

.meas tran vdout0_15ck190 FIND v(dout0_15) AT=100.025n

.meas tran vdout0_16ck190 FIND v(dout0_16) AT=100.025n

.meas tran vdout0_17ck190 FIND v(dout0_17) AT=100.025n

.meas tran vdout0_18ck190 FIND v(dout0_18) AT=100.025n

.meas tran vdout0_19ck190 FIND v(dout0_19) AT=100.025n

.meas tran vdout0_20ck190 FIND v(dout0_20) AT=100.025n

.meas tran vdout0_0ck210 FIND v(dout0_0) AT=110.025n

.meas tran vdout0_1ck210 FIND v(dout0_1) AT=110.025n

.meas tran vdout0_2ck210 FIND v(dout0_2) AT=110.025n

.meas tran vdout0_3ck210 FIND v(dout0_3) AT=110.025n

.meas tran vdout0_4ck210 FIND v(dout0_4) AT=110.025n

.meas tran vdout0_5ck210 FIND v(dout0_5) AT=110.025n

.meas tran vdout0_6ck210 FIND v(dout0_6) AT=110.025n

.meas tran vdout0_7ck210 FIND v(dout0_7) AT=110.025n

.meas tran vdout0_8ck210 FIND v(dout0_8) AT=110.025n

.meas tran vdout0_9ck210 FIND v(dout0_9) AT=110.025n

.meas tran vdout0_10ck210 FIND v(dout0_10) AT=110.025n

.meas tran vdout0_11ck210 FIND v(dout0_11) AT=110.025n

.meas tran vdout0_12ck210 FIND v(dout0_12) AT=110.025n

.meas tran vdout0_13ck210 FIND v(dout0_13) AT=110.025n

.meas tran vdout0_14ck210 FIND v(dout0_14) AT=110.025n

.meas tran vdout0_15ck210 FIND v(dout0_15) AT=110.025n

.meas tran vdout0_16ck210 FIND v(dout0_16) AT=110.025n

.meas tran vdout0_17ck210 FIND v(dout0_17) AT=110.025n

.meas tran vdout0_18ck210 FIND v(dout0_18) AT=110.025n

.meas tran vdout0_19ck210 FIND v(dout0_19) AT=110.025n

.meas tran vdout0_20ck210 FIND v(dout0_20) AT=110.025n

.meas tran vdout0_0ck230 FIND v(dout0_0) AT=120.025n

.meas tran vdout0_1ck230 FIND v(dout0_1) AT=120.025n

.meas tran vdout0_2ck230 FIND v(dout0_2) AT=120.025n

.meas tran vdout0_3ck230 FIND v(dout0_3) AT=120.025n

.meas tran vdout0_4ck230 FIND v(dout0_4) AT=120.025n

.meas tran vdout0_5ck230 FIND v(dout0_5) AT=120.025n

.meas tran vdout0_6ck230 FIND v(dout0_6) AT=120.025n

.meas tran vdout0_7ck230 FIND v(dout0_7) AT=120.025n

.meas tran vdout0_8ck230 FIND v(dout0_8) AT=120.025n

.meas tran vdout0_9ck230 FIND v(dout0_9) AT=120.025n

.meas tran vdout0_10ck230 FIND v(dout0_10) AT=120.025n

.meas tran vdout0_11ck230 FIND v(dout0_11) AT=120.025n

.meas tran vdout0_12ck230 FIND v(dout0_12) AT=120.025n

.meas tran vdout0_13ck230 FIND v(dout0_13) AT=120.025n

.meas tran vdout0_14ck230 FIND v(dout0_14) AT=120.025n

.meas tran vdout0_15ck230 FIND v(dout0_15) AT=120.025n

.meas tran vdout0_16ck230 FIND v(dout0_16) AT=120.025n

.meas tran vdout0_17ck230 FIND v(dout0_17) AT=120.025n

.meas tran vdout0_18ck230 FIND v(dout0_18) AT=120.025n

.meas tran vdout0_19ck230 FIND v(dout0_19) AT=120.025n

.meas tran vdout0_20ck230 FIND v(dout0_20) AT=120.025n

.meas tran vdout0_0ck240 FIND v(dout0_0) AT=125.025n

.meas tran vdout0_1ck240 FIND v(dout0_1) AT=125.025n

.meas tran vdout0_2ck240 FIND v(dout0_2) AT=125.025n

.meas tran vdout0_3ck240 FIND v(dout0_3) AT=125.025n

.meas tran vdout0_4ck240 FIND v(dout0_4) AT=125.025n

.meas tran vdout0_5ck240 FIND v(dout0_5) AT=125.025n

.meas tran vdout0_6ck240 FIND v(dout0_6) AT=125.025n

.meas tran vdout0_7ck240 FIND v(dout0_7) AT=125.025n

.meas tran vdout0_8ck240 FIND v(dout0_8) AT=125.025n

.meas tran vdout0_9ck240 FIND v(dout0_9) AT=125.025n

.meas tran vdout0_10ck240 FIND v(dout0_10) AT=125.025n

.meas tran vdout0_11ck240 FIND v(dout0_11) AT=125.025n

.meas tran vdout0_12ck240 FIND v(dout0_12) AT=125.025n

.meas tran vdout0_13ck240 FIND v(dout0_13) AT=125.025n

.meas tran vdout0_14ck240 FIND v(dout0_14) AT=125.025n

.meas tran vdout0_15ck240 FIND v(dout0_15) AT=125.025n

.meas tran vdout0_16ck240 FIND v(dout0_16) AT=125.025n

.meas tran vdout0_17ck240 FIND v(dout0_17) AT=125.025n

.meas tran vdout0_18ck240 FIND v(dout0_18) AT=125.025n

.meas tran vdout0_19ck240 FIND v(dout0_19) AT=125.025n

.meas tran vdout0_20ck240 FIND v(dout0_20) AT=125.025n

.meas tran vdout0_0ck260 FIND v(dout0_0) AT=135.025n

.meas tran vdout0_1ck260 FIND v(dout0_1) AT=135.025n

.meas tran vdout0_2ck260 FIND v(dout0_2) AT=135.025n

.meas tran vdout0_3ck260 FIND v(dout0_3) AT=135.025n

.meas tran vdout0_4ck260 FIND v(dout0_4) AT=135.025n

.meas tran vdout0_5ck260 FIND v(dout0_5) AT=135.025n

.meas tran vdout0_6ck260 FIND v(dout0_6) AT=135.025n

.meas tran vdout0_7ck260 FIND v(dout0_7) AT=135.025n

.meas tran vdout0_8ck260 FIND v(dout0_8) AT=135.025n

.meas tran vdout0_9ck260 FIND v(dout0_9) AT=135.025n

.meas tran vdout0_10ck260 FIND v(dout0_10) AT=135.025n

.meas tran vdout0_11ck260 FIND v(dout0_11) AT=135.025n

.meas tran vdout0_12ck260 FIND v(dout0_12) AT=135.025n

.meas tran vdout0_13ck260 FIND v(dout0_13) AT=135.025n

.meas tran vdout0_14ck260 FIND v(dout0_14) AT=135.025n

.meas tran vdout0_15ck260 FIND v(dout0_15) AT=135.025n

.meas tran vdout0_16ck260 FIND v(dout0_16) AT=135.025n

.meas tran vdout0_17ck260 FIND v(dout0_17) AT=135.025n

.meas tran vdout0_18ck260 FIND v(dout0_18) AT=135.025n

.meas tran vdout0_19ck260 FIND v(dout0_19) AT=135.025n

.meas tran vdout0_20ck260 FIND v(dout0_20) AT=135.025n

.meas tran vdout0_0ck270 FIND v(dout0_0) AT=140.025n

.meas tran vdout0_1ck270 FIND v(dout0_1) AT=140.025n

.meas tran vdout0_2ck270 FIND v(dout0_2) AT=140.025n

.meas tran vdout0_3ck270 FIND v(dout0_3) AT=140.025n

.meas tran vdout0_4ck270 FIND v(dout0_4) AT=140.025n

.meas tran vdout0_5ck270 FIND v(dout0_5) AT=140.025n

.meas tran vdout0_6ck270 FIND v(dout0_6) AT=140.025n

.meas tran vdout0_7ck270 FIND v(dout0_7) AT=140.025n

.meas tran vdout0_8ck270 FIND v(dout0_8) AT=140.025n

.meas tran vdout0_9ck270 FIND v(dout0_9) AT=140.025n

.meas tran vdout0_10ck270 FIND v(dout0_10) AT=140.025n

.meas tran vdout0_11ck270 FIND v(dout0_11) AT=140.025n

.meas tran vdout0_12ck270 FIND v(dout0_12) AT=140.025n

.meas tran vdout0_13ck270 FIND v(dout0_13) AT=140.025n

.meas tran vdout0_14ck270 FIND v(dout0_14) AT=140.025n

.meas tran vdout0_15ck270 FIND v(dout0_15) AT=140.025n

.meas tran vdout0_16ck270 FIND v(dout0_16) AT=140.025n

.meas tran vdout0_17ck270 FIND v(dout0_17) AT=140.025n

.meas tran vdout0_18ck270 FIND v(dout0_18) AT=140.025n

.meas tran vdout0_19ck270 FIND v(dout0_19) AT=140.025n

.meas tran vdout0_20ck270 FIND v(dout0_20) AT=140.025n

.meas tran vdout0_0ck290 FIND v(dout0_0) AT=150.025n

.meas tran vdout0_1ck290 FIND v(dout0_1) AT=150.025n

.meas tran vdout0_2ck290 FIND v(dout0_2) AT=150.025n

.meas tran vdout0_3ck290 FIND v(dout0_3) AT=150.025n

.meas tran vdout0_4ck290 FIND v(dout0_4) AT=150.025n

.meas tran vdout0_5ck290 FIND v(dout0_5) AT=150.025n

.meas tran vdout0_6ck290 FIND v(dout0_6) AT=150.025n

.meas tran vdout0_7ck290 FIND v(dout0_7) AT=150.025n

.meas tran vdout0_8ck290 FIND v(dout0_8) AT=150.025n

.meas tran vdout0_9ck290 FIND v(dout0_9) AT=150.025n

.meas tran vdout0_10ck290 FIND v(dout0_10) AT=150.025n

.meas tran vdout0_11ck290 FIND v(dout0_11) AT=150.025n

.meas tran vdout0_12ck290 FIND v(dout0_12) AT=150.025n

.meas tran vdout0_13ck290 FIND v(dout0_13) AT=150.025n

.meas tran vdout0_14ck290 FIND v(dout0_14) AT=150.025n

.meas tran vdout0_15ck290 FIND v(dout0_15) AT=150.025n

.meas tran vdout0_16ck290 FIND v(dout0_16) AT=150.025n

.meas tran vdout0_17ck290 FIND v(dout0_17) AT=150.025n

.meas tran vdout0_18ck290 FIND v(dout0_18) AT=150.025n

.meas tran vdout0_19ck290 FIND v(dout0_19) AT=150.025n

.meas tran vdout0_20ck290 FIND v(dout0_20) AT=150.025n

.meas tran vdout0_0ck300 FIND v(dout0_0) AT=155.025n

.meas tran vdout0_1ck300 FIND v(dout0_1) AT=155.025n

.meas tran vdout0_2ck300 FIND v(dout0_2) AT=155.025n

.meas tran vdout0_3ck300 FIND v(dout0_3) AT=155.025n

.meas tran vdout0_4ck300 FIND v(dout0_4) AT=155.025n

.meas tran vdout0_5ck300 FIND v(dout0_5) AT=155.025n

.meas tran vdout0_6ck300 FIND v(dout0_6) AT=155.025n

.meas tran vdout0_7ck300 FIND v(dout0_7) AT=155.025n

.meas tran vdout0_8ck300 FIND v(dout0_8) AT=155.025n

.meas tran vdout0_9ck300 FIND v(dout0_9) AT=155.025n

.meas tran vdout0_10ck300 FIND v(dout0_10) AT=155.025n

.meas tran vdout0_11ck300 FIND v(dout0_11) AT=155.025n

.meas tran vdout0_12ck300 FIND v(dout0_12) AT=155.025n

.meas tran vdout0_13ck300 FIND v(dout0_13) AT=155.025n

.meas tran vdout0_14ck300 FIND v(dout0_14) AT=155.025n

.meas tran vdout0_15ck300 FIND v(dout0_15) AT=155.025n

.meas tran vdout0_16ck300 FIND v(dout0_16) AT=155.025n

.meas tran vdout0_17ck300 FIND v(dout0_17) AT=155.025n

.meas tran vdout0_18ck300 FIND v(dout0_18) AT=155.025n

.meas tran vdout0_19ck300 FIND v(dout0_19) AT=155.025n

.meas tran vdout0_20ck300 FIND v(dout0_20) AT=155.025n

.meas tran vdout0_0ck330 FIND v(dout0_0) AT=170.025n

.meas tran vdout0_1ck330 FIND v(dout0_1) AT=170.025n

.meas tran vdout0_2ck330 FIND v(dout0_2) AT=170.025n

.meas tran vdout0_3ck330 FIND v(dout0_3) AT=170.025n

.meas tran vdout0_4ck330 FIND v(dout0_4) AT=170.025n

.meas tran vdout0_5ck330 FIND v(dout0_5) AT=170.025n

.meas tran vdout0_6ck330 FIND v(dout0_6) AT=170.025n

.meas tran vdout0_7ck330 FIND v(dout0_7) AT=170.025n

.meas tran vdout0_8ck330 FIND v(dout0_8) AT=170.025n

.meas tran vdout0_9ck330 FIND v(dout0_9) AT=170.025n

.meas tran vdout0_10ck330 FIND v(dout0_10) AT=170.025n

.meas tran vdout0_11ck330 FIND v(dout0_11) AT=170.025n

.meas tran vdout0_12ck330 FIND v(dout0_12) AT=170.025n

.meas tran vdout0_13ck330 FIND v(dout0_13) AT=170.025n

.meas tran vdout0_14ck330 FIND v(dout0_14) AT=170.025n

.meas tran vdout0_15ck330 FIND v(dout0_15) AT=170.025n

.meas tran vdout0_16ck330 FIND v(dout0_16) AT=170.025n

.meas tran vdout0_17ck330 FIND v(dout0_17) AT=170.025n

.meas tran vdout0_18ck330 FIND v(dout0_18) AT=170.025n

.meas tran vdout0_19ck330 FIND v(dout0_19) AT=170.025n

.meas tran vdout0_20ck330 FIND v(dout0_20) AT=170.025n

.meas tran vdout0_0ck350 FIND v(dout0_0) AT=180.025n

.meas tran vdout0_1ck350 FIND v(dout0_1) AT=180.025n

.meas tran vdout0_2ck350 FIND v(dout0_2) AT=180.025n

.meas tran vdout0_3ck350 FIND v(dout0_3) AT=180.025n

.meas tran vdout0_4ck350 FIND v(dout0_4) AT=180.025n

.meas tran vdout0_5ck350 FIND v(dout0_5) AT=180.025n

.meas tran vdout0_6ck350 FIND v(dout0_6) AT=180.025n

.meas tran vdout0_7ck350 FIND v(dout0_7) AT=180.025n

.meas tran vdout0_8ck350 FIND v(dout0_8) AT=180.025n

.meas tran vdout0_9ck350 FIND v(dout0_9) AT=180.025n

.meas tran vdout0_10ck350 FIND v(dout0_10) AT=180.025n

.meas tran vdout0_11ck350 FIND v(dout0_11) AT=180.025n

.meas tran vdout0_12ck350 FIND v(dout0_12) AT=180.025n

.meas tran vdout0_13ck350 FIND v(dout0_13) AT=180.025n

.meas tran vdout0_14ck350 FIND v(dout0_14) AT=180.025n

.meas tran vdout0_15ck350 FIND v(dout0_15) AT=180.025n

.meas tran vdout0_16ck350 FIND v(dout0_16) AT=180.025n

.meas tran vdout0_17ck350 FIND v(dout0_17) AT=180.025n

.meas tran vdout0_18ck350 FIND v(dout0_18) AT=180.025n

.meas tran vdout0_19ck350 FIND v(dout0_19) AT=180.025n

.meas tran vdout0_20ck350 FIND v(dout0_20) AT=180.025n

.meas tran vdout0_0ck360 FIND v(dout0_0) AT=185.025n

.meas tran vdout0_1ck360 FIND v(dout0_1) AT=185.025n

.meas tran vdout0_2ck360 FIND v(dout0_2) AT=185.025n

.meas tran vdout0_3ck360 FIND v(dout0_3) AT=185.025n

.meas tran vdout0_4ck360 FIND v(dout0_4) AT=185.025n

.meas tran vdout0_5ck360 FIND v(dout0_5) AT=185.025n

.meas tran vdout0_6ck360 FIND v(dout0_6) AT=185.025n

.meas tran vdout0_7ck360 FIND v(dout0_7) AT=185.025n

.meas tran vdout0_8ck360 FIND v(dout0_8) AT=185.025n

.meas tran vdout0_9ck360 FIND v(dout0_9) AT=185.025n

.meas tran vdout0_10ck360 FIND v(dout0_10) AT=185.025n

.meas tran vdout0_11ck360 FIND v(dout0_11) AT=185.025n

.meas tran vdout0_12ck360 FIND v(dout0_12) AT=185.025n

.meas tran vdout0_13ck360 FIND v(dout0_13) AT=185.025n

.meas tran vdout0_14ck360 FIND v(dout0_14) AT=185.025n

.meas tran vdout0_15ck360 FIND v(dout0_15) AT=185.025n

.meas tran vdout0_16ck360 FIND v(dout0_16) AT=185.025n

.meas tran vdout0_17ck360 FIND v(dout0_17) AT=185.025n

.meas tran vdout0_18ck360 FIND v(dout0_18) AT=185.025n

.meas tran vdout0_19ck360 FIND v(dout0_19) AT=185.025n

.meas tran vdout0_20ck360 FIND v(dout0_20) AT=185.025n

.meas tran vdout0_0ck400 FIND v(dout0_0) AT=205.025n

.meas tran vdout0_1ck400 FIND v(dout0_1) AT=205.025n

.meas tran vdout0_2ck400 FIND v(dout0_2) AT=205.025n

.meas tran vdout0_3ck400 FIND v(dout0_3) AT=205.025n

.meas tran vdout0_4ck400 FIND v(dout0_4) AT=205.025n

.meas tran vdout0_5ck400 FIND v(dout0_5) AT=205.025n

.meas tran vdout0_6ck400 FIND v(dout0_6) AT=205.025n

.meas tran vdout0_7ck400 FIND v(dout0_7) AT=205.025n

.meas tran vdout0_8ck400 FIND v(dout0_8) AT=205.025n

.meas tran vdout0_9ck400 FIND v(dout0_9) AT=205.025n

.meas tran vdout0_10ck400 FIND v(dout0_10) AT=205.025n

.meas tran vdout0_11ck400 FIND v(dout0_11) AT=205.025n

.meas tran vdout0_12ck400 FIND v(dout0_12) AT=205.025n

.meas tran vdout0_13ck400 FIND v(dout0_13) AT=205.025n

.meas tran vdout0_14ck400 FIND v(dout0_14) AT=205.025n

.meas tran vdout0_15ck400 FIND v(dout0_15) AT=205.025n

.meas tran vdout0_16ck400 FIND v(dout0_16) AT=205.025n

.meas tran vdout0_17ck400 FIND v(dout0_17) AT=205.025n

.meas tran vdout0_18ck400 FIND v(dout0_18) AT=205.025n

.meas tran vdout0_19ck400 FIND v(dout0_19) AT=205.025n

.meas tran vdout0_20ck400 FIND v(dout0_20) AT=205.025n

.meas tran vdout0_0ck410 FIND v(dout0_0) AT=210.025n

.meas tran vdout0_1ck410 FIND v(dout0_1) AT=210.025n

.meas tran vdout0_2ck410 FIND v(dout0_2) AT=210.025n

.meas tran vdout0_3ck410 FIND v(dout0_3) AT=210.025n

.meas tran vdout0_4ck410 FIND v(dout0_4) AT=210.025n

.meas tran vdout0_5ck410 FIND v(dout0_5) AT=210.025n

.meas tran vdout0_6ck410 FIND v(dout0_6) AT=210.025n

.meas tran vdout0_7ck410 FIND v(dout0_7) AT=210.025n

.meas tran vdout0_8ck410 FIND v(dout0_8) AT=210.025n

.meas tran vdout0_9ck410 FIND v(dout0_9) AT=210.025n

.meas tran vdout0_10ck410 FIND v(dout0_10) AT=210.025n

.meas tran vdout0_11ck410 FIND v(dout0_11) AT=210.025n

.meas tran vdout0_12ck410 FIND v(dout0_12) AT=210.025n

.meas tran vdout0_13ck410 FIND v(dout0_13) AT=210.025n

.meas tran vdout0_14ck410 FIND v(dout0_14) AT=210.025n

.meas tran vdout0_15ck410 FIND v(dout0_15) AT=210.025n

.meas tran vdout0_16ck410 FIND v(dout0_16) AT=210.025n

.meas tran vdout0_17ck410 FIND v(dout0_17) AT=210.025n

.meas tran vdout0_18ck410 FIND v(dout0_18) AT=210.025n

.meas tran vdout0_19ck410 FIND v(dout0_19) AT=210.025n

.meas tran vdout0_20ck410 FIND v(dout0_20) AT=210.025n

.meas tran vdout0_0ck420 FIND v(dout0_0) AT=215.025n

.meas tran vdout0_1ck420 FIND v(dout0_1) AT=215.025n

.meas tran vdout0_2ck420 FIND v(dout0_2) AT=215.025n

.meas tran vdout0_3ck420 FIND v(dout0_3) AT=215.025n

.meas tran vdout0_4ck420 FIND v(dout0_4) AT=215.025n

.meas tran vdout0_5ck420 FIND v(dout0_5) AT=215.025n

.meas tran vdout0_6ck420 FIND v(dout0_6) AT=215.025n

.meas tran vdout0_7ck420 FIND v(dout0_7) AT=215.025n

.meas tran vdout0_8ck420 FIND v(dout0_8) AT=215.025n

.meas tran vdout0_9ck420 FIND v(dout0_9) AT=215.025n

.meas tran vdout0_10ck420 FIND v(dout0_10) AT=215.025n

.meas tran vdout0_11ck420 FIND v(dout0_11) AT=215.025n

.meas tran vdout0_12ck420 FIND v(dout0_12) AT=215.025n

.meas tran vdout0_13ck420 FIND v(dout0_13) AT=215.025n

.meas tran vdout0_14ck420 FIND v(dout0_14) AT=215.025n

.meas tran vdout0_15ck420 FIND v(dout0_15) AT=215.025n

.meas tran vdout0_16ck420 FIND v(dout0_16) AT=215.025n

.meas tran vdout0_17ck420 FIND v(dout0_17) AT=215.025n

.meas tran vdout0_18ck420 FIND v(dout0_18) AT=215.025n

.meas tran vdout0_19ck420 FIND v(dout0_19) AT=215.025n

.meas tran vdout0_20ck420 FIND v(dout0_20) AT=215.025n

.meas tran vdout0_0ck470 FIND v(dout0_0) AT=240.025n

.meas tran vdout0_1ck470 FIND v(dout0_1) AT=240.025n

.meas tran vdout0_2ck470 FIND v(dout0_2) AT=240.025n

.meas tran vdout0_3ck470 FIND v(dout0_3) AT=240.025n

.meas tran vdout0_4ck470 FIND v(dout0_4) AT=240.025n

.meas tran vdout0_5ck470 FIND v(dout0_5) AT=240.025n

.meas tran vdout0_6ck470 FIND v(dout0_6) AT=240.025n

.meas tran vdout0_7ck470 FIND v(dout0_7) AT=240.025n

.meas tran vdout0_8ck470 FIND v(dout0_8) AT=240.025n

.meas tran vdout0_9ck470 FIND v(dout0_9) AT=240.025n

.meas tran vdout0_10ck470 FIND v(dout0_10) AT=240.025n

.meas tran vdout0_11ck470 FIND v(dout0_11) AT=240.025n

.meas tran vdout0_12ck470 FIND v(dout0_12) AT=240.025n

.meas tran vdout0_13ck470 FIND v(dout0_13) AT=240.025n

.meas tran vdout0_14ck470 FIND v(dout0_14) AT=240.025n

.meas tran vdout0_15ck470 FIND v(dout0_15) AT=240.025n

.meas tran vdout0_16ck470 FIND v(dout0_16) AT=240.025n

.meas tran vdout0_17ck470 FIND v(dout0_17) AT=240.025n

.meas tran vdout0_18ck470 FIND v(dout0_18) AT=240.025n

.meas tran vdout0_19ck470 FIND v(dout0_19) AT=240.025n

.meas tran vdout0_20ck470 FIND v(dout0_20) AT=240.025n

.meas tran vdout0_0ck500 FIND v(dout0_0) AT=255.025n

.meas tran vdout0_1ck500 FIND v(dout0_1) AT=255.025n

.meas tran vdout0_2ck500 FIND v(dout0_2) AT=255.025n

.meas tran vdout0_3ck500 FIND v(dout0_3) AT=255.025n

.meas tran vdout0_4ck500 FIND v(dout0_4) AT=255.025n

.meas tran vdout0_5ck500 FIND v(dout0_5) AT=255.025n

.meas tran vdout0_6ck500 FIND v(dout0_6) AT=255.025n

.meas tran vdout0_7ck500 FIND v(dout0_7) AT=255.025n

.meas tran vdout0_8ck500 FIND v(dout0_8) AT=255.025n

.meas tran vdout0_9ck500 FIND v(dout0_9) AT=255.025n

.meas tran vdout0_10ck500 FIND v(dout0_10) AT=255.025n

.meas tran vdout0_11ck500 FIND v(dout0_11) AT=255.025n

.meas tran vdout0_12ck500 FIND v(dout0_12) AT=255.025n

.meas tran vdout0_13ck500 FIND v(dout0_13) AT=255.025n

.meas tran vdout0_14ck500 FIND v(dout0_14) AT=255.025n

.meas tran vdout0_15ck500 FIND v(dout0_15) AT=255.025n

.meas tran vdout0_16ck500 FIND v(dout0_16) AT=255.025n

.meas tran vdout0_17ck500 FIND v(dout0_17) AT=255.025n

.meas tran vdout0_18ck500 FIND v(dout0_18) AT=255.025n

.meas tran vdout0_19ck500 FIND v(dout0_19) AT=255.025n

.meas tran vdout0_20ck500 FIND v(dout0_20) AT=255.025n

.meas tran vdout0_0ck580 FIND v(dout0_0) AT=295.025n

.meas tran vdout0_1ck580 FIND v(dout0_1) AT=295.025n

.meas tran vdout0_2ck580 FIND v(dout0_2) AT=295.025n

.meas tran vdout0_3ck580 FIND v(dout0_3) AT=295.025n

.meas tran vdout0_4ck580 FIND v(dout0_4) AT=295.025n

.meas tran vdout0_5ck580 FIND v(dout0_5) AT=295.025n

.meas tran vdout0_6ck580 FIND v(dout0_6) AT=295.025n

.meas tran vdout0_7ck580 FIND v(dout0_7) AT=295.025n

.meas tran vdout0_8ck580 FIND v(dout0_8) AT=295.025n

.meas tran vdout0_9ck580 FIND v(dout0_9) AT=295.025n

.meas tran vdout0_10ck580 FIND v(dout0_10) AT=295.025n

.meas tran vdout0_11ck580 FIND v(dout0_11) AT=295.025n

.meas tran vdout0_12ck580 FIND v(dout0_12) AT=295.025n

.meas tran vdout0_13ck580 FIND v(dout0_13) AT=295.025n

.meas tran vdout0_14ck580 FIND v(dout0_14) AT=295.025n

.meas tran vdout0_15ck580 FIND v(dout0_15) AT=295.025n

.meas tran vdout0_16ck580 FIND v(dout0_16) AT=295.025n

.meas tran vdout0_17ck580 FIND v(dout0_17) AT=295.025n

.meas tran vdout0_18ck580 FIND v(dout0_18) AT=295.025n

.meas tran vdout0_19ck580 FIND v(dout0_19) AT=295.025n

.meas tran vdout0_20ck580 FIND v(dout0_20) AT=295.025n

.meas tran vdout0_0ck590 FIND v(dout0_0) AT=300.025n

.meas tran vdout0_1ck590 FIND v(dout0_1) AT=300.025n

.meas tran vdout0_2ck590 FIND v(dout0_2) AT=300.025n

.meas tran vdout0_3ck590 FIND v(dout0_3) AT=300.025n

.meas tran vdout0_4ck590 FIND v(dout0_4) AT=300.025n

.meas tran vdout0_5ck590 FIND v(dout0_5) AT=300.025n

.meas tran vdout0_6ck590 FIND v(dout0_6) AT=300.025n

.meas tran vdout0_7ck590 FIND v(dout0_7) AT=300.025n

.meas tran vdout0_8ck590 FIND v(dout0_8) AT=300.025n

.meas tran vdout0_9ck590 FIND v(dout0_9) AT=300.025n

.meas tran vdout0_10ck590 FIND v(dout0_10) AT=300.025n

.meas tran vdout0_11ck590 FIND v(dout0_11) AT=300.025n

.meas tran vdout0_12ck590 FIND v(dout0_12) AT=300.025n

.meas tran vdout0_13ck590 FIND v(dout0_13) AT=300.025n

.meas tran vdout0_14ck590 FIND v(dout0_14) AT=300.025n

.meas tran vdout0_15ck590 FIND v(dout0_15) AT=300.025n

.meas tran vdout0_16ck590 FIND v(dout0_16) AT=300.025n

.meas tran vdout0_17ck590 FIND v(dout0_17) AT=300.025n

.meas tran vdout0_18ck590 FIND v(dout0_18) AT=300.025n

.meas tran vdout0_19ck590 FIND v(dout0_19) AT=300.025n

.meas tran vdout0_20ck590 FIND v(dout0_20) AT=300.025n

.meas tran vdout0_0ck600 FIND v(dout0_0) AT=305.025n

.meas tran vdout0_1ck600 FIND v(dout0_1) AT=305.025n

.meas tran vdout0_2ck600 FIND v(dout0_2) AT=305.025n

.meas tran vdout0_3ck600 FIND v(dout0_3) AT=305.025n

.meas tran vdout0_4ck600 FIND v(dout0_4) AT=305.025n

.meas tran vdout0_5ck600 FIND v(dout0_5) AT=305.025n

.meas tran vdout0_6ck600 FIND v(dout0_6) AT=305.025n

.meas tran vdout0_7ck600 FIND v(dout0_7) AT=305.025n

.meas tran vdout0_8ck600 FIND v(dout0_8) AT=305.025n

.meas tran vdout0_9ck600 FIND v(dout0_9) AT=305.025n

.meas tran vdout0_10ck600 FIND v(dout0_10) AT=305.025n

.meas tran vdout0_11ck600 FIND v(dout0_11) AT=305.025n

.meas tran vdout0_12ck600 FIND v(dout0_12) AT=305.025n

.meas tran vdout0_13ck600 FIND v(dout0_13) AT=305.025n

.meas tran vdout0_14ck600 FIND v(dout0_14) AT=305.025n

.meas tran vdout0_15ck600 FIND v(dout0_15) AT=305.025n

.meas tran vdout0_16ck600 FIND v(dout0_16) AT=305.025n

.meas tran vdout0_17ck600 FIND v(dout0_17) AT=305.025n

.meas tran vdout0_18ck600 FIND v(dout0_18) AT=305.025n

.meas tran vdout0_19ck600 FIND v(dout0_19) AT=305.025n

.meas tran vdout0_20ck600 FIND v(dout0_20) AT=305.025n

.meas tran vdout0_0ck610 FIND v(dout0_0) AT=310.025n

.meas tran vdout0_1ck610 FIND v(dout0_1) AT=310.025n

.meas tran vdout0_2ck610 FIND v(dout0_2) AT=310.025n

.meas tran vdout0_3ck610 FIND v(dout0_3) AT=310.025n

.meas tran vdout0_4ck610 FIND v(dout0_4) AT=310.025n

.meas tran vdout0_5ck610 FIND v(dout0_5) AT=310.025n

.meas tran vdout0_6ck610 FIND v(dout0_6) AT=310.025n

.meas tran vdout0_7ck610 FIND v(dout0_7) AT=310.025n

.meas tran vdout0_8ck610 FIND v(dout0_8) AT=310.025n

.meas tran vdout0_9ck610 FIND v(dout0_9) AT=310.025n

.meas tran vdout0_10ck610 FIND v(dout0_10) AT=310.025n

.meas tran vdout0_11ck610 FIND v(dout0_11) AT=310.025n

.meas tran vdout0_12ck610 FIND v(dout0_12) AT=310.025n

.meas tran vdout0_13ck610 FIND v(dout0_13) AT=310.025n

.meas tran vdout0_14ck610 FIND v(dout0_14) AT=310.025n

.meas tran vdout0_15ck610 FIND v(dout0_15) AT=310.025n

.meas tran vdout0_16ck610 FIND v(dout0_16) AT=310.025n

.meas tran vdout0_17ck610 FIND v(dout0_17) AT=310.025n

.meas tran vdout0_18ck610 FIND v(dout0_18) AT=310.025n

.meas tran vdout0_19ck610 FIND v(dout0_19) AT=310.025n

.meas tran vdout0_20ck610 FIND v(dout0_20) AT=310.025n

.meas tran vdout0_0ck630 FIND v(dout0_0) AT=320.025n

.meas tran vdout0_1ck630 FIND v(dout0_1) AT=320.025n

.meas tran vdout0_2ck630 FIND v(dout0_2) AT=320.025n

.meas tran vdout0_3ck630 FIND v(dout0_3) AT=320.025n

.meas tran vdout0_4ck630 FIND v(dout0_4) AT=320.025n

.meas tran vdout0_5ck630 FIND v(dout0_5) AT=320.025n

.meas tran vdout0_6ck630 FIND v(dout0_6) AT=320.025n

.meas tran vdout0_7ck630 FIND v(dout0_7) AT=320.025n

.meas tran vdout0_8ck630 FIND v(dout0_8) AT=320.025n

.meas tran vdout0_9ck630 FIND v(dout0_9) AT=320.025n

.meas tran vdout0_10ck630 FIND v(dout0_10) AT=320.025n

.meas tran vdout0_11ck630 FIND v(dout0_11) AT=320.025n

.meas tran vdout0_12ck630 FIND v(dout0_12) AT=320.025n

.meas tran vdout0_13ck630 FIND v(dout0_13) AT=320.025n

.meas tran vdout0_14ck630 FIND v(dout0_14) AT=320.025n

.meas tran vdout0_15ck630 FIND v(dout0_15) AT=320.025n

.meas tran vdout0_16ck630 FIND v(dout0_16) AT=320.025n

.meas tran vdout0_17ck630 FIND v(dout0_17) AT=320.025n

.meas tran vdout0_18ck630 FIND v(dout0_18) AT=320.025n

.meas tran vdout0_19ck630 FIND v(dout0_19) AT=320.025n

.meas tran vdout0_20ck630 FIND v(dout0_20) AT=320.025n

.meas tran vdout0_0ck690 FIND v(dout0_0) AT=350.025n

.meas tran vdout0_1ck690 FIND v(dout0_1) AT=350.025n

.meas tran vdout0_2ck690 FIND v(dout0_2) AT=350.025n

.meas tran vdout0_3ck690 FIND v(dout0_3) AT=350.025n

.meas tran vdout0_4ck690 FIND v(dout0_4) AT=350.025n

.meas tran vdout0_5ck690 FIND v(dout0_5) AT=350.025n

.meas tran vdout0_6ck690 FIND v(dout0_6) AT=350.025n

.meas tran vdout0_7ck690 FIND v(dout0_7) AT=350.025n

.meas tran vdout0_8ck690 FIND v(dout0_8) AT=350.025n

.meas tran vdout0_9ck690 FIND v(dout0_9) AT=350.025n

.meas tran vdout0_10ck690 FIND v(dout0_10) AT=350.025n

.meas tran vdout0_11ck690 FIND v(dout0_11) AT=350.025n

.meas tran vdout0_12ck690 FIND v(dout0_12) AT=350.025n

.meas tran vdout0_13ck690 FIND v(dout0_13) AT=350.025n

.meas tran vdout0_14ck690 FIND v(dout0_14) AT=350.025n

.meas tran vdout0_15ck690 FIND v(dout0_15) AT=350.025n

.meas tran vdout0_16ck690 FIND v(dout0_16) AT=350.025n

.meas tran vdout0_17ck690 FIND v(dout0_17) AT=350.025n

.meas tran vdout0_18ck690 FIND v(dout0_18) AT=350.025n

.meas tran vdout0_19ck690 FIND v(dout0_19) AT=350.025n

.meas tran vdout0_20ck690 FIND v(dout0_20) AT=350.025n

.meas tran vdout0_0ck720 FIND v(dout0_0) AT=365.025n

.meas tran vdout0_1ck720 FIND v(dout0_1) AT=365.025n

.meas tran vdout0_2ck720 FIND v(dout0_2) AT=365.025n

.meas tran vdout0_3ck720 FIND v(dout0_3) AT=365.025n

.meas tran vdout0_4ck720 FIND v(dout0_4) AT=365.025n

.meas tran vdout0_5ck720 FIND v(dout0_5) AT=365.025n

.meas tran vdout0_6ck720 FIND v(dout0_6) AT=365.025n

.meas tran vdout0_7ck720 FIND v(dout0_7) AT=365.025n

.meas tran vdout0_8ck720 FIND v(dout0_8) AT=365.025n

.meas tran vdout0_9ck720 FIND v(dout0_9) AT=365.025n

.meas tran vdout0_10ck720 FIND v(dout0_10) AT=365.025n

.meas tran vdout0_11ck720 FIND v(dout0_11) AT=365.025n

.meas tran vdout0_12ck720 FIND v(dout0_12) AT=365.025n

.meas tran vdout0_13ck720 FIND v(dout0_13) AT=365.025n

.meas tran vdout0_14ck720 FIND v(dout0_14) AT=365.025n

.meas tran vdout0_15ck720 FIND v(dout0_15) AT=365.025n

.meas tran vdout0_16ck720 FIND v(dout0_16) AT=365.025n

.meas tran vdout0_17ck720 FIND v(dout0_17) AT=365.025n

.meas tran vdout0_18ck720 FIND v(dout0_18) AT=365.025n

.meas tran vdout0_19ck720 FIND v(dout0_19) AT=365.025n

.meas tran vdout0_20ck720 FIND v(dout0_20) AT=365.025n

.meas tran vdout0_0ck770 FIND v(dout0_0) AT=390.025n

.meas tran vdout0_1ck770 FIND v(dout0_1) AT=390.025n

.meas tran vdout0_2ck770 FIND v(dout0_2) AT=390.025n

.meas tran vdout0_3ck770 FIND v(dout0_3) AT=390.025n

.meas tran vdout0_4ck770 FIND v(dout0_4) AT=390.025n

.meas tran vdout0_5ck770 FIND v(dout0_5) AT=390.025n

.meas tran vdout0_6ck770 FIND v(dout0_6) AT=390.025n

.meas tran vdout0_7ck770 FIND v(dout0_7) AT=390.025n

.meas tran vdout0_8ck770 FIND v(dout0_8) AT=390.025n

.meas tran vdout0_9ck770 FIND v(dout0_9) AT=390.025n

.meas tran vdout0_10ck770 FIND v(dout0_10) AT=390.025n

.meas tran vdout0_11ck770 FIND v(dout0_11) AT=390.025n

.meas tran vdout0_12ck770 FIND v(dout0_12) AT=390.025n

.meas tran vdout0_13ck770 FIND v(dout0_13) AT=390.025n

.meas tran vdout0_14ck770 FIND v(dout0_14) AT=390.025n

.meas tran vdout0_15ck770 FIND v(dout0_15) AT=390.025n

.meas tran vdout0_16ck770 FIND v(dout0_16) AT=390.025n

.meas tran vdout0_17ck770 FIND v(dout0_17) AT=390.025n

.meas tran vdout0_18ck770 FIND v(dout0_18) AT=390.025n

.meas tran vdout0_19ck770 FIND v(dout0_19) AT=390.025n

.meas tran vdout0_20ck770 FIND v(dout0_20) AT=390.025n

.meas tran vdout0_0ck790 FIND v(dout0_0) AT=400.025n

.meas tran vdout0_1ck790 FIND v(dout0_1) AT=400.025n

.meas tran vdout0_2ck790 FIND v(dout0_2) AT=400.025n

.meas tran vdout0_3ck790 FIND v(dout0_3) AT=400.025n

.meas tran vdout0_4ck790 FIND v(dout0_4) AT=400.025n

.meas tran vdout0_5ck790 FIND v(dout0_5) AT=400.025n

.meas tran vdout0_6ck790 FIND v(dout0_6) AT=400.025n

.meas tran vdout0_7ck790 FIND v(dout0_7) AT=400.025n

.meas tran vdout0_8ck790 FIND v(dout0_8) AT=400.025n

.meas tran vdout0_9ck790 FIND v(dout0_9) AT=400.025n

.meas tran vdout0_10ck790 FIND v(dout0_10) AT=400.025n

.meas tran vdout0_11ck790 FIND v(dout0_11) AT=400.025n

.meas tran vdout0_12ck790 FIND v(dout0_12) AT=400.025n

.meas tran vdout0_13ck790 FIND v(dout0_13) AT=400.025n

.meas tran vdout0_14ck790 FIND v(dout0_14) AT=400.025n

.meas tran vdout0_15ck790 FIND v(dout0_15) AT=400.025n

.meas tran vdout0_16ck790 FIND v(dout0_16) AT=400.025n

.meas tran vdout0_17ck790 FIND v(dout0_17) AT=400.025n

.meas tran vdout0_18ck790 FIND v(dout0_18) AT=400.025n

.meas tran vdout0_19ck790 FIND v(dout0_19) AT=400.025n

.meas tran vdout0_20ck790 FIND v(dout0_20) AT=400.025n

.meas tran vdout0_0ck800 FIND v(dout0_0) AT=405.025n

.meas tran vdout0_1ck800 FIND v(dout0_1) AT=405.025n

.meas tran vdout0_2ck800 FIND v(dout0_2) AT=405.025n

.meas tran vdout0_3ck800 FIND v(dout0_3) AT=405.025n

.meas tran vdout0_4ck800 FIND v(dout0_4) AT=405.025n

.meas tran vdout0_5ck800 FIND v(dout0_5) AT=405.025n

.meas tran vdout0_6ck800 FIND v(dout0_6) AT=405.025n

.meas tran vdout0_7ck800 FIND v(dout0_7) AT=405.025n

.meas tran vdout0_8ck800 FIND v(dout0_8) AT=405.025n

.meas tran vdout0_9ck800 FIND v(dout0_9) AT=405.025n

.meas tran vdout0_10ck800 FIND v(dout0_10) AT=405.025n

.meas tran vdout0_11ck800 FIND v(dout0_11) AT=405.025n

.meas tran vdout0_12ck800 FIND v(dout0_12) AT=405.025n

.meas tran vdout0_13ck800 FIND v(dout0_13) AT=405.025n

.meas tran vdout0_14ck800 FIND v(dout0_14) AT=405.025n

.meas tran vdout0_15ck800 FIND v(dout0_15) AT=405.025n

.meas tran vdout0_16ck800 FIND v(dout0_16) AT=405.025n

.meas tran vdout0_17ck800 FIND v(dout0_17) AT=405.025n

.meas tran vdout0_18ck800 FIND v(dout0_18) AT=405.025n

.meas tran vdout0_19ck800 FIND v(dout0_19) AT=405.025n

.meas tran vdout0_20ck800 FIND v(dout0_20) AT=405.025n

.meas tran vdout0_0ck840 FIND v(dout0_0) AT=425.025n

.meas tran vdout0_1ck840 FIND v(dout0_1) AT=425.025n

.meas tran vdout0_2ck840 FIND v(dout0_2) AT=425.025n

.meas tran vdout0_3ck840 FIND v(dout0_3) AT=425.025n

.meas tran vdout0_4ck840 FIND v(dout0_4) AT=425.025n

.meas tran vdout0_5ck840 FIND v(dout0_5) AT=425.025n

.meas tran vdout0_6ck840 FIND v(dout0_6) AT=425.025n

.meas tran vdout0_7ck840 FIND v(dout0_7) AT=425.025n

.meas tran vdout0_8ck840 FIND v(dout0_8) AT=425.025n

.meas tran vdout0_9ck840 FIND v(dout0_9) AT=425.025n

.meas tran vdout0_10ck840 FIND v(dout0_10) AT=425.025n

.meas tran vdout0_11ck840 FIND v(dout0_11) AT=425.025n

.meas tran vdout0_12ck840 FIND v(dout0_12) AT=425.025n

.meas tran vdout0_13ck840 FIND v(dout0_13) AT=425.025n

.meas tran vdout0_14ck840 FIND v(dout0_14) AT=425.025n

.meas tran vdout0_15ck840 FIND v(dout0_15) AT=425.025n

.meas tran vdout0_16ck840 FIND v(dout0_16) AT=425.025n

.meas tran vdout0_17ck840 FIND v(dout0_17) AT=425.025n

.meas tran vdout0_18ck840 FIND v(dout0_18) AT=425.025n

.meas tran vdout0_19ck840 FIND v(dout0_19) AT=425.025n

.meas tran vdout0_20ck840 FIND v(dout0_20) AT=425.025n

.meas tran vdout0_0ck850 FIND v(dout0_0) AT=430.025n

.meas tran vdout0_1ck850 FIND v(dout0_1) AT=430.025n

.meas tran vdout0_2ck850 FIND v(dout0_2) AT=430.025n

.meas tran vdout0_3ck850 FIND v(dout0_3) AT=430.025n

.meas tran vdout0_4ck850 FIND v(dout0_4) AT=430.025n

.meas tran vdout0_5ck850 FIND v(dout0_5) AT=430.025n

.meas tran vdout0_6ck850 FIND v(dout0_6) AT=430.025n

.meas tran vdout0_7ck850 FIND v(dout0_7) AT=430.025n

.meas tran vdout0_8ck850 FIND v(dout0_8) AT=430.025n

.meas tran vdout0_9ck850 FIND v(dout0_9) AT=430.025n

.meas tran vdout0_10ck850 FIND v(dout0_10) AT=430.025n

.meas tran vdout0_11ck850 FIND v(dout0_11) AT=430.025n

.meas tran vdout0_12ck850 FIND v(dout0_12) AT=430.025n

.meas tran vdout0_13ck850 FIND v(dout0_13) AT=430.025n

.meas tran vdout0_14ck850 FIND v(dout0_14) AT=430.025n

.meas tran vdout0_15ck850 FIND v(dout0_15) AT=430.025n

.meas tran vdout0_16ck850 FIND v(dout0_16) AT=430.025n

.meas tran vdout0_17ck850 FIND v(dout0_17) AT=430.025n

.meas tran vdout0_18ck850 FIND v(dout0_18) AT=430.025n

.meas tran vdout0_19ck850 FIND v(dout0_19) AT=430.025n

.meas tran vdout0_20ck850 FIND v(dout0_20) AT=430.025n

.meas tran vdout0_0ck870 FIND v(dout0_0) AT=440.025n

.meas tran vdout0_1ck870 FIND v(dout0_1) AT=440.025n

.meas tran vdout0_2ck870 FIND v(dout0_2) AT=440.025n

.meas tran vdout0_3ck870 FIND v(dout0_3) AT=440.025n

.meas tran vdout0_4ck870 FIND v(dout0_4) AT=440.025n

.meas tran vdout0_5ck870 FIND v(dout0_5) AT=440.025n

.meas tran vdout0_6ck870 FIND v(dout0_6) AT=440.025n

.meas tran vdout0_7ck870 FIND v(dout0_7) AT=440.025n

.meas tran vdout0_8ck870 FIND v(dout0_8) AT=440.025n

.meas tran vdout0_9ck870 FIND v(dout0_9) AT=440.025n

.meas tran vdout0_10ck870 FIND v(dout0_10) AT=440.025n

.meas tran vdout0_11ck870 FIND v(dout0_11) AT=440.025n

.meas tran vdout0_12ck870 FIND v(dout0_12) AT=440.025n

.meas tran vdout0_13ck870 FIND v(dout0_13) AT=440.025n

.meas tran vdout0_14ck870 FIND v(dout0_14) AT=440.025n

.meas tran vdout0_15ck870 FIND v(dout0_15) AT=440.025n

.meas tran vdout0_16ck870 FIND v(dout0_16) AT=440.025n

.meas tran vdout0_17ck870 FIND v(dout0_17) AT=440.025n

.meas tran vdout0_18ck870 FIND v(dout0_18) AT=440.025n

.meas tran vdout0_19ck870 FIND v(dout0_19) AT=440.025n

.meas tran vdout0_20ck870 FIND v(dout0_20) AT=440.025n

.meas tran vdout0_0ck920 FIND v(dout0_0) AT=465.025n

.meas tran vdout0_1ck920 FIND v(dout0_1) AT=465.025n

.meas tran vdout0_2ck920 FIND v(dout0_2) AT=465.025n

.meas tran vdout0_3ck920 FIND v(dout0_3) AT=465.025n

.meas tran vdout0_4ck920 FIND v(dout0_4) AT=465.025n

.meas tran vdout0_5ck920 FIND v(dout0_5) AT=465.025n

.meas tran vdout0_6ck920 FIND v(dout0_6) AT=465.025n

.meas tran vdout0_7ck920 FIND v(dout0_7) AT=465.025n

.meas tran vdout0_8ck920 FIND v(dout0_8) AT=465.025n

.meas tran vdout0_9ck920 FIND v(dout0_9) AT=465.025n

.meas tran vdout0_10ck920 FIND v(dout0_10) AT=465.025n

.meas tran vdout0_11ck920 FIND v(dout0_11) AT=465.025n

.meas tran vdout0_12ck920 FIND v(dout0_12) AT=465.025n

.meas tran vdout0_13ck920 FIND v(dout0_13) AT=465.025n

.meas tran vdout0_14ck920 FIND v(dout0_14) AT=465.025n

.meas tran vdout0_15ck920 FIND v(dout0_15) AT=465.025n

.meas tran vdout0_16ck920 FIND v(dout0_16) AT=465.025n

.meas tran vdout0_17ck920 FIND v(dout0_17) AT=465.025n

.meas tran vdout0_18ck920 FIND v(dout0_18) AT=465.025n

.meas tran vdout0_19ck920 FIND v(dout0_19) AT=465.025n

.meas tran vdout0_20ck920 FIND v(dout0_20) AT=465.025n

.meas tran vdout0_0ck930 FIND v(dout0_0) AT=470.025n

.meas tran vdout0_1ck930 FIND v(dout0_1) AT=470.025n

.meas tran vdout0_2ck930 FIND v(dout0_2) AT=470.025n

.meas tran vdout0_3ck930 FIND v(dout0_3) AT=470.025n

.meas tran vdout0_4ck930 FIND v(dout0_4) AT=470.025n

.meas tran vdout0_5ck930 FIND v(dout0_5) AT=470.025n

.meas tran vdout0_6ck930 FIND v(dout0_6) AT=470.025n

.meas tran vdout0_7ck930 FIND v(dout0_7) AT=470.025n

.meas tran vdout0_8ck930 FIND v(dout0_8) AT=470.025n

.meas tran vdout0_9ck930 FIND v(dout0_9) AT=470.025n

.meas tran vdout0_10ck930 FIND v(dout0_10) AT=470.025n

.meas tran vdout0_11ck930 FIND v(dout0_11) AT=470.025n

.meas tran vdout0_12ck930 FIND v(dout0_12) AT=470.025n

.meas tran vdout0_13ck930 FIND v(dout0_13) AT=470.025n

.meas tran vdout0_14ck930 FIND v(dout0_14) AT=470.025n

.meas tran vdout0_15ck930 FIND v(dout0_15) AT=470.025n

.meas tran vdout0_16ck930 FIND v(dout0_16) AT=470.025n

.meas tran vdout0_17ck930 FIND v(dout0_17) AT=470.025n

.meas tran vdout0_18ck930 FIND v(dout0_18) AT=470.025n

.meas tran vdout0_19ck930 FIND v(dout0_19) AT=470.025n

.meas tran vdout0_20ck930 FIND v(dout0_20) AT=470.025n

.meas tran vdout0_0ck960 FIND v(dout0_0) AT=485.025n

.meas tran vdout0_1ck960 FIND v(dout0_1) AT=485.025n

.meas tran vdout0_2ck960 FIND v(dout0_2) AT=485.025n

.meas tran vdout0_3ck960 FIND v(dout0_3) AT=485.025n

.meas tran vdout0_4ck960 FIND v(dout0_4) AT=485.025n

.meas tran vdout0_5ck960 FIND v(dout0_5) AT=485.025n

.meas tran vdout0_6ck960 FIND v(dout0_6) AT=485.025n

.meas tran vdout0_7ck960 FIND v(dout0_7) AT=485.025n

.meas tran vdout0_8ck960 FIND v(dout0_8) AT=485.025n

.meas tran vdout0_9ck960 FIND v(dout0_9) AT=485.025n

.meas tran vdout0_10ck960 FIND v(dout0_10) AT=485.025n

.meas tran vdout0_11ck960 FIND v(dout0_11) AT=485.025n

.meas tran vdout0_12ck960 FIND v(dout0_12) AT=485.025n

.meas tran vdout0_13ck960 FIND v(dout0_13) AT=485.025n

.meas tran vdout0_14ck960 FIND v(dout0_14) AT=485.025n

.meas tran vdout0_15ck960 FIND v(dout0_15) AT=485.025n

.meas tran vdout0_16ck960 FIND v(dout0_16) AT=485.025n

.meas tran vdout0_17ck960 FIND v(dout0_17) AT=485.025n

.meas tran vdout0_18ck960 FIND v(dout0_18) AT=485.025n

.meas tran vdout0_19ck960 FIND v(dout0_19) AT=485.025n

.meas tran vdout0_20ck960 FIND v(dout0_20) AT=485.025n

.meas tran vdout0_0ck990 FIND v(dout0_0) AT=500.025n

.meas tran vdout0_1ck990 FIND v(dout0_1) AT=500.025n

.meas tran vdout0_2ck990 FIND v(dout0_2) AT=500.025n

.meas tran vdout0_3ck990 FIND v(dout0_3) AT=500.025n

.meas tran vdout0_4ck990 FIND v(dout0_4) AT=500.025n

.meas tran vdout0_5ck990 FIND v(dout0_5) AT=500.025n

.meas tran vdout0_6ck990 FIND v(dout0_6) AT=500.025n

.meas tran vdout0_7ck990 FIND v(dout0_7) AT=500.025n

.meas tran vdout0_8ck990 FIND v(dout0_8) AT=500.025n

.meas tran vdout0_9ck990 FIND v(dout0_9) AT=500.025n

.meas tran vdout0_10ck990 FIND v(dout0_10) AT=500.025n

.meas tran vdout0_11ck990 FIND v(dout0_11) AT=500.025n

.meas tran vdout0_12ck990 FIND v(dout0_12) AT=500.025n

.meas tran vdout0_13ck990 FIND v(dout0_13) AT=500.025n

.meas tran vdout0_14ck990 FIND v(dout0_14) AT=500.025n

.meas tran vdout0_15ck990 FIND v(dout0_15) AT=500.025n

.meas tran vdout0_16ck990 FIND v(dout0_16) AT=500.025n

.meas tran vdout0_17ck990 FIND v(dout0_17) AT=500.025n

.meas tran vdout0_18ck990 FIND v(dout0_18) AT=500.025n

.meas tran vdout0_19ck990 FIND v(dout0_19) AT=500.025n

.meas tran vdout0_20ck990 FIND v(dout0_20) AT=500.025n

.meas tran vdout0_0ck1000 FIND v(dout0_0) AT=505.025n

.meas tran vdout0_1ck1000 FIND v(dout0_1) AT=505.025n

.meas tran vdout0_2ck1000 FIND v(dout0_2) AT=505.025n

.meas tran vdout0_3ck1000 FIND v(dout0_3) AT=505.025n

.meas tran vdout0_4ck1000 FIND v(dout0_4) AT=505.025n

.meas tran vdout0_5ck1000 FIND v(dout0_5) AT=505.025n

.meas tran vdout0_6ck1000 FIND v(dout0_6) AT=505.025n

.meas tran vdout0_7ck1000 FIND v(dout0_7) AT=505.025n

.meas tran vdout0_8ck1000 FIND v(dout0_8) AT=505.025n

.meas tran vdout0_9ck1000 FIND v(dout0_9) AT=505.025n

.meas tran vdout0_10ck1000 FIND v(dout0_10) AT=505.025n

.meas tran vdout0_11ck1000 FIND v(dout0_11) AT=505.025n

.meas tran vdout0_12ck1000 FIND v(dout0_12) AT=505.025n

.meas tran vdout0_13ck1000 FIND v(dout0_13) AT=505.025n

.meas tran vdout0_14ck1000 FIND v(dout0_14) AT=505.025n

.meas tran vdout0_15ck1000 FIND v(dout0_15) AT=505.025n

.meas tran vdout0_16ck1000 FIND v(dout0_16) AT=505.025n

.meas tran vdout0_17ck1000 FIND v(dout0_17) AT=505.025n

.meas tran vdout0_18ck1000 FIND v(dout0_18) AT=505.025n

.meas tran vdout0_19ck1000 FIND v(dout0_19) AT=505.025n

.meas tran vdout0_20ck1000 FIND v(dout0_20) AT=505.025n

.meas tran vdout0_0ck1010 FIND v(dout0_0) AT=510.025n

.meas tran vdout0_1ck1010 FIND v(dout0_1) AT=510.025n

.meas tran vdout0_2ck1010 FIND v(dout0_2) AT=510.025n

.meas tran vdout0_3ck1010 FIND v(dout0_3) AT=510.025n

.meas tran vdout0_4ck1010 FIND v(dout0_4) AT=510.025n

.meas tran vdout0_5ck1010 FIND v(dout0_5) AT=510.025n

.meas tran vdout0_6ck1010 FIND v(dout0_6) AT=510.025n

.meas tran vdout0_7ck1010 FIND v(dout0_7) AT=510.025n

.meas tran vdout0_8ck1010 FIND v(dout0_8) AT=510.025n

.meas tran vdout0_9ck1010 FIND v(dout0_9) AT=510.025n

.meas tran vdout0_10ck1010 FIND v(dout0_10) AT=510.025n

.meas tran vdout0_11ck1010 FIND v(dout0_11) AT=510.025n

.meas tran vdout0_12ck1010 FIND v(dout0_12) AT=510.025n

.meas tran vdout0_13ck1010 FIND v(dout0_13) AT=510.025n

.meas tran vdout0_14ck1010 FIND v(dout0_14) AT=510.025n

.meas tran vdout0_15ck1010 FIND v(dout0_15) AT=510.025n

.meas tran vdout0_16ck1010 FIND v(dout0_16) AT=510.025n

.meas tran vdout0_17ck1010 FIND v(dout0_17) AT=510.025n

.meas tran vdout0_18ck1010 FIND v(dout0_18) AT=510.025n

.meas tran vdout0_19ck1010 FIND v(dout0_19) AT=510.025n

.meas tran vdout0_20ck1010 FIND v(dout0_20) AT=510.025n

.meas tran vdout0_0ck1030 FIND v(dout0_0) AT=520.025n

.meas tran vdout0_1ck1030 FIND v(dout0_1) AT=520.025n

.meas tran vdout0_2ck1030 FIND v(dout0_2) AT=520.025n

.meas tran vdout0_3ck1030 FIND v(dout0_3) AT=520.025n

.meas tran vdout0_4ck1030 FIND v(dout0_4) AT=520.025n

.meas tran vdout0_5ck1030 FIND v(dout0_5) AT=520.025n

.meas tran vdout0_6ck1030 FIND v(dout0_6) AT=520.025n

.meas tran vdout0_7ck1030 FIND v(dout0_7) AT=520.025n

.meas tran vdout0_8ck1030 FIND v(dout0_8) AT=520.025n

.meas tran vdout0_9ck1030 FIND v(dout0_9) AT=520.025n

.meas tran vdout0_10ck1030 FIND v(dout0_10) AT=520.025n

.meas tran vdout0_11ck1030 FIND v(dout0_11) AT=520.025n

.meas tran vdout0_12ck1030 FIND v(dout0_12) AT=520.025n

.meas tran vdout0_13ck1030 FIND v(dout0_13) AT=520.025n

.meas tran vdout0_14ck1030 FIND v(dout0_14) AT=520.025n

.meas tran vdout0_15ck1030 FIND v(dout0_15) AT=520.025n

.meas tran vdout0_16ck1030 FIND v(dout0_16) AT=520.025n

.meas tran vdout0_17ck1030 FIND v(dout0_17) AT=520.025n

.meas tran vdout0_18ck1030 FIND v(dout0_18) AT=520.025n

.meas tran vdout0_19ck1030 FIND v(dout0_19) AT=520.025n

.meas tran vdout0_20ck1030 FIND v(dout0_20) AT=520.025n

.meas tran vdout0_0ck1050 FIND v(dout0_0) AT=530.025n

.meas tran vdout0_1ck1050 FIND v(dout0_1) AT=530.025n

.meas tran vdout0_2ck1050 FIND v(dout0_2) AT=530.025n

.meas tran vdout0_3ck1050 FIND v(dout0_3) AT=530.025n

.meas tran vdout0_4ck1050 FIND v(dout0_4) AT=530.025n

.meas tran vdout0_5ck1050 FIND v(dout0_5) AT=530.025n

.meas tran vdout0_6ck1050 FIND v(dout0_6) AT=530.025n

.meas tran vdout0_7ck1050 FIND v(dout0_7) AT=530.025n

.meas tran vdout0_8ck1050 FIND v(dout0_8) AT=530.025n

.meas tran vdout0_9ck1050 FIND v(dout0_9) AT=530.025n

.meas tran vdout0_10ck1050 FIND v(dout0_10) AT=530.025n

.meas tran vdout0_11ck1050 FIND v(dout0_11) AT=530.025n

.meas tran vdout0_12ck1050 FIND v(dout0_12) AT=530.025n

.meas tran vdout0_13ck1050 FIND v(dout0_13) AT=530.025n

.meas tran vdout0_14ck1050 FIND v(dout0_14) AT=530.025n

.meas tran vdout0_15ck1050 FIND v(dout0_15) AT=530.025n

.meas tran vdout0_16ck1050 FIND v(dout0_16) AT=530.025n

.meas tran vdout0_17ck1050 FIND v(dout0_17) AT=530.025n

.meas tran vdout0_18ck1050 FIND v(dout0_18) AT=530.025n

.meas tran vdout0_19ck1050 FIND v(dout0_19) AT=530.025n

.meas tran vdout0_20ck1050 FIND v(dout0_20) AT=530.025n

.meas tran vdout0_0ck1060 FIND v(dout0_0) AT=535.025n

.meas tran vdout0_1ck1060 FIND v(dout0_1) AT=535.025n

.meas tran vdout0_2ck1060 FIND v(dout0_2) AT=535.025n

.meas tran vdout0_3ck1060 FIND v(dout0_3) AT=535.025n

.meas tran vdout0_4ck1060 FIND v(dout0_4) AT=535.025n

.meas tran vdout0_5ck1060 FIND v(dout0_5) AT=535.025n

.meas tran vdout0_6ck1060 FIND v(dout0_6) AT=535.025n

.meas tran vdout0_7ck1060 FIND v(dout0_7) AT=535.025n

.meas tran vdout0_8ck1060 FIND v(dout0_8) AT=535.025n

.meas tran vdout0_9ck1060 FIND v(dout0_9) AT=535.025n

.meas tran vdout0_10ck1060 FIND v(dout0_10) AT=535.025n

.meas tran vdout0_11ck1060 FIND v(dout0_11) AT=535.025n

.meas tran vdout0_12ck1060 FIND v(dout0_12) AT=535.025n

.meas tran vdout0_13ck1060 FIND v(dout0_13) AT=535.025n

.meas tran vdout0_14ck1060 FIND v(dout0_14) AT=535.025n

.meas tran vdout0_15ck1060 FIND v(dout0_15) AT=535.025n

.meas tran vdout0_16ck1060 FIND v(dout0_16) AT=535.025n

.meas tran vdout0_17ck1060 FIND v(dout0_17) AT=535.025n

.meas tran vdout0_18ck1060 FIND v(dout0_18) AT=535.025n

.meas tran vdout0_19ck1060 FIND v(dout0_19) AT=535.025n

.meas tran vdout0_20ck1060 FIND v(dout0_20) AT=535.025n

.meas tran vdout0_0ck1070 FIND v(dout0_0) AT=540.025n

.meas tran vdout0_1ck1070 FIND v(dout0_1) AT=540.025n

.meas tran vdout0_2ck1070 FIND v(dout0_2) AT=540.025n

.meas tran vdout0_3ck1070 FIND v(dout0_3) AT=540.025n

.meas tran vdout0_4ck1070 FIND v(dout0_4) AT=540.025n

.meas tran vdout0_5ck1070 FIND v(dout0_5) AT=540.025n

.meas tran vdout0_6ck1070 FIND v(dout0_6) AT=540.025n

.meas tran vdout0_7ck1070 FIND v(dout0_7) AT=540.025n

.meas tran vdout0_8ck1070 FIND v(dout0_8) AT=540.025n

.meas tran vdout0_9ck1070 FIND v(dout0_9) AT=540.025n

.meas tran vdout0_10ck1070 FIND v(dout0_10) AT=540.025n

.meas tran vdout0_11ck1070 FIND v(dout0_11) AT=540.025n

.meas tran vdout0_12ck1070 FIND v(dout0_12) AT=540.025n

.meas tran vdout0_13ck1070 FIND v(dout0_13) AT=540.025n

.meas tran vdout0_14ck1070 FIND v(dout0_14) AT=540.025n

.meas tran vdout0_15ck1070 FIND v(dout0_15) AT=540.025n

.meas tran vdout0_16ck1070 FIND v(dout0_16) AT=540.025n

.meas tran vdout0_17ck1070 FIND v(dout0_17) AT=540.025n

.meas tran vdout0_18ck1070 FIND v(dout0_18) AT=540.025n

.meas tran vdout0_19ck1070 FIND v(dout0_19) AT=540.025n

.meas tran vdout0_20ck1070 FIND v(dout0_20) AT=540.025n

.meas tran vdout0_0ck1080 FIND v(dout0_0) AT=545.025n

.meas tran vdout0_1ck1080 FIND v(dout0_1) AT=545.025n

.meas tran vdout0_2ck1080 FIND v(dout0_2) AT=545.025n

.meas tran vdout0_3ck1080 FIND v(dout0_3) AT=545.025n

.meas tran vdout0_4ck1080 FIND v(dout0_4) AT=545.025n

.meas tran vdout0_5ck1080 FIND v(dout0_5) AT=545.025n

.meas tran vdout0_6ck1080 FIND v(dout0_6) AT=545.025n

.meas tran vdout0_7ck1080 FIND v(dout0_7) AT=545.025n

.meas tran vdout0_8ck1080 FIND v(dout0_8) AT=545.025n

.meas tran vdout0_9ck1080 FIND v(dout0_9) AT=545.025n

.meas tran vdout0_10ck1080 FIND v(dout0_10) AT=545.025n

.meas tran vdout0_11ck1080 FIND v(dout0_11) AT=545.025n

.meas tran vdout0_12ck1080 FIND v(dout0_12) AT=545.025n

.meas tran vdout0_13ck1080 FIND v(dout0_13) AT=545.025n

.meas tran vdout0_14ck1080 FIND v(dout0_14) AT=545.025n

.meas tran vdout0_15ck1080 FIND v(dout0_15) AT=545.025n

.meas tran vdout0_16ck1080 FIND v(dout0_16) AT=545.025n

.meas tran vdout0_17ck1080 FIND v(dout0_17) AT=545.025n

.meas tran vdout0_18ck1080 FIND v(dout0_18) AT=545.025n

.meas tran vdout0_19ck1080 FIND v(dout0_19) AT=545.025n

.meas tran vdout0_20ck1080 FIND v(dout0_20) AT=545.025n

.meas tran vdout0_0ck1090 FIND v(dout0_0) AT=550.025n

.meas tran vdout0_1ck1090 FIND v(dout0_1) AT=550.025n

.meas tran vdout0_2ck1090 FIND v(dout0_2) AT=550.025n

.meas tran vdout0_3ck1090 FIND v(dout0_3) AT=550.025n

.meas tran vdout0_4ck1090 FIND v(dout0_4) AT=550.025n

.meas tran vdout0_5ck1090 FIND v(dout0_5) AT=550.025n

.meas tran vdout0_6ck1090 FIND v(dout0_6) AT=550.025n

.meas tran vdout0_7ck1090 FIND v(dout0_7) AT=550.025n

.meas tran vdout0_8ck1090 FIND v(dout0_8) AT=550.025n

.meas tran vdout0_9ck1090 FIND v(dout0_9) AT=550.025n

.meas tran vdout0_10ck1090 FIND v(dout0_10) AT=550.025n

.meas tran vdout0_11ck1090 FIND v(dout0_11) AT=550.025n

.meas tran vdout0_12ck1090 FIND v(dout0_12) AT=550.025n

.meas tran vdout0_13ck1090 FIND v(dout0_13) AT=550.025n

.meas tran vdout0_14ck1090 FIND v(dout0_14) AT=550.025n

.meas tran vdout0_15ck1090 FIND v(dout0_15) AT=550.025n

.meas tran vdout0_16ck1090 FIND v(dout0_16) AT=550.025n

.meas tran vdout0_17ck1090 FIND v(dout0_17) AT=550.025n

.meas tran vdout0_18ck1090 FIND v(dout0_18) AT=550.025n

.meas tran vdout0_19ck1090 FIND v(dout0_19) AT=550.025n

.meas tran vdout0_20ck1090 FIND v(dout0_20) AT=550.025n

.meas tran vdout0_0ck1110 FIND v(dout0_0) AT=560.025n

.meas tran vdout0_1ck1110 FIND v(dout0_1) AT=560.025n

.meas tran vdout0_2ck1110 FIND v(dout0_2) AT=560.025n

.meas tran vdout0_3ck1110 FIND v(dout0_3) AT=560.025n

.meas tran vdout0_4ck1110 FIND v(dout0_4) AT=560.025n

.meas tran vdout0_5ck1110 FIND v(dout0_5) AT=560.025n

.meas tran vdout0_6ck1110 FIND v(dout0_6) AT=560.025n

.meas tran vdout0_7ck1110 FIND v(dout0_7) AT=560.025n

.meas tran vdout0_8ck1110 FIND v(dout0_8) AT=560.025n

.meas tran vdout0_9ck1110 FIND v(dout0_9) AT=560.025n

.meas tran vdout0_10ck1110 FIND v(dout0_10) AT=560.025n

.meas tran vdout0_11ck1110 FIND v(dout0_11) AT=560.025n

.meas tran vdout0_12ck1110 FIND v(dout0_12) AT=560.025n

.meas tran vdout0_13ck1110 FIND v(dout0_13) AT=560.025n

.meas tran vdout0_14ck1110 FIND v(dout0_14) AT=560.025n

.meas tran vdout0_15ck1110 FIND v(dout0_15) AT=560.025n

.meas tran vdout0_16ck1110 FIND v(dout0_16) AT=560.025n

.meas tran vdout0_17ck1110 FIND v(dout0_17) AT=560.025n

.meas tran vdout0_18ck1110 FIND v(dout0_18) AT=560.025n

.meas tran vdout0_19ck1110 FIND v(dout0_19) AT=560.025n

.meas tran vdout0_20ck1110 FIND v(dout0_20) AT=560.025n

.meas tran vdout0_0ck1130 FIND v(dout0_0) AT=570.025n

.meas tran vdout0_1ck1130 FIND v(dout0_1) AT=570.025n

.meas tran vdout0_2ck1130 FIND v(dout0_2) AT=570.025n

.meas tran vdout0_3ck1130 FIND v(dout0_3) AT=570.025n

.meas tran vdout0_4ck1130 FIND v(dout0_4) AT=570.025n

.meas tran vdout0_5ck1130 FIND v(dout0_5) AT=570.025n

.meas tran vdout0_6ck1130 FIND v(dout0_6) AT=570.025n

.meas tran vdout0_7ck1130 FIND v(dout0_7) AT=570.025n

.meas tran vdout0_8ck1130 FIND v(dout0_8) AT=570.025n

.meas tran vdout0_9ck1130 FIND v(dout0_9) AT=570.025n

.meas tran vdout0_10ck1130 FIND v(dout0_10) AT=570.025n

.meas tran vdout0_11ck1130 FIND v(dout0_11) AT=570.025n

.meas tran vdout0_12ck1130 FIND v(dout0_12) AT=570.025n

.meas tran vdout0_13ck1130 FIND v(dout0_13) AT=570.025n

.meas tran vdout0_14ck1130 FIND v(dout0_14) AT=570.025n

.meas tran vdout0_15ck1130 FIND v(dout0_15) AT=570.025n

.meas tran vdout0_16ck1130 FIND v(dout0_16) AT=570.025n

.meas tran vdout0_17ck1130 FIND v(dout0_17) AT=570.025n

.meas tran vdout0_18ck1130 FIND v(dout0_18) AT=570.025n

.meas tran vdout0_19ck1130 FIND v(dout0_19) AT=570.025n

.meas tran vdout0_20ck1130 FIND v(dout0_20) AT=570.025n

.meas tran vdout0_0ck1170 FIND v(dout0_0) AT=590.025n

.meas tran vdout0_1ck1170 FIND v(dout0_1) AT=590.025n

.meas tran vdout0_2ck1170 FIND v(dout0_2) AT=590.025n

.meas tran vdout0_3ck1170 FIND v(dout0_3) AT=590.025n

.meas tran vdout0_4ck1170 FIND v(dout0_4) AT=590.025n

.meas tran vdout0_5ck1170 FIND v(dout0_5) AT=590.025n

.meas tran vdout0_6ck1170 FIND v(dout0_6) AT=590.025n

.meas tran vdout0_7ck1170 FIND v(dout0_7) AT=590.025n

.meas tran vdout0_8ck1170 FIND v(dout0_8) AT=590.025n

.meas tran vdout0_9ck1170 FIND v(dout0_9) AT=590.025n

.meas tran vdout0_10ck1170 FIND v(dout0_10) AT=590.025n

.meas tran vdout0_11ck1170 FIND v(dout0_11) AT=590.025n

.meas tran vdout0_12ck1170 FIND v(dout0_12) AT=590.025n

.meas tran vdout0_13ck1170 FIND v(dout0_13) AT=590.025n

.meas tran vdout0_14ck1170 FIND v(dout0_14) AT=590.025n

.meas tran vdout0_15ck1170 FIND v(dout0_15) AT=590.025n

.meas tran vdout0_16ck1170 FIND v(dout0_16) AT=590.025n

.meas tran vdout0_17ck1170 FIND v(dout0_17) AT=590.025n

.meas tran vdout0_18ck1170 FIND v(dout0_18) AT=590.025n

.meas tran vdout0_19ck1170 FIND v(dout0_19) AT=590.025n

.meas tran vdout0_20ck1170 FIND v(dout0_20) AT=590.025n

.meas tran vdout0_0ck1210 FIND v(dout0_0) AT=610.025n

.meas tran vdout0_1ck1210 FIND v(dout0_1) AT=610.025n

.meas tran vdout0_2ck1210 FIND v(dout0_2) AT=610.025n

.meas tran vdout0_3ck1210 FIND v(dout0_3) AT=610.025n

.meas tran vdout0_4ck1210 FIND v(dout0_4) AT=610.025n

.meas tran vdout0_5ck1210 FIND v(dout0_5) AT=610.025n

.meas tran vdout0_6ck1210 FIND v(dout0_6) AT=610.025n

.meas tran vdout0_7ck1210 FIND v(dout0_7) AT=610.025n

.meas tran vdout0_8ck1210 FIND v(dout0_8) AT=610.025n

.meas tran vdout0_9ck1210 FIND v(dout0_9) AT=610.025n

.meas tran vdout0_10ck1210 FIND v(dout0_10) AT=610.025n

.meas tran vdout0_11ck1210 FIND v(dout0_11) AT=610.025n

.meas tran vdout0_12ck1210 FIND v(dout0_12) AT=610.025n

.meas tran vdout0_13ck1210 FIND v(dout0_13) AT=610.025n

.meas tran vdout0_14ck1210 FIND v(dout0_14) AT=610.025n

.meas tran vdout0_15ck1210 FIND v(dout0_15) AT=610.025n

.meas tran vdout0_16ck1210 FIND v(dout0_16) AT=610.025n

.meas tran vdout0_17ck1210 FIND v(dout0_17) AT=610.025n

.meas tran vdout0_18ck1210 FIND v(dout0_18) AT=610.025n

.meas tran vdout0_19ck1210 FIND v(dout0_19) AT=610.025n

.meas tran vdout0_20ck1210 FIND v(dout0_20) AT=610.025n

.meas tran vdout0_0ck1250 FIND v(dout0_0) AT=630.025n

.meas tran vdout0_1ck1250 FIND v(dout0_1) AT=630.025n

.meas tran vdout0_2ck1250 FIND v(dout0_2) AT=630.025n

.meas tran vdout0_3ck1250 FIND v(dout0_3) AT=630.025n

.meas tran vdout0_4ck1250 FIND v(dout0_4) AT=630.025n

.meas tran vdout0_5ck1250 FIND v(dout0_5) AT=630.025n

.meas tran vdout0_6ck1250 FIND v(dout0_6) AT=630.025n

.meas tran vdout0_7ck1250 FIND v(dout0_7) AT=630.025n

.meas tran vdout0_8ck1250 FIND v(dout0_8) AT=630.025n

.meas tran vdout0_9ck1250 FIND v(dout0_9) AT=630.025n

.meas tran vdout0_10ck1250 FIND v(dout0_10) AT=630.025n

.meas tran vdout0_11ck1250 FIND v(dout0_11) AT=630.025n

.meas tran vdout0_12ck1250 FIND v(dout0_12) AT=630.025n

.meas tran vdout0_13ck1250 FIND v(dout0_13) AT=630.025n

.meas tran vdout0_14ck1250 FIND v(dout0_14) AT=630.025n

.meas tran vdout0_15ck1250 FIND v(dout0_15) AT=630.025n

.meas tran vdout0_16ck1250 FIND v(dout0_16) AT=630.025n

.meas tran vdout0_17ck1250 FIND v(dout0_17) AT=630.025n

.meas tran vdout0_18ck1250 FIND v(dout0_18) AT=630.025n

.meas tran vdout0_19ck1250 FIND v(dout0_19) AT=630.025n

.meas tran vdout0_20ck1250 FIND v(dout0_20) AT=630.025n

.meas tran vdout0_0ck1260 FIND v(dout0_0) AT=635.025n

.meas tran vdout0_1ck1260 FIND v(dout0_1) AT=635.025n

.meas tran vdout0_2ck1260 FIND v(dout0_2) AT=635.025n

.meas tran vdout0_3ck1260 FIND v(dout0_3) AT=635.025n

.meas tran vdout0_4ck1260 FIND v(dout0_4) AT=635.025n

.meas tran vdout0_5ck1260 FIND v(dout0_5) AT=635.025n

.meas tran vdout0_6ck1260 FIND v(dout0_6) AT=635.025n

.meas tran vdout0_7ck1260 FIND v(dout0_7) AT=635.025n

.meas tran vdout0_8ck1260 FIND v(dout0_8) AT=635.025n

.meas tran vdout0_9ck1260 FIND v(dout0_9) AT=635.025n

.meas tran vdout0_10ck1260 FIND v(dout0_10) AT=635.025n

.meas tran vdout0_11ck1260 FIND v(dout0_11) AT=635.025n

.meas tran vdout0_12ck1260 FIND v(dout0_12) AT=635.025n

.meas tran vdout0_13ck1260 FIND v(dout0_13) AT=635.025n

.meas tran vdout0_14ck1260 FIND v(dout0_14) AT=635.025n

.meas tran vdout0_15ck1260 FIND v(dout0_15) AT=635.025n

.meas tran vdout0_16ck1260 FIND v(dout0_16) AT=635.025n

.meas tran vdout0_17ck1260 FIND v(dout0_17) AT=635.025n

.meas tran vdout0_18ck1260 FIND v(dout0_18) AT=635.025n

.meas tran vdout0_19ck1260 FIND v(dout0_19) AT=635.025n

.meas tran vdout0_20ck1260 FIND v(dout0_20) AT=635.025n

.meas tran vdout0_0ck1270 FIND v(dout0_0) AT=640.025n

.meas tran vdout0_1ck1270 FIND v(dout0_1) AT=640.025n

.meas tran vdout0_2ck1270 FIND v(dout0_2) AT=640.025n

.meas tran vdout0_3ck1270 FIND v(dout0_3) AT=640.025n

.meas tran vdout0_4ck1270 FIND v(dout0_4) AT=640.025n

.meas tran vdout0_5ck1270 FIND v(dout0_5) AT=640.025n

.meas tran vdout0_6ck1270 FIND v(dout0_6) AT=640.025n

.meas tran vdout0_7ck1270 FIND v(dout0_7) AT=640.025n

.meas tran vdout0_8ck1270 FIND v(dout0_8) AT=640.025n

.meas tran vdout0_9ck1270 FIND v(dout0_9) AT=640.025n

.meas tran vdout0_10ck1270 FIND v(dout0_10) AT=640.025n

.meas tran vdout0_11ck1270 FIND v(dout0_11) AT=640.025n

.meas tran vdout0_12ck1270 FIND v(dout0_12) AT=640.025n

.meas tran vdout0_13ck1270 FIND v(dout0_13) AT=640.025n

.meas tran vdout0_14ck1270 FIND v(dout0_14) AT=640.025n

.meas tran vdout0_15ck1270 FIND v(dout0_15) AT=640.025n

.meas tran vdout0_16ck1270 FIND v(dout0_16) AT=640.025n

.meas tran vdout0_17ck1270 FIND v(dout0_17) AT=640.025n

.meas tran vdout0_18ck1270 FIND v(dout0_18) AT=640.025n

.meas tran vdout0_19ck1270 FIND v(dout0_19) AT=640.025n

.meas tran vdout0_20ck1270 FIND v(dout0_20) AT=640.025n

.meas tran vdout0_0ck1280 FIND v(dout0_0) AT=645.025n

.meas tran vdout0_1ck1280 FIND v(dout0_1) AT=645.025n

.meas tran vdout0_2ck1280 FIND v(dout0_2) AT=645.025n

.meas tran vdout0_3ck1280 FIND v(dout0_3) AT=645.025n

.meas tran vdout0_4ck1280 FIND v(dout0_4) AT=645.025n

.meas tran vdout0_5ck1280 FIND v(dout0_5) AT=645.025n

.meas tran vdout0_6ck1280 FIND v(dout0_6) AT=645.025n

.meas tran vdout0_7ck1280 FIND v(dout0_7) AT=645.025n

.meas tran vdout0_8ck1280 FIND v(dout0_8) AT=645.025n

.meas tran vdout0_9ck1280 FIND v(dout0_9) AT=645.025n

.meas tran vdout0_10ck1280 FIND v(dout0_10) AT=645.025n

.meas tran vdout0_11ck1280 FIND v(dout0_11) AT=645.025n

.meas tran vdout0_12ck1280 FIND v(dout0_12) AT=645.025n

.meas tran vdout0_13ck1280 FIND v(dout0_13) AT=645.025n

.meas tran vdout0_14ck1280 FIND v(dout0_14) AT=645.025n

.meas tran vdout0_15ck1280 FIND v(dout0_15) AT=645.025n

.meas tran vdout0_16ck1280 FIND v(dout0_16) AT=645.025n

.meas tran vdout0_17ck1280 FIND v(dout0_17) AT=645.025n

.meas tran vdout0_18ck1280 FIND v(dout0_18) AT=645.025n

.meas tran vdout0_19ck1280 FIND v(dout0_19) AT=645.025n

.meas tran vdout0_20ck1280 FIND v(dout0_20) AT=645.025n

.meas tran vdout0_0ck1290 FIND v(dout0_0) AT=650.025n

.meas tran vdout0_1ck1290 FIND v(dout0_1) AT=650.025n

.meas tran vdout0_2ck1290 FIND v(dout0_2) AT=650.025n

.meas tran vdout0_3ck1290 FIND v(dout0_3) AT=650.025n

.meas tran vdout0_4ck1290 FIND v(dout0_4) AT=650.025n

.meas tran vdout0_5ck1290 FIND v(dout0_5) AT=650.025n

.meas tran vdout0_6ck1290 FIND v(dout0_6) AT=650.025n

.meas tran vdout0_7ck1290 FIND v(dout0_7) AT=650.025n

.meas tran vdout0_8ck1290 FIND v(dout0_8) AT=650.025n

.meas tran vdout0_9ck1290 FIND v(dout0_9) AT=650.025n

.meas tran vdout0_10ck1290 FIND v(dout0_10) AT=650.025n

.meas tran vdout0_11ck1290 FIND v(dout0_11) AT=650.025n

.meas tran vdout0_12ck1290 FIND v(dout0_12) AT=650.025n

.meas tran vdout0_13ck1290 FIND v(dout0_13) AT=650.025n

.meas tran vdout0_14ck1290 FIND v(dout0_14) AT=650.025n

.meas tran vdout0_15ck1290 FIND v(dout0_15) AT=650.025n

.meas tran vdout0_16ck1290 FIND v(dout0_16) AT=650.025n

.meas tran vdout0_17ck1290 FIND v(dout0_17) AT=650.025n

.meas tran vdout0_18ck1290 FIND v(dout0_18) AT=650.025n

.meas tran vdout0_19ck1290 FIND v(dout0_19) AT=650.025n

.meas tran vdout0_20ck1290 FIND v(dout0_20) AT=650.025n

.meas tran vdout0_0ck1300 FIND v(dout0_0) AT=655.025n

.meas tran vdout0_1ck1300 FIND v(dout0_1) AT=655.025n

.meas tran vdout0_2ck1300 FIND v(dout0_2) AT=655.025n

.meas tran vdout0_3ck1300 FIND v(dout0_3) AT=655.025n

.meas tran vdout0_4ck1300 FIND v(dout0_4) AT=655.025n

.meas tran vdout0_5ck1300 FIND v(dout0_5) AT=655.025n

.meas tran vdout0_6ck1300 FIND v(dout0_6) AT=655.025n

.meas tran vdout0_7ck1300 FIND v(dout0_7) AT=655.025n

.meas tran vdout0_8ck1300 FIND v(dout0_8) AT=655.025n

.meas tran vdout0_9ck1300 FIND v(dout0_9) AT=655.025n

.meas tran vdout0_10ck1300 FIND v(dout0_10) AT=655.025n

.meas tran vdout0_11ck1300 FIND v(dout0_11) AT=655.025n

.meas tran vdout0_12ck1300 FIND v(dout0_12) AT=655.025n

.meas tran vdout0_13ck1300 FIND v(dout0_13) AT=655.025n

.meas tran vdout0_14ck1300 FIND v(dout0_14) AT=655.025n

.meas tran vdout0_15ck1300 FIND v(dout0_15) AT=655.025n

.meas tran vdout0_16ck1300 FIND v(dout0_16) AT=655.025n

.meas tran vdout0_17ck1300 FIND v(dout0_17) AT=655.025n

.meas tran vdout0_18ck1300 FIND v(dout0_18) AT=655.025n

.meas tran vdout0_19ck1300 FIND v(dout0_19) AT=655.025n

.meas tran vdout0_20ck1300 FIND v(dout0_20) AT=655.025n

.meas tran vdout0_0ck1310 FIND v(dout0_0) AT=660.025n

.meas tran vdout0_1ck1310 FIND v(dout0_1) AT=660.025n

.meas tran vdout0_2ck1310 FIND v(dout0_2) AT=660.025n

.meas tran vdout0_3ck1310 FIND v(dout0_3) AT=660.025n

.meas tran vdout0_4ck1310 FIND v(dout0_4) AT=660.025n

.meas tran vdout0_5ck1310 FIND v(dout0_5) AT=660.025n

.meas tran vdout0_6ck1310 FIND v(dout0_6) AT=660.025n

.meas tran vdout0_7ck1310 FIND v(dout0_7) AT=660.025n

.meas tran vdout0_8ck1310 FIND v(dout0_8) AT=660.025n

.meas tran vdout0_9ck1310 FIND v(dout0_9) AT=660.025n

.meas tran vdout0_10ck1310 FIND v(dout0_10) AT=660.025n

.meas tran vdout0_11ck1310 FIND v(dout0_11) AT=660.025n

.meas tran vdout0_12ck1310 FIND v(dout0_12) AT=660.025n

.meas tran vdout0_13ck1310 FIND v(dout0_13) AT=660.025n

.meas tran vdout0_14ck1310 FIND v(dout0_14) AT=660.025n

.meas tran vdout0_15ck1310 FIND v(dout0_15) AT=660.025n

.meas tran vdout0_16ck1310 FIND v(dout0_16) AT=660.025n

.meas tran vdout0_17ck1310 FIND v(dout0_17) AT=660.025n

.meas tran vdout0_18ck1310 FIND v(dout0_18) AT=660.025n

.meas tran vdout0_19ck1310 FIND v(dout0_19) AT=660.025n

.meas tran vdout0_20ck1310 FIND v(dout0_20) AT=660.025n

.meas tran vdout0_0ck1340 FIND v(dout0_0) AT=675.025n

.meas tran vdout0_1ck1340 FIND v(dout0_1) AT=675.025n

.meas tran vdout0_2ck1340 FIND v(dout0_2) AT=675.025n

.meas tran vdout0_3ck1340 FIND v(dout0_3) AT=675.025n

.meas tran vdout0_4ck1340 FIND v(dout0_4) AT=675.025n

.meas tran vdout0_5ck1340 FIND v(dout0_5) AT=675.025n

.meas tran vdout0_6ck1340 FIND v(dout0_6) AT=675.025n

.meas tran vdout0_7ck1340 FIND v(dout0_7) AT=675.025n

.meas tran vdout0_8ck1340 FIND v(dout0_8) AT=675.025n

.meas tran vdout0_9ck1340 FIND v(dout0_9) AT=675.025n

.meas tran vdout0_10ck1340 FIND v(dout0_10) AT=675.025n

.meas tran vdout0_11ck1340 FIND v(dout0_11) AT=675.025n

.meas tran vdout0_12ck1340 FIND v(dout0_12) AT=675.025n

.meas tran vdout0_13ck1340 FIND v(dout0_13) AT=675.025n

.meas tran vdout0_14ck1340 FIND v(dout0_14) AT=675.025n

.meas tran vdout0_15ck1340 FIND v(dout0_15) AT=675.025n

.meas tran vdout0_16ck1340 FIND v(dout0_16) AT=675.025n

.meas tran vdout0_17ck1340 FIND v(dout0_17) AT=675.025n

.meas tran vdout0_18ck1340 FIND v(dout0_18) AT=675.025n

.meas tran vdout0_19ck1340 FIND v(dout0_19) AT=675.025n

.meas tran vdout0_20ck1340 FIND v(dout0_20) AT=675.025n

.meas tran vdout0_0ck1360 FIND v(dout0_0) AT=685.025n

.meas tran vdout0_1ck1360 FIND v(dout0_1) AT=685.025n

.meas tran vdout0_2ck1360 FIND v(dout0_2) AT=685.025n

.meas tran vdout0_3ck1360 FIND v(dout0_3) AT=685.025n

.meas tran vdout0_4ck1360 FIND v(dout0_4) AT=685.025n

.meas tran vdout0_5ck1360 FIND v(dout0_5) AT=685.025n

.meas tran vdout0_6ck1360 FIND v(dout0_6) AT=685.025n

.meas tran vdout0_7ck1360 FIND v(dout0_7) AT=685.025n

.meas tran vdout0_8ck1360 FIND v(dout0_8) AT=685.025n

.meas tran vdout0_9ck1360 FIND v(dout0_9) AT=685.025n

.meas tran vdout0_10ck1360 FIND v(dout0_10) AT=685.025n

.meas tran vdout0_11ck1360 FIND v(dout0_11) AT=685.025n

.meas tran vdout0_12ck1360 FIND v(dout0_12) AT=685.025n

.meas tran vdout0_13ck1360 FIND v(dout0_13) AT=685.025n

.meas tran vdout0_14ck1360 FIND v(dout0_14) AT=685.025n

.meas tran vdout0_15ck1360 FIND v(dout0_15) AT=685.025n

.meas tran vdout0_16ck1360 FIND v(dout0_16) AT=685.025n

.meas tran vdout0_17ck1360 FIND v(dout0_17) AT=685.025n

.meas tran vdout0_18ck1360 FIND v(dout0_18) AT=685.025n

.meas tran vdout0_19ck1360 FIND v(dout0_19) AT=685.025n

.meas tran vdout0_20ck1360 FIND v(dout0_20) AT=685.025n

.meas tran vdout0_0ck1400 FIND v(dout0_0) AT=705.025n

.meas tran vdout0_1ck1400 FIND v(dout0_1) AT=705.025n

.meas tran vdout0_2ck1400 FIND v(dout0_2) AT=705.025n

.meas tran vdout0_3ck1400 FIND v(dout0_3) AT=705.025n

.meas tran vdout0_4ck1400 FIND v(dout0_4) AT=705.025n

.meas tran vdout0_5ck1400 FIND v(dout0_5) AT=705.025n

.meas tran vdout0_6ck1400 FIND v(dout0_6) AT=705.025n

.meas tran vdout0_7ck1400 FIND v(dout0_7) AT=705.025n

.meas tran vdout0_8ck1400 FIND v(dout0_8) AT=705.025n

.meas tran vdout0_9ck1400 FIND v(dout0_9) AT=705.025n

.meas tran vdout0_10ck1400 FIND v(dout0_10) AT=705.025n

.meas tran vdout0_11ck1400 FIND v(dout0_11) AT=705.025n

.meas tran vdout0_12ck1400 FIND v(dout0_12) AT=705.025n

.meas tran vdout0_13ck1400 FIND v(dout0_13) AT=705.025n

.meas tran vdout0_14ck1400 FIND v(dout0_14) AT=705.025n

.meas tran vdout0_15ck1400 FIND v(dout0_15) AT=705.025n

.meas tran vdout0_16ck1400 FIND v(dout0_16) AT=705.025n

.meas tran vdout0_17ck1400 FIND v(dout0_17) AT=705.025n

.meas tran vdout0_18ck1400 FIND v(dout0_18) AT=705.025n

.meas tran vdout0_19ck1400 FIND v(dout0_19) AT=705.025n

.meas tran vdout0_20ck1400 FIND v(dout0_20) AT=705.025n

.meas tran vdout0_0ck1430 FIND v(dout0_0) AT=720.025n

.meas tran vdout0_1ck1430 FIND v(dout0_1) AT=720.025n

.meas tran vdout0_2ck1430 FIND v(dout0_2) AT=720.025n

.meas tran vdout0_3ck1430 FIND v(dout0_3) AT=720.025n

.meas tran vdout0_4ck1430 FIND v(dout0_4) AT=720.025n

.meas tran vdout0_5ck1430 FIND v(dout0_5) AT=720.025n

.meas tran vdout0_6ck1430 FIND v(dout0_6) AT=720.025n

.meas tran vdout0_7ck1430 FIND v(dout0_7) AT=720.025n

.meas tran vdout0_8ck1430 FIND v(dout0_8) AT=720.025n

.meas tran vdout0_9ck1430 FIND v(dout0_9) AT=720.025n

.meas tran vdout0_10ck1430 FIND v(dout0_10) AT=720.025n

.meas tran vdout0_11ck1430 FIND v(dout0_11) AT=720.025n

.meas tran vdout0_12ck1430 FIND v(dout0_12) AT=720.025n

.meas tran vdout0_13ck1430 FIND v(dout0_13) AT=720.025n

.meas tran vdout0_14ck1430 FIND v(dout0_14) AT=720.025n

.meas tran vdout0_15ck1430 FIND v(dout0_15) AT=720.025n

.meas tran vdout0_16ck1430 FIND v(dout0_16) AT=720.025n

.meas tran vdout0_17ck1430 FIND v(dout0_17) AT=720.025n

.meas tran vdout0_18ck1430 FIND v(dout0_18) AT=720.025n

.meas tran vdout0_19ck1430 FIND v(dout0_19) AT=720.025n

.meas tran vdout0_20ck1430 FIND v(dout0_20) AT=720.025n

.meas tran vdout0_0ck1450 FIND v(dout0_0) AT=730.025n

.meas tran vdout0_1ck1450 FIND v(dout0_1) AT=730.025n

.meas tran vdout0_2ck1450 FIND v(dout0_2) AT=730.025n

.meas tran vdout0_3ck1450 FIND v(dout0_3) AT=730.025n

.meas tran vdout0_4ck1450 FIND v(dout0_4) AT=730.025n

.meas tran vdout0_5ck1450 FIND v(dout0_5) AT=730.025n

.meas tran vdout0_6ck1450 FIND v(dout0_6) AT=730.025n

.meas tran vdout0_7ck1450 FIND v(dout0_7) AT=730.025n

.meas tran vdout0_8ck1450 FIND v(dout0_8) AT=730.025n

.meas tran vdout0_9ck1450 FIND v(dout0_9) AT=730.025n

.meas tran vdout0_10ck1450 FIND v(dout0_10) AT=730.025n

.meas tran vdout0_11ck1450 FIND v(dout0_11) AT=730.025n

.meas tran vdout0_12ck1450 FIND v(dout0_12) AT=730.025n

.meas tran vdout0_13ck1450 FIND v(dout0_13) AT=730.025n

.meas tran vdout0_14ck1450 FIND v(dout0_14) AT=730.025n

.meas tran vdout0_15ck1450 FIND v(dout0_15) AT=730.025n

.meas tran vdout0_16ck1450 FIND v(dout0_16) AT=730.025n

.meas tran vdout0_17ck1450 FIND v(dout0_17) AT=730.025n

.meas tran vdout0_18ck1450 FIND v(dout0_18) AT=730.025n

.meas tran vdout0_19ck1450 FIND v(dout0_19) AT=730.025n

.meas tran vdout0_20ck1450 FIND v(dout0_20) AT=730.025n

.meas tran vdout0_0ck1490 FIND v(dout0_0) AT=750.025n

.meas tran vdout0_1ck1490 FIND v(dout0_1) AT=750.025n

.meas tran vdout0_2ck1490 FIND v(dout0_2) AT=750.025n

.meas tran vdout0_3ck1490 FIND v(dout0_3) AT=750.025n

.meas tran vdout0_4ck1490 FIND v(dout0_4) AT=750.025n

.meas tran vdout0_5ck1490 FIND v(dout0_5) AT=750.025n

.meas tran vdout0_6ck1490 FIND v(dout0_6) AT=750.025n

.meas tran vdout0_7ck1490 FIND v(dout0_7) AT=750.025n

.meas tran vdout0_8ck1490 FIND v(dout0_8) AT=750.025n

.meas tran vdout0_9ck1490 FIND v(dout0_9) AT=750.025n

.meas tran vdout0_10ck1490 FIND v(dout0_10) AT=750.025n

.meas tran vdout0_11ck1490 FIND v(dout0_11) AT=750.025n

.meas tran vdout0_12ck1490 FIND v(dout0_12) AT=750.025n

.meas tran vdout0_13ck1490 FIND v(dout0_13) AT=750.025n

.meas tran vdout0_14ck1490 FIND v(dout0_14) AT=750.025n

.meas tran vdout0_15ck1490 FIND v(dout0_15) AT=750.025n

.meas tran vdout0_16ck1490 FIND v(dout0_16) AT=750.025n

.meas tran vdout0_17ck1490 FIND v(dout0_17) AT=750.025n

.meas tran vdout0_18ck1490 FIND v(dout0_18) AT=750.025n

.meas tran vdout0_19ck1490 FIND v(dout0_19) AT=750.025n

.meas tran vdout0_20ck1490 FIND v(dout0_20) AT=750.025n

.meas tran vdout0_0ck1500 FIND v(dout0_0) AT=755.025n

.meas tran vdout0_1ck1500 FIND v(dout0_1) AT=755.025n

.meas tran vdout0_2ck1500 FIND v(dout0_2) AT=755.025n

.meas tran vdout0_3ck1500 FIND v(dout0_3) AT=755.025n

.meas tran vdout0_4ck1500 FIND v(dout0_4) AT=755.025n

.meas tran vdout0_5ck1500 FIND v(dout0_5) AT=755.025n

.meas tran vdout0_6ck1500 FIND v(dout0_6) AT=755.025n

.meas tran vdout0_7ck1500 FIND v(dout0_7) AT=755.025n

.meas tran vdout0_8ck1500 FIND v(dout0_8) AT=755.025n

.meas tran vdout0_9ck1500 FIND v(dout0_9) AT=755.025n

.meas tran vdout0_10ck1500 FIND v(dout0_10) AT=755.025n

.meas tran vdout0_11ck1500 FIND v(dout0_11) AT=755.025n

.meas tran vdout0_12ck1500 FIND v(dout0_12) AT=755.025n

.meas tran vdout0_13ck1500 FIND v(dout0_13) AT=755.025n

.meas tran vdout0_14ck1500 FIND v(dout0_14) AT=755.025n

.meas tran vdout0_15ck1500 FIND v(dout0_15) AT=755.025n

.meas tran vdout0_16ck1500 FIND v(dout0_16) AT=755.025n

.meas tran vdout0_17ck1500 FIND v(dout0_17) AT=755.025n

.meas tran vdout0_18ck1500 FIND v(dout0_18) AT=755.025n

.meas tran vdout0_19ck1500 FIND v(dout0_19) AT=755.025n

.meas tran vdout0_20ck1500 FIND v(dout0_20) AT=755.025n

.meas tran vdout0_0ck1520 FIND v(dout0_0) AT=765.025n

.meas tran vdout0_1ck1520 FIND v(dout0_1) AT=765.025n

.meas tran vdout0_2ck1520 FIND v(dout0_2) AT=765.025n

.meas tran vdout0_3ck1520 FIND v(dout0_3) AT=765.025n

.meas tran vdout0_4ck1520 FIND v(dout0_4) AT=765.025n

.meas tran vdout0_5ck1520 FIND v(dout0_5) AT=765.025n

.meas tran vdout0_6ck1520 FIND v(dout0_6) AT=765.025n

.meas tran vdout0_7ck1520 FIND v(dout0_7) AT=765.025n

.meas tran vdout0_8ck1520 FIND v(dout0_8) AT=765.025n

.meas tran vdout0_9ck1520 FIND v(dout0_9) AT=765.025n

.meas tran vdout0_10ck1520 FIND v(dout0_10) AT=765.025n

.meas tran vdout0_11ck1520 FIND v(dout0_11) AT=765.025n

.meas tran vdout0_12ck1520 FIND v(dout0_12) AT=765.025n

.meas tran vdout0_13ck1520 FIND v(dout0_13) AT=765.025n

.meas tran vdout0_14ck1520 FIND v(dout0_14) AT=765.025n

.meas tran vdout0_15ck1520 FIND v(dout0_15) AT=765.025n

.meas tran vdout0_16ck1520 FIND v(dout0_16) AT=765.025n

.meas tran vdout0_17ck1520 FIND v(dout0_17) AT=765.025n

.meas tran vdout0_18ck1520 FIND v(dout0_18) AT=765.025n

.meas tran vdout0_19ck1520 FIND v(dout0_19) AT=765.025n

.meas tran vdout0_20ck1520 FIND v(dout0_20) AT=765.025n

.meas tran vdout0_0ck1540 FIND v(dout0_0) AT=775.025n

.meas tran vdout0_1ck1540 FIND v(dout0_1) AT=775.025n

.meas tran vdout0_2ck1540 FIND v(dout0_2) AT=775.025n

.meas tran vdout0_3ck1540 FIND v(dout0_3) AT=775.025n

.meas tran vdout0_4ck1540 FIND v(dout0_4) AT=775.025n

.meas tran vdout0_5ck1540 FIND v(dout0_5) AT=775.025n

.meas tran vdout0_6ck1540 FIND v(dout0_6) AT=775.025n

.meas tran vdout0_7ck1540 FIND v(dout0_7) AT=775.025n

.meas tran vdout0_8ck1540 FIND v(dout0_8) AT=775.025n

.meas tran vdout0_9ck1540 FIND v(dout0_9) AT=775.025n

.meas tran vdout0_10ck1540 FIND v(dout0_10) AT=775.025n

.meas tran vdout0_11ck1540 FIND v(dout0_11) AT=775.025n

.meas tran vdout0_12ck1540 FIND v(dout0_12) AT=775.025n

.meas tran vdout0_13ck1540 FIND v(dout0_13) AT=775.025n

.meas tran vdout0_14ck1540 FIND v(dout0_14) AT=775.025n

.meas tran vdout0_15ck1540 FIND v(dout0_15) AT=775.025n

.meas tran vdout0_16ck1540 FIND v(dout0_16) AT=775.025n

.meas tran vdout0_17ck1540 FIND v(dout0_17) AT=775.025n

.meas tran vdout0_18ck1540 FIND v(dout0_18) AT=775.025n

.meas tran vdout0_19ck1540 FIND v(dout0_19) AT=775.025n

.meas tran vdout0_20ck1540 FIND v(dout0_20) AT=775.025n

.meas tran vdout0_0ck1570 FIND v(dout0_0) AT=790.025n

.meas tran vdout0_1ck1570 FIND v(dout0_1) AT=790.025n

.meas tran vdout0_2ck1570 FIND v(dout0_2) AT=790.025n

.meas tran vdout0_3ck1570 FIND v(dout0_3) AT=790.025n

.meas tran vdout0_4ck1570 FIND v(dout0_4) AT=790.025n

.meas tran vdout0_5ck1570 FIND v(dout0_5) AT=790.025n

.meas tran vdout0_6ck1570 FIND v(dout0_6) AT=790.025n

.meas tran vdout0_7ck1570 FIND v(dout0_7) AT=790.025n

.meas tran vdout0_8ck1570 FIND v(dout0_8) AT=790.025n

.meas tran vdout0_9ck1570 FIND v(dout0_9) AT=790.025n

.meas tran vdout0_10ck1570 FIND v(dout0_10) AT=790.025n

.meas tran vdout0_11ck1570 FIND v(dout0_11) AT=790.025n

.meas tran vdout0_12ck1570 FIND v(dout0_12) AT=790.025n

.meas tran vdout0_13ck1570 FIND v(dout0_13) AT=790.025n

.meas tran vdout0_14ck1570 FIND v(dout0_14) AT=790.025n

.meas tran vdout0_15ck1570 FIND v(dout0_15) AT=790.025n

.meas tran vdout0_16ck1570 FIND v(dout0_16) AT=790.025n

.meas tran vdout0_17ck1570 FIND v(dout0_17) AT=790.025n

.meas tran vdout0_18ck1570 FIND v(dout0_18) AT=790.025n

.meas tran vdout0_19ck1570 FIND v(dout0_19) AT=790.025n

.meas tran vdout0_20ck1570 FIND v(dout0_20) AT=790.025n

.meas tran vdout0_0ck1580 FIND v(dout0_0) AT=795.025n

.meas tran vdout0_1ck1580 FIND v(dout0_1) AT=795.025n

.meas tran vdout0_2ck1580 FIND v(dout0_2) AT=795.025n

.meas tran vdout0_3ck1580 FIND v(dout0_3) AT=795.025n

.meas tran vdout0_4ck1580 FIND v(dout0_4) AT=795.025n

.meas tran vdout0_5ck1580 FIND v(dout0_5) AT=795.025n

.meas tran vdout0_6ck1580 FIND v(dout0_6) AT=795.025n

.meas tran vdout0_7ck1580 FIND v(dout0_7) AT=795.025n

.meas tran vdout0_8ck1580 FIND v(dout0_8) AT=795.025n

.meas tran vdout0_9ck1580 FIND v(dout0_9) AT=795.025n

.meas tran vdout0_10ck1580 FIND v(dout0_10) AT=795.025n

.meas tran vdout0_11ck1580 FIND v(dout0_11) AT=795.025n

.meas tran vdout0_12ck1580 FIND v(dout0_12) AT=795.025n

.meas tran vdout0_13ck1580 FIND v(dout0_13) AT=795.025n

.meas tran vdout0_14ck1580 FIND v(dout0_14) AT=795.025n

.meas tran vdout0_15ck1580 FIND v(dout0_15) AT=795.025n

.meas tran vdout0_16ck1580 FIND v(dout0_16) AT=795.025n

.meas tran vdout0_17ck1580 FIND v(dout0_17) AT=795.025n

.meas tran vdout0_18ck1580 FIND v(dout0_18) AT=795.025n

.meas tran vdout0_19ck1580 FIND v(dout0_19) AT=795.025n

.meas tran vdout0_20ck1580 FIND v(dout0_20) AT=795.025n

.meas tran vdout0_0ck1590 FIND v(dout0_0) AT=800.025n

.meas tran vdout0_1ck1590 FIND v(dout0_1) AT=800.025n

.meas tran vdout0_2ck1590 FIND v(dout0_2) AT=800.025n

.meas tran vdout0_3ck1590 FIND v(dout0_3) AT=800.025n

.meas tran vdout0_4ck1590 FIND v(dout0_4) AT=800.025n

.meas tran vdout0_5ck1590 FIND v(dout0_5) AT=800.025n

.meas tran vdout0_6ck1590 FIND v(dout0_6) AT=800.025n

.meas tran vdout0_7ck1590 FIND v(dout0_7) AT=800.025n

.meas tran vdout0_8ck1590 FIND v(dout0_8) AT=800.025n

.meas tran vdout0_9ck1590 FIND v(dout0_9) AT=800.025n

.meas tran vdout0_10ck1590 FIND v(dout0_10) AT=800.025n

.meas tran vdout0_11ck1590 FIND v(dout0_11) AT=800.025n

.meas tran vdout0_12ck1590 FIND v(dout0_12) AT=800.025n

.meas tran vdout0_13ck1590 FIND v(dout0_13) AT=800.025n

.meas tran vdout0_14ck1590 FIND v(dout0_14) AT=800.025n

.meas tran vdout0_15ck1590 FIND v(dout0_15) AT=800.025n

.meas tran vdout0_16ck1590 FIND v(dout0_16) AT=800.025n

.meas tran vdout0_17ck1590 FIND v(dout0_17) AT=800.025n

.meas tran vdout0_18ck1590 FIND v(dout0_18) AT=800.025n

.meas tran vdout0_19ck1590 FIND v(dout0_19) AT=800.025n

.meas tran vdout0_20ck1590 FIND v(dout0_20) AT=800.025n

.meas tran vdout0_0ck1620 FIND v(dout0_0) AT=815.025n

.meas tran vdout0_1ck1620 FIND v(dout0_1) AT=815.025n

.meas tran vdout0_2ck1620 FIND v(dout0_2) AT=815.025n

.meas tran vdout0_3ck1620 FIND v(dout0_3) AT=815.025n

.meas tran vdout0_4ck1620 FIND v(dout0_4) AT=815.025n

.meas tran vdout0_5ck1620 FIND v(dout0_5) AT=815.025n

.meas tran vdout0_6ck1620 FIND v(dout0_6) AT=815.025n

.meas tran vdout0_7ck1620 FIND v(dout0_7) AT=815.025n

.meas tran vdout0_8ck1620 FIND v(dout0_8) AT=815.025n

.meas tran vdout0_9ck1620 FIND v(dout0_9) AT=815.025n

.meas tran vdout0_10ck1620 FIND v(dout0_10) AT=815.025n

.meas tran vdout0_11ck1620 FIND v(dout0_11) AT=815.025n

.meas tran vdout0_12ck1620 FIND v(dout0_12) AT=815.025n

.meas tran vdout0_13ck1620 FIND v(dout0_13) AT=815.025n

.meas tran vdout0_14ck1620 FIND v(dout0_14) AT=815.025n

.meas tran vdout0_15ck1620 FIND v(dout0_15) AT=815.025n

.meas tran vdout0_16ck1620 FIND v(dout0_16) AT=815.025n

.meas tran vdout0_17ck1620 FIND v(dout0_17) AT=815.025n

.meas tran vdout0_18ck1620 FIND v(dout0_18) AT=815.025n

.meas tran vdout0_19ck1620 FIND v(dout0_19) AT=815.025n

.meas tran vdout0_20ck1620 FIND v(dout0_20) AT=815.025n

.meas tran vdout0_0ck1630 FIND v(dout0_0) AT=820.025n

.meas tran vdout0_1ck1630 FIND v(dout0_1) AT=820.025n

.meas tran vdout0_2ck1630 FIND v(dout0_2) AT=820.025n

.meas tran vdout0_3ck1630 FIND v(dout0_3) AT=820.025n

.meas tran vdout0_4ck1630 FIND v(dout0_4) AT=820.025n

.meas tran vdout0_5ck1630 FIND v(dout0_5) AT=820.025n

.meas tran vdout0_6ck1630 FIND v(dout0_6) AT=820.025n

.meas tran vdout0_7ck1630 FIND v(dout0_7) AT=820.025n

.meas tran vdout0_8ck1630 FIND v(dout0_8) AT=820.025n

.meas tran vdout0_9ck1630 FIND v(dout0_9) AT=820.025n

.meas tran vdout0_10ck1630 FIND v(dout0_10) AT=820.025n

.meas tran vdout0_11ck1630 FIND v(dout0_11) AT=820.025n

.meas tran vdout0_12ck1630 FIND v(dout0_12) AT=820.025n

.meas tran vdout0_13ck1630 FIND v(dout0_13) AT=820.025n

.meas tran vdout0_14ck1630 FIND v(dout0_14) AT=820.025n

.meas tran vdout0_15ck1630 FIND v(dout0_15) AT=820.025n

.meas tran vdout0_16ck1630 FIND v(dout0_16) AT=820.025n

.meas tran vdout0_17ck1630 FIND v(dout0_17) AT=820.025n

.meas tran vdout0_18ck1630 FIND v(dout0_18) AT=820.025n

.meas tran vdout0_19ck1630 FIND v(dout0_19) AT=820.025n

.meas tran vdout0_20ck1630 FIND v(dout0_20) AT=820.025n

.meas tran vdout0_0ck1650 FIND v(dout0_0) AT=830.025n

.meas tran vdout0_1ck1650 FIND v(dout0_1) AT=830.025n

.meas tran vdout0_2ck1650 FIND v(dout0_2) AT=830.025n

.meas tran vdout0_3ck1650 FIND v(dout0_3) AT=830.025n

.meas tran vdout0_4ck1650 FIND v(dout0_4) AT=830.025n

.meas tran vdout0_5ck1650 FIND v(dout0_5) AT=830.025n

.meas tran vdout0_6ck1650 FIND v(dout0_6) AT=830.025n

.meas tran vdout0_7ck1650 FIND v(dout0_7) AT=830.025n

.meas tran vdout0_8ck1650 FIND v(dout0_8) AT=830.025n

.meas tran vdout0_9ck1650 FIND v(dout0_9) AT=830.025n

.meas tran vdout0_10ck1650 FIND v(dout0_10) AT=830.025n

.meas tran vdout0_11ck1650 FIND v(dout0_11) AT=830.025n

.meas tran vdout0_12ck1650 FIND v(dout0_12) AT=830.025n

.meas tran vdout0_13ck1650 FIND v(dout0_13) AT=830.025n

.meas tran vdout0_14ck1650 FIND v(dout0_14) AT=830.025n

.meas tran vdout0_15ck1650 FIND v(dout0_15) AT=830.025n

.meas tran vdout0_16ck1650 FIND v(dout0_16) AT=830.025n

.meas tran vdout0_17ck1650 FIND v(dout0_17) AT=830.025n

.meas tran vdout0_18ck1650 FIND v(dout0_18) AT=830.025n

.meas tran vdout0_19ck1650 FIND v(dout0_19) AT=830.025n

.meas tran vdout0_20ck1650 FIND v(dout0_20) AT=830.025n

.meas tran vdout0_0ck1690 FIND v(dout0_0) AT=850.025n

.meas tran vdout0_1ck1690 FIND v(dout0_1) AT=850.025n

.meas tran vdout0_2ck1690 FIND v(dout0_2) AT=850.025n

.meas tran vdout0_3ck1690 FIND v(dout0_3) AT=850.025n

.meas tran vdout0_4ck1690 FIND v(dout0_4) AT=850.025n

.meas tran vdout0_5ck1690 FIND v(dout0_5) AT=850.025n

.meas tran vdout0_6ck1690 FIND v(dout0_6) AT=850.025n

.meas tran vdout0_7ck1690 FIND v(dout0_7) AT=850.025n

.meas tran vdout0_8ck1690 FIND v(dout0_8) AT=850.025n

.meas tran vdout0_9ck1690 FIND v(dout0_9) AT=850.025n

.meas tran vdout0_10ck1690 FIND v(dout0_10) AT=850.025n

.meas tran vdout0_11ck1690 FIND v(dout0_11) AT=850.025n

.meas tran vdout0_12ck1690 FIND v(dout0_12) AT=850.025n

.meas tran vdout0_13ck1690 FIND v(dout0_13) AT=850.025n

.meas tran vdout0_14ck1690 FIND v(dout0_14) AT=850.025n

.meas tran vdout0_15ck1690 FIND v(dout0_15) AT=850.025n

.meas tran vdout0_16ck1690 FIND v(dout0_16) AT=850.025n

.meas tran vdout0_17ck1690 FIND v(dout0_17) AT=850.025n

.meas tran vdout0_18ck1690 FIND v(dout0_18) AT=850.025n

.meas tran vdout0_19ck1690 FIND v(dout0_19) AT=850.025n

.meas tran vdout0_20ck1690 FIND v(dout0_20) AT=850.025n

.meas tran vdout0_0ck1700 FIND v(dout0_0) AT=855.025n

.meas tran vdout0_1ck1700 FIND v(dout0_1) AT=855.025n

.meas tran vdout0_2ck1700 FIND v(dout0_2) AT=855.025n

.meas tran vdout0_3ck1700 FIND v(dout0_3) AT=855.025n

.meas tran vdout0_4ck1700 FIND v(dout0_4) AT=855.025n

.meas tran vdout0_5ck1700 FIND v(dout0_5) AT=855.025n

.meas tran vdout0_6ck1700 FIND v(dout0_6) AT=855.025n

.meas tran vdout0_7ck1700 FIND v(dout0_7) AT=855.025n

.meas tran vdout0_8ck1700 FIND v(dout0_8) AT=855.025n

.meas tran vdout0_9ck1700 FIND v(dout0_9) AT=855.025n

.meas tran vdout0_10ck1700 FIND v(dout0_10) AT=855.025n

.meas tran vdout0_11ck1700 FIND v(dout0_11) AT=855.025n

.meas tran vdout0_12ck1700 FIND v(dout0_12) AT=855.025n

.meas tran vdout0_13ck1700 FIND v(dout0_13) AT=855.025n

.meas tran vdout0_14ck1700 FIND v(dout0_14) AT=855.025n

.meas tran vdout0_15ck1700 FIND v(dout0_15) AT=855.025n

.meas tran vdout0_16ck1700 FIND v(dout0_16) AT=855.025n

.meas tran vdout0_17ck1700 FIND v(dout0_17) AT=855.025n

.meas tran vdout0_18ck1700 FIND v(dout0_18) AT=855.025n

.meas tran vdout0_19ck1700 FIND v(dout0_19) AT=855.025n

.meas tran vdout0_20ck1700 FIND v(dout0_20) AT=855.025n

.meas tran vdout0_0ck1720 FIND v(dout0_0) AT=865.025n

.meas tran vdout0_1ck1720 FIND v(dout0_1) AT=865.025n

.meas tran vdout0_2ck1720 FIND v(dout0_2) AT=865.025n

.meas tran vdout0_3ck1720 FIND v(dout0_3) AT=865.025n

.meas tran vdout0_4ck1720 FIND v(dout0_4) AT=865.025n

.meas tran vdout0_5ck1720 FIND v(dout0_5) AT=865.025n

.meas tran vdout0_6ck1720 FIND v(dout0_6) AT=865.025n

.meas tran vdout0_7ck1720 FIND v(dout0_7) AT=865.025n

.meas tran vdout0_8ck1720 FIND v(dout0_8) AT=865.025n

.meas tran vdout0_9ck1720 FIND v(dout0_9) AT=865.025n

.meas tran vdout0_10ck1720 FIND v(dout0_10) AT=865.025n

.meas tran vdout0_11ck1720 FIND v(dout0_11) AT=865.025n

.meas tran vdout0_12ck1720 FIND v(dout0_12) AT=865.025n

.meas tran vdout0_13ck1720 FIND v(dout0_13) AT=865.025n

.meas tran vdout0_14ck1720 FIND v(dout0_14) AT=865.025n

.meas tran vdout0_15ck1720 FIND v(dout0_15) AT=865.025n

.meas tran vdout0_16ck1720 FIND v(dout0_16) AT=865.025n

.meas tran vdout0_17ck1720 FIND v(dout0_17) AT=865.025n

.meas tran vdout0_18ck1720 FIND v(dout0_18) AT=865.025n

.meas tran vdout0_19ck1720 FIND v(dout0_19) AT=865.025n

.meas tran vdout0_20ck1720 FIND v(dout0_20) AT=865.025n

.meas tran vdout0_0ck1740 FIND v(dout0_0) AT=875.025n

.meas tran vdout0_1ck1740 FIND v(dout0_1) AT=875.025n

.meas tran vdout0_2ck1740 FIND v(dout0_2) AT=875.025n

.meas tran vdout0_3ck1740 FIND v(dout0_3) AT=875.025n

.meas tran vdout0_4ck1740 FIND v(dout0_4) AT=875.025n

.meas tran vdout0_5ck1740 FIND v(dout0_5) AT=875.025n

.meas tran vdout0_6ck1740 FIND v(dout0_6) AT=875.025n

.meas tran vdout0_7ck1740 FIND v(dout0_7) AT=875.025n

.meas tran vdout0_8ck1740 FIND v(dout0_8) AT=875.025n

.meas tran vdout0_9ck1740 FIND v(dout0_9) AT=875.025n

.meas tran vdout0_10ck1740 FIND v(dout0_10) AT=875.025n

.meas tran vdout0_11ck1740 FIND v(dout0_11) AT=875.025n

.meas tran vdout0_12ck1740 FIND v(dout0_12) AT=875.025n

.meas tran vdout0_13ck1740 FIND v(dout0_13) AT=875.025n

.meas tran vdout0_14ck1740 FIND v(dout0_14) AT=875.025n

.meas tran vdout0_15ck1740 FIND v(dout0_15) AT=875.025n

.meas tran vdout0_16ck1740 FIND v(dout0_16) AT=875.025n

.meas tran vdout0_17ck1740 FIND v(dout0_17) AT=875.025n

.meas tran vdout0_18ck1740 FIND v(dout0_18) AT=875.025n

.meas tran vdout0_19ck1740 FIND v(dout0_19) AT=875.025n

.meas tran vdout0_20ck1740 FIND v(dout0_20) AT=875.025n

.meas tran vdout0_0ck1750 FIND v(dout0_0) AT=880.025n

.meas tran vdout0_1ck1750 FIND v(dout0_1) AT=880.025n

.meas tran vdout0_2ck1750 FIND v(dout0_2) AT=880.025n

.meas tran vdout0_3ck1750 FIND v(dout0_3) AT=880.025n

.meas tran vdout0_4ck1750 FIND v(dout0_4) AT=880.025n

.meas tran vdout0_5ck1750 FIND v(dout0_5) AT=880.025n

.meas tran vdout0_6ck1750 FIND v(dout0_6) AT=880.025n

.meas tran vdout0_7ck1750 FIND v(dout0_7) AT=880.025n

.meas tran vdout0_8ck1750 FIND v(dout0_8) AT=880.025n

.meas tran vdout0_9ck1750 FIND v(dout0_9) AT=880.025n

.meas tran vdout0_10ck1750 FIND v(dout0_10) AT=880.025n

.meas tran vdout0_11ck1750 FIND v(dout0_11) AT=880.025n

.meas tran vdout0_12ck1750 FIND v(dout0_12) AT=880.025n

.meas tran vdout0_13ck1750 FIND v(dout0_13) AT=880.025n

.meas tran vdout0_14ck1750 FIND v(dout0_14) AT=880.025n

.meas tran vdout0_15ck1750 FIND v(dout0_15) AT=880.025n

.meas tran vdout0_16ck1750 FIND v(dout0_16) AT=880.025n

.meas tran vdout0_17ck1750 FIND v(dout0_17) AT=880.025n

.meas tran vdout0_18ck1750 FIND v(dout0_18) AT=880.025n

.meas tran vdout0_19ck1750 FIND v(dout0_19) AT=880.025n

.meas tran vdout0_20ck1750 FIND v(dout0_20) AT=880.025n

.meas tran vdout0_0ck1790 FIND v(dout0_0) AT=900.025n

.meas tran vdout0_1ck1790 FIND v(dout0_1) AT=900.025n

.meas tran vdout0_2ck1790 FIND v(dout0_2) AT=900.025n

.meas tran vdout0_3ck1790 FIND v(dout0_3) AT=900.025n

.meas tran vdout0_4ck1790 FIND v(dout0_4) AT=900.025n

.meas tran vdout0_5ck1790 FIND v(dout0_5) AT=900.025n

.meas tran vdout0_6ck1790 FIND v(dout0_6) AT=900.025n

.meas tran vdout0_7ck1790 FIND v(dout0_7) AT=900.025n

.meas tran vdout0_8ck1790 FIND v(dout0_8) AT=900.025n

.meas tran vdout0_9ck1790 FIND v(dout0_9) AT=900.025n

.meas tran vdout0_10ck1790 FIND v(dout0_10) AT=900.025n

.meas tran vdout0_11ck1790 FIND v(dout0_11) AT=900.025n

.meas tran vdout0_12ck1790 FIND v(dout0_12) AT=900.025n

.meas tran vdout0_13ck1790 FIND v(dout0_13) AT=900.025n

.meas tran vdout0_14ck1790 FIND v(dout0_14) AT=900.025n

.meas tran vdout0_15ck1790 FIND v(dout0_15) AT=900.025n

.meas tran vdout0_16ck1790 FIND v(dout0_16) AT=900.025n

.meas tran vdout0_17ck1790 FIND v(dout0_17) AT=900.025n

.meas tran vdout0_18ck1790 FIND v(dout0_18) AT=900.025n

.meas tran vdout0_19ck1790 FIND v(dout0_19) AT=900.025n

.meas tran vdout0_20ck1790 FIND v(dout0_20) AT=900.025n

.meas tran vdout0_0ck1800 FIND v(dout0_0) AT=905.025n

.meas tran vdout0_1ck1800 FIND v(dout0_1) AT=905.025n

.meas tran vdout0_2ck1800 FIND v(dout0_2) AT=905.025n

.meas tran vdout0_3ck1800 FIND v(dout0_3) AT=905.025n

.meas tran vdout0_4ck1800 FIND v(dout0_4) AT=905.025n

.meas tran vdout0_5ck1800 FIND v(dout0_5) AT=905.025n

.meas tran vdout0_6ck1800 FIND v(dout0_6) AT=905.025n

.meas tran vdout0_7ck1800 FIND v(dout0_7) AT=905.025n

.meas tran vdout0_8ck1800 FIND v(dout0_8) AT=905.025n

.meas tran vdout0_9ck1800 FIND v(dout0_9) AT=905.025n

.meas tran vdout0_10ck1800 FIND v(dout0_10) AT=905.025n

.meas tran vdout0_11ck1800 FIND v(dout0_11) AT=905.025n

.meas tran vdout0_12ck1800 FIND v(dout0_12) AT=905.025n

.meas tran vdout0_13ck1800 FIND v(dout0_13) AT=905.025n

.meas tran vdout0_14ck1800 FIND v(dout0_14) AT=905.025n

.meas tran vdout0_15ck1800 FIND v(dout0_15) AT=905.025n

.meas tran vdout0_16ck1800 FIND v(dout0_16) AT=905.025n

.meas tran vdout0_17ck1800 FIND v(dout0_17) AT=905.025n

.meas tran vdout0_18ck1800 FIND v(dout0_18) AT=905.025n

.meas tran vdout0_19ck1800 FIND v(dout0_19) AT=905.025n

.meas tran vdout0_20ck1800 FIND v(dout0_20) AT=905.025n

.meas tran vdout0_0ck1810 FIND v(dout0_0) AT=910.025n

.meas tran vdout0_1ck1810 FIND v(dout0_1) AT=910.025n

.meas tran vdout0_2ck1810 FIND v(dout0_2) AT=910.025n

.meas tran vdout0_3ck1810 FIND v(dout0_3) AT=910.025n

.meas tran vdout0_4ck1810 FIND v(dout0_4) AT=910.025n

.meas tran vdout0_5ck1810 FIND v(dout0_5) AT=910.025n

.meas tran vdout0_6ck1810 FIND v(dout0_6) AT=910.025n

.meas tran vdout0_7ck1810 FIND v(dout0_7) AT=910.025n

.meas tran vdout0_8ck1810 FIND v(dout0_8) AT=910.025n

.meas tran vdout0_9ck1810 FIND v(dout0_9) AT=910.025n

.meas tran vdout0_10ck1810 FIND v(dout0_10) AT=910.025n

.meas tran vdout0_11ck1810 FIND v(dout0_11) AT=910.025n

.meas tran vdout0_12ck1810 FIND v(dout0_12) AT=910.025n

.meas tran vdout0_13ck1810 FIND v(dout0_13) AT=910.025n

.meas tran vdout0_14ck1810 FIND v(dout0_14) AT=910.025n

.meas tran vdout0_15ck1810 FIND v(dout0_15) AT=910.025n

.meas tran vdout0_16ck1810 FIND v(dout0_16) AT=910.025n

.meas tran vdout0_17ck1810 FIND v(dout0_17) AT=910.025n

.meas tran vdout0_18ck1810 FIND v(dout0_18) AT=910.025n

.meas tran vdout0_19ck1810 FIND v(dout0_19) AT=910.025n

.meas tran vdout0_20ck1810 FIND v(dout0_20) AT=910.025n

.meas tran vdout0_0ck1830 FIND v(dout0_0) AT=920.025n

.meas tran vdout0_1ck1830 FIND v(dout0_1) AT=920.025n

.meas tran vdout0_2ck1830 FIND v(dout0_2) AT=920.025n

.meas tran vdout0_3ck1830 FIND v(dout0_3) AT=920.025n

.meas tran vdout0_4ck1830 FIND v(dout0_4) AT=920.025n

.meas tran vdout0_5ck1830 FIND v(dout0_5) AT=920.025n

.meas tran vdout0_6ck1830 FIND v(dout0_6) AT=920.025n

.meas tran vdout0_7ck1830 FIND v(dout0_7) AT=920.025n

.meas tran vdout0_8ck1830 FIND v(dout0_8) AT=920.025n

.meas tran vdout0_9ck1830 FIND v(dout0_9) AT=920.025n

.meas tran vdout0_10ck1830 FIND v(dout0_10) AT=920.025n

.meas tran vdout0_11ck1830 FIND v(dout0_11) AT=920.025n

.meas tran vdout0_12ck1830 FIND v(dout0_12) AT=920.025n

.meas tran vdout0_13ck1830 FIND v(dout0_13) AT=920.025n

.meas tran vdout0_14ck1830 FIND v(dout0_14) AT=920.025n

.meas tran vdout0_15ck1830 FIND v(dout0_15) AT=920.025n

.meas tran vdout0_16ck1830 FIND v(dout0_16) AT=920.025n

.meas tran vdout0_17ck1830 FIND v(dout0_17) AT=920.025n

.meas tran vdout0_18ck1830 FIND v(dout0_18) AT=920.025n

.meas tran vdout0_19ck1830 FIND v(dout0_19) AT=920.025n

.meas tran vdout0_20ck1830 FIND v(dout0_20) AT=920.025n

.meas tran vdout0_0ck1850 FIND v(dout0_0) AT=930.025n

.meas tran vdout0_1ck1850 FIND v(dout0_1) AT=930.025n

.meas tran vdout0_2ck1850 FIND v(dout0_2) AT=930.025n

.meas tran vdout0_3ck1850 FIND v(dout0_3) AT=930.025n

.meas tran vdout0_4ck1850 FIND v(dout0_4) AT=930.025n

.meas tran vdout0_5ck1850 FIND v(dout0_5) AT=930.025n

.meas tran vdout0_6ck1850 FIND v(dout0_6) AT=930.025n

.meas tran vdout0_7ck1850 FIND v(dout0_7) AT=930.025n

.meas tran vdout0_8ck1850 FIND v(dout0_8) AT=930.025n

.meas tran vdout0_9ck1850 FIND v(dout0_9) AT=930.025n

.meas tran vdout0_10ck1850 FIND v(dout0_10) AT=930.025n

.meas tran vdout0_11ck1850 FIND v(dout0_11) AT=930.025n

.meas tran vdout0_12ck1850 FIND v(dout0_12) AT=930.025n

.meas tran vdout0_13ck1850 FIND v(dout0_13) AT=930.025n

.meas tran vdout0_14ck1850 FIND v(dout0_14) AT=930.025n

.meas tran vdout0_15ck1850 FIND v(dout0_15) AT=930.025n

.meas tran vdout0_16ck1850 FIND v(dout0_16) AT=930.025n

.meas tran vdout0_17ck1850 FIND v(dout0_17) AT=930.025n

.meas tran vdout0_18ck1850 FIND v(dout0_18) AT=930.025n

.meas tran vdout0_19ck1850 FIND v(dout0_19) AT=930.025n

.meas tran vdout0_20ck1850 FIND v(dout0_20) AT=930.025n

.meas tran vdout0_0ck1880 FIND v(dout0_0) AT=945.025n

.meas tran vdout0_1ck1880 FIND v(dout0_1) AT=945.025n

.meas tran vdout0_2ck1880 FIND v(dout0_2) AT=945.025n

.meas tran vdout0_3ck1880 FIND v(dout0_3) AT=945.025n

.meas tran vdout0_4ck1880 FIND v(dout0_4) AT=945.025n

.meas tran vdout0_5ck1880 FIND v(dout0_5) AT=945.025n

.meas tran vdout0_6ck1880 FIND v(dout0_6) AT=945.025n

.meas tran vdout0_7ck1880 FIND v(dout0_7) AT=945.025n

.meas tran vdout0_8ck1880 FIND v(dout0_8) AT=945.025n

.meas tran vdout0_9ck1880 FIND v(dout0_9) AT=945.025n

.meas tran vdout0_10ck1880 FIND v(dout0_10) AT=945.025n

.meas tran vdout0_11ck1880 FIND v(dout0_11) AT=945.025n

.meas tran vdout0_12ck1880 FIND v(dout0_12) AT=945.025n

.meas tran vdout0_13ck1880 FIND v(dout0_13) AT=945.025n

.meas tran vdout0_14ck1880 FIND v(dout0_14) AT=945.025n

.meas tran vdout0_15ck1880 FIND v(dout0_15) AT=945.025n

.meas tran vdout0_16ck1880 FIND v(dout0_16) AT=945.025n

.meas tran vdout0_17ck1880 FIND v(dout0_17) AT=945.025n

.meas tran vdout0_18ck1880 FIND v(dout0_18) AT=945.025n

.meas tran vdout0_19ck1880 FIND v(dout0_19) AT=945.025n

.meas tran vdout0_20ck1880 FIND v(dout0_20) AT=945.025n

.meas tran vdout0_0ck1910 FIND v(dout0_0) AT=960.025n

.meas tran vdout0_1ck1910 FIND v(dout0_1) AT=960.025n

.meas tran vdout0_2ck1910 FIND v(dout0_2) AT=960.025n

.meas tran vdout0_3ck1910 FIND v(dout0_3) AT=960.025n

.meas tran vdout0_4ck1910 FIND v(dout0_4) AT=960.025n

.meas tran vdout0_5ck1910 FIND v(dout0_5) AT=960.025n

.meas tran vdout0_6ck1910 FIND v(dout0_6) AT=960.025n

.meas tran vdout0_7ck1910 FIND v(dout0_7) AT=960.025n

.meas tran vdout0_8ck1910 FIND v(dout0_8) AT=960.025n

.meas tran vdout0_9ck1910 FIND v(dout0_9) AT=960.025n

.meas tran vdout0_10ck1910 FIND v(dout0_10) AT=960.025n

.meas tran vdout0_11ck1910 FIND v(dout0_11) AT=960.025n

.meas tran vdout0_12ck1910 FIND v(dout0_12) AT=960.025n

.meas tran vdout0_13ck1910 FIND v(dout0_13) AT=960.025n

.meas tran vdout0_14ck1910 FIND v(dout0_14) AT=960.025n

.meas tran vdout0_15ck1910 FIND v(dout0_15) AT=960.025n

.meas tran vdout0_16ck1910 FIND v(dout0_16) AT=960.025n

.meas tran vdout0_17ck1910 FIND v(dout0_17) AT=960.025n

.meas tran vdout0_18ck1910 FIND v(dout0_18) AT=960.025n

.meas tran vdout0_19ck1910 FIND v(dout0_19) AT=960.025n

.meas tran vdout0_20ck1910 FIND v(dout0_20) AT=960.025n

.meas tran vdout0_0ck1930 FIND v(dout0_0) AT=970.025n

.meas tran vdout0_1ck1930 FIND v(dout0_1) AT=970.025n

.meas tran vdout0_2ck1930 FIND v(dout0_2) AT=970.025n

.meas tran vdout0_3ck1930 FIND v(dout0_3) AT=970.025n

.meas tran vdout0_4ck1930 FIND v(dout0_4) AT=970.025n

.meas tran vdout0_5ck1930 FIND v(dout0_5) AT=970.025n

.meas tran vdout0_6ck1930 FIND v(dout0_6) AT=970.025n

.meas tran vdout0_7ck1930 FIND v(dout0_7) AT=970.025n

.meas tran vdout0_8ck1930 FIND v(dout0_8) AT=970.025n

.meas tran vdout0_9ck1930 FIND v(dout0_9) AT=970.025n

.meas tran vdout0_10ck1930 FIND v(dout0_10) AT=970.025n

.meas tran vdout0_11ck1930 FIND v(dout0_11) AT=970.025n

.meas tran vdout0_12ck1930 FIND v(dout0_12) AT=970.025n

.meas tran vdout0_13ck1930 FIND v(dout0_13) AT=970.025n

.meas tran vdout0_14ck1930 FIND v(dout0_14) AT=970.025n

.meas tran vdout0_15ck1930 FIND v(dout0_15) AT=970.025n

.meas tran vdout0_16ck1930 FIND v(dout0_16) AT=970.025n

.meas tran vdout0_17ck1930 FIND v(dout0_17) AT=970.025n

.meas tran vdout0_18ck1930 FIND v(dout0_18) AT=970.025n

.meas tran vdout0_19ck1930 FIND v(dout0_19) AT=970.025n

.meas tran vdout0_20ck1930 FIND v(dout0_20) AT=970.025n

.meas tran vdout0_0ck1940 FIND v(dout0_0) AT=975.025n

.meas tran vdout0_1ck1940 FIND v(dout0_1) AT=975.025n

.meas tran vdout0_2ck1940 FIND v(dout0_2) AT=975.025n

.meas tran vdout0_3ck1940 FIND v(dout0_3) AT=975.025n

.meas tran vdout0_4ck1940 FIND v(dout0_4) AT=975.025n

.meas tran vdout0_5ck1940 FIND v(dout0_5) AT=975.025n

.meas tran vdout0_6ck1940 FIND v(dout0_6) AT=975.025n

.meas tran vdout0_7ck1940 FIND v(dout0_7) AT=975.025n

.meas tran vdout0_8ck1940 FIND v(dout0_8) AT=975.025n

.meas tran vdout0_9ck1940 FIND v(dout0_9) AT=975.025n

.meas tran vdout0_10ck1940 FIND v(dout0_10) AT=975.025n

.meas tran vdout0_11ck1940 FIND v(dout0_11) AT=975.025n

.meas tran vdout0_12ck1940 FIND v(dout0_12) AT=975.025n

.meas tran vdout0_13ck1940 FIND v(dout0_13) AT=975.025n

.meas tran vdout0_14ck1940 FIND v(dout0_14) AT=975.025n

.meas tran vdout0_15ck1940 FIND v(dout0_15) AT=975.025n

.meas tran vdout0_16ck1940 FIND v(dout0_16) AT=975.025n

.meas tran vdout0_17ck1940 FIND v(dout0_17) AT=975.025n

.meas tran vdout0_18ck1940 FIND v(dout0_18) AT=975.025n

.meas tran vdout0_19ck1940 FIND v(dout0_19) AT=975.025n

.meas tran vdout0_20ck1940 FIND v(dout0_20) AT=975.025n

.meas tran vdout0_0ck1950 FIND v(dout0_0) AT=980.025n

.meas tran vdout0_1ck1950 FIND v(dout0_1) AT=980.025n

.meas tran vdout0_2ck1950 FIND v(dout0_2) AT=980.025n

.meas tran vdout0_3ck1950 FIND v(dout0_3) AT=980.025n

.meas tran vdout0_4ck1950 FIND v(dout0_4) AT=980.025n

.meas tran vdout0_5ck1950 FIND v(dout0_5) AT=980.025n

.meas tran vdout0_6ck1950 FIND v(dout0_6) AT=980.025n

.meas tran vdout0_7ck1950 FIND v(dout0_7) AT=980.025n

.meas tran vdout0_8ck1950 FIND v(dout0_8) AT=980.025n

.meas tran vdout0_9ck1950 FIND v(dout0_9) AT=980.025n

.meas tran vdout0_10ck1950 FIND v(dout0_10) AT=980.025n

.meas tran vdout0_11ck1950 FIND v(dout0_11) AT=980.025n

.meas tran vdout0_12ck1950 FIND v(dout0_12) AT=980.025n

.meas tran vdout0_13ck1950 FIND v(dout0_13) AT=980.025n

.meas tran vdout0_14ck1950 FIND v(dout0_14) AT=980.025n

.meas tran vdout0_15ck1950 FIND v(dout0_15) AT=980.025n

.meas tran vdout0_16ck1950 FIND v(dout0_16) AT=980.025n

.meas tran vdout0_17ck1950 FIND v(dout0_17) AT=980.025n

.meas tran vdout0_18ck1950 FIND v(dout0_18) AT=980.025n

.meas tran vdout0_19ck1950 FIND v(dout0_19) AT=980.025n

.meas tran vdout0_20ck1950 FIND v(dout0_20) AT=980.025n

.meas tran vdout0_0ck1990 FIND v(dout0_0) AT=1000.025n

.meas tran vdout0_1ck1990 FIND v(dout0_1) AT=1000.025n

.meas tran vdout0_2ck1990 FIND v(dout0_2) AT=1000.025n

.meas tran vdout0_3ck1990 FIND v(dout0_3) AT=1000.025n

.meas tran vdout0_4ck1990 FIND v(dout0_4) AT=1000.025n

.meas tran vdout0_5ck1990 FIND v(dout0_5) AT=1000.025n

.meas tran vdout0_6ck1990 FIND v(dout0_6) AT=1000.025n

.meas tran vdout0_7ck1990 FIND v(dout0_7) AT=1000.025n

.meas tran vdout0_8ck1990 FIND v(dout0_8) AT=1000.025n

.meas tran vdout0_9ck1990 FIND v(dout0_9) AT=1000.025n

.meas tran vdout0_10ck1990 FIND v(dout0_10) AT=1000.025n

.meas tran vdout0_11ck1990 FIND v(dout0_11) AT=1000.025n

.meas tran vdout0_12ck1990 FIND v(dout0_12) AT=1000.025n

.meas tran vdout0_13ck1990 FIND v(dout0_13) AT=1000.025n

.meas tran vdout0_14ck1990 FIND v(dout0_14) AT=1000.025n

.meas tran vdout0_15ck1990 FIND v(dout0_15) AT=1000.025n

.meas tran vdout0_16ck1990 FIND v(dout0_16) AT=1000.025n

.meas tran vdout0_17ck1990 FIND v(dout0_17) AT=1000.025n

.meas tran vdout0_18ck1990 FIND v(dout0_18) AT=1000.025n

.meas tran vdout0_19ck1990 FIND v(dout0_19) AT=1000.025n

.meas tran vdout0_20ck1990 FIND v(dout0_20) AT=1000.025n

.meas tran vdout0_0ck2000 FIND v(dout0_0) AT=1005.025n

.meas tran vdout0_1ck2000 FIND v(dout0_1) AT=1005.025n

.meas tran vdout0_2ck2000 FIND v(dout0_2) AT=1005.025n

.meas tran vdout0_3ck2000 FIND v(dout0_3) AT=1005.025n

.meas tran vdout0_4ck2000 FIND v(dout0_4) AT=1005.025n

.meas tran vdout0_5ck2000 FIND v(dout0_5) AT=1005.025n

.meas tran vdout0_6ck2000 FIND v(dout0_6) AT=1005.025n

.meas tran vdout0_7ck2000 FIND v(dout0_7) AT=1005.025n

.meas tran vdout0_8ck2000 FIND v(dout0_8) AT=1005.025n

.meas tran vdout0_9ck2000 FIND v(dout0_9) AT=1005.025n

.meas tran vdout0_10ck2000 FIND v(dout0_10) AT=1005.025n

.meas tran vdout0_11ck2000 FIND v(dout0_11) AT=1005.025n

.meas tran vdout0_12ck2000 FIND v(dout0_12) AT=1005.025n

.meas tran vdout0_13ck2000 FIND v(dout0_13) AT=1005.025n

.meas tran vdout0_14ck2000 FIND v(dout0_14) AT=1005.025n

.meas tran vdout0_15ck2000 FIND v(dout0_15) AT=1005.025n

.meas tran vdout0_16ck2000 FIND v(dout0_16) AT=1005.025n

.meas tran vdout0_17ck2000 FIND v(dout0_17) AT=1005.025n

.meas tran vdout0_18ck2000 FIND v(dout0_18) AT=1005.025n

.meas tran vdout0_19ck2000 FIND v(dout0_19) AT=1005.025n

.meas tran vdout0_20ck2000 FIND v(dout0_20) AT=1005.025n

.meas tran vdout0_0ck2040 FIND v(dout0_0) AT=1025.025n

.meas tran vdout0_1ck2040 FIND v(dout0_1) AT=1025.025n

.meas tran vdout0_2ck2040 FIND v(dout0_2) AT=1025.025n

.meas tran vdout0_3ck2040 FIND v(dout0_3) AT=1025.025n

.meas tran vdout0_4ck2040 FIND v(dout0_4) AT=1025.025n

.meas tran vdout0_5ck2040 FIND v(dout0_5) AT=1025.025n

.meas tran vdout0_6ck2040 FIND v(dout0_6) AT=1025.025n

.meas tran vdout0_7ck2040 FIND v(dout0_7) AT=1025.025n

.meas tran vdout0_8ck2040 FIND v(dout0_8) AT=1025.025n

.meas tran vdout0_9ck2040 FIND v(dout0_9) AT=1025.025n

.meas tran vdout0_10ck2040 FIND v(dout0_10) AT=1025.025n

.meas tran vdout0_11ck2040 FIND v(dout0_11) AT=1025.025n

.meas tran vdout0_12ck2040 FIND v(dout0_12) AT=1025.025n

.meas tran vdout0_13ck2040 FIND v(dout0_13) AT=1025.025n

.meas tran vdout0_14ck2040 FIND v(dout0_14) AT=1025.025n

.meas tran vdout0_15ck2040 FIND v(dout0_15) AT=1025.025n

.meas tran vdout0_16ck2040 FIND v(dout0_16) AT=1025.025n

.meas tran vdout0_17ck2040 FIND v(dout0_17) AT=1025.025n

.meas tran vdout0_18ck2040 FIND v(dout0_18) AT=1025.025n

.meas tran vdout0_19ck2040 FIND v(dout0_19) AT=1025.025n

.meas tran vdout0_20ck2040 FIND v(dout0_20) AT=1025.025n
