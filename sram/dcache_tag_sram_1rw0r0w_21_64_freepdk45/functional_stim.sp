* Functional test stimulus file for 5ns period

* SS process corner
.include "/home/discontentBoron/Projects/OpenRAM/technology/freepdk45/models/tran_models/models_ss/PMOS_VTG.inc"
.include "/home/discontentBoron/Projects/OpenRAM/technology/freepdk45/models/tran_models/models_ss/NMOS_VTG.inc"
.include "/tmp/openram_discontentBoron_5722_temp/sram.sp"

* Global Power Supplies
Vvdd vdd 0 0.95

*Nodes gnd and 0 are the same global ground node in ngspice/hspice/xa. Otherwise, this source may be needed.
Vgnd gnd 0 0.0

* Instantiation of the SRAM
Xdcache_tag_sram_1rw0r0w_21_64_freepdk45 din0_0 din0_1 din0_2 din0_3 din0_4 din0_5 din0_6 din0_7 din0_8 din0_9 din0_10 din0_11 din0_12 din0_13 din0_14 din0_15 din0_16 din0_17 din0_18 din0_19 din0_20 a0_0 a0_1 a0_2 a0_3 a0_4 a0_5 CSB0 WEB0 clk0 dout0_0 dout0_1 dout0_2 dout0_3 dout0_4 dout0_5 dout0_6 dout0_7 dout0_8 dout0_9 dout0_10 dout0_11 dout0_12 dout0_13 dout0_14 dout0_15 dout0_16 dout0_17 dout0_18 dout0_19 dout0_20 vdd gnd dcache_tag_sram_1rw0r0w_21_64_freepdk45

* SRAM output loads
CD00 dout0_0  0 0.8364f
CD01 dout0_1  0 0.8364f
CD02 dout0_2  0 0.8364f
CD03 dout0_3  0 0.8364f
CD04 dout0_4  0 0.8364f
CD05 dout0_5  0 0.8364f
CD06 dout0_6  0 0.8364f
CD07 dout0_7  0 0.8364f
CD08 dout0_8  0 0.8364f
CD09 dout0_9  0 0.8364f
CD010 dout0_10  0 0.8364f
CD011 dout0_11  0 0.8364f
CD012 dout0_12  0 0.8364f
CD013 dout0_13  0 0.8364f
CD014 dout0_14  0 0.8364f
CD015 dout0_15  0 0.8364f
CD016 dout0_16  0 0.8364f
CD017 dout0_17  0 0.8364f
CD018 dout0_18  0 0.8364f
CD019 dout0_19  0 0.8364f
CD020 dout0_20  0 0.8364f

* Important signals for debug
* bl:	xsram:xbank0:bl_0_0
* br:	xsram:xbank0:br_0_0
* s_en:	xsram:s_en
* q:	xsram:xbank0:xbitcell_array:xbitcell_array:xbit_r0_c0:Q
* qbar:	xsram:xbank0:xbitcell_array:xbitcell_array:xbit_r0_c0:Q_bar

* Sequence of operations
*	Idle during cycle 0 (0ns - 5ns)
*	Writing 111110010011101111001  to  address 000000 (from port 0) during cycle 1 (5ns - 10ns)
*	Writing 110110110010101101110  to  address 000001 (from port 0) during cycle 2 (10ns - 15ns)
*	Writing 110110000010000111011  to  address 000001 (from port 0) during cycle 3 (15ns - 20ns)
*	Reading 110110000010000111011 from address 000001 (from port 0) during cycle 4 (20ns - 25ns)
*	Writing 010110101000111000011  to  address 000000 (from port 0) during cycle 6 (30ns - 35ns)
*	Writing 101010011101001101111  to  address 000000 (from port 0) during cycle 9 (45ns - 50ns)
*	Reading 110110000010000111011 from address 000001 (from port 0) during cycle 10 (50ns - 55ns)
*	Reading 101010011101001101111 from address 000000 (from port 0) during cycle 11 (55ns - 60ns)
*	Reading 101010011101001101111 from address 000000 (from port 0) during cycle 12 (60ns - 65ns)
*	Writing 010101010000000011111  to  address 000000 (from port 0) during cycle 13 (65ns - 70ns)
*	Reading 110110000010000111011 from address 000001 (from port 0) during cycle 14 (70ns - 75ns)
*	Reading 110110000010000111011 from address 000001 (from port 0) during cycle 15 (75ns - 80ns)
*	Reading 010101010000000011111 from address 000000 (from port 0) during cycle 16 (80ns - 85ns)
*	Reading 010101010000000011111 from address 000000 (from port 0) during cycle 17 (85ns - 90ns)
*	Reading 010101010000000011111 from address 000000 (from port 0) during cycle 18 (90ns - 95ns)
*	Reading 010101010000000011111 from address 000000 (from port 0) during cycle 19 (95ns - 100ns)
*	Reading 010101010000000011111 from address 000000 (from port 0) during cycle 21 (105ns - 110ns)
*	Reading 010101010000000011111 from address 000000 (from port 0) during cycle 23 (115ns - 120ns)
*	Reading 010101010000000011111 from address 000000 (from port 0) during cycle 24 (120ns - 125ns)
*	Writing 001100000100110110001  to  address 111101 (from port 0) during cycle 25 (125ns - 130ns)
*	Reading 010101010000000011111 from address 000000 (from port 0) during cycle 26 (130ns - 135ns)
*	Reading 010101010000000011111 from address 000000 (from port 0) during cycle 27 (135ns - 140ns)
*	Reading 110110000010000111011 from address 000001 (from port 0) during cycle 29 (145ns - 150ns)
*	Reading 110110000010000111011 from address 000001 (from port 0) during cycle 30 (150ns - 155ns)
*	Writing 001000001111111110000  to  address 111110 (from port 0) during cycle 31 (155ns - 160ns)
*	Reading 110110000010000111011 from address 000001 (from port 0) during cycle 33 (165ns - 170ns)
*	Reading 110110000010000111011 from address 000001 (from port 0) during cycle 35 (175ns - 180ns)
*	Reading 001100000100110110001 from address 111101 (from port 0) during cycle 36 (180ns - 185ns)
*	Writing 000000101100010111101  to  address 000000 (from port 0) during cycle 37 (185ns - 190ns)
*	Reading 110110000010000111011 from address 000001 (from port 0) during cycle 40 (200ns - 205ns)
*	Reading 000000101100010111101 from address 000000 (from port 0) during cycle 41 (205ns - 210ns)
*	Reading 110110000010000111011 from address 000001 (from port 0) during cycle 42 (210ns - 215ns)
*	Writing 001001101000100010000  to  address 111101 (from port 0) during cycle 43 (215ns - 220ns)
*	Writing 010111010110101011011  to  address 111110 (from port 0) during cycle 44 (220ns - 225ns)
*	Writing 011001010001101001011  to  address 000000 (from port 0) during cycle 46 (230ns - 235ns)
*	Reading 110110000010000111011 from address 000001 (from port 0) during cycle 47 (235ns - 240ns)
*	Writing 010011001000100110110  to  address 000001 (from port 0) during cycle 48 (240ns - 245ns)
*	Writing 110010010110000011110  to  address 111110 (from port 0) during cycle 49 (245ns - 250ns)
*	Reading 010011001000100110110 from address 000001 (from port 0) during cycle 50 (250ns - 255ns)
*	Writing 011001100000110010001  to  address 000000 (from port 0) during cycle 52 (260ns - 265ns)
*	Writing 110000010011010011100  to  address 000000 (from port 0) during cycle 53 (265ns - 270ns)
*	Writing 110010011100010111010  to  address 111101 (from port 0) during cycle 57 (285ns - 290ns)
*	Reading 110000010011010011100 from address 000000 (from port 0) during cycle 58 (290ns - 295ns)
*	Reading 110000010011010011100 from address 000000 (from port 0) during cycle 59 (295ns - 300ns)
*	Reading 010011001000100110110 from address 000001 (from port 0) during cycle 60 (300ns - 305ns)
*	Reading 110000010011010011100 from address 000000 (from port 0) during cycle 61 (305ns - 310ns)
*	Reading 010011001000100110110 from address 000001 (from port 0) during cycle 63 (315ns - 320ns)
*	Reading 110010011100010111010 from address 111101 (from port 0) during cycle 69 (345ns - 350ns)
*	Writing 110111101010001000111  to  address 000001 (from port 0) during cycle 71 (355ns - 360ns)
*	Reading 110111101010001000111 from address 000001 (from port 0) during cycle 72 (360ns - 365ns)
*	Writing 010110100001000110001  to  address 000001 (from port 0) during cycle 73 (365ns - 370ns)
*	Writing 100110010100001010101  to  address 000000 (from port 0) during cycle 76 (380ns - 385ns)
*	Reading 110010010110000011110 from address 111110 (from port 0) during cycle 77 (385ns - 390ns)
*	Writing 011010011001101011011  to  address 111101 (from port 0) during cycle 78 (390ns - 395ns)
*	Reading 011010011001101011011 from address 111101 (from port 0) during cycle 79 (395ns - 400ns)
*	Reading 110010010110000011110 from address 111110 (from port 0) during cycle 80 (400ns - 405ns)
*	Writing 111011011100000100101  to  address 111101 (from port 0) during cycle 81 (405ns - 410ns)
*	Reading 100110010100001010101 from address 000000 (from port 0) during cycle 84 (420ns - 425ns)
*	Reading 111011011100000100101 from address 111101 (from port 0) during cycle 85 (425ns - 430ns)
*	Writing 101101000100011101101  to  address 000000 (from port 0) during cycle 86 (430ns - 435ns)
*	Reading 010110100001000110001 from address 000001 (from port 0) during cycle 87 (435ns - 440ns)
*	Reading 101101000100011101101 from address 000000 (from port 0) during cycle 92 (460ns - 465ns)
*	Reading 101101000100011101101 from address 000000 (from port 0) during cycle 93 (465ns - 470ns)
*	Writing 001100110011100001000  to  address 000001 (from port 0) during cycle 94 (470ns - 475ns)
*	Reading 110010010110000011110 from address 111110 (from port 0) during cycle 96 (480ns - 485ns)
*	Writing 111100001100010010111  to  address 111101 (from port 0) during cycle 97 (485ns - 490ns)
*	Writing 011001010101011101101  to  address 000001 (from port 0) during cycle 98 (490ns - 495ns)
*	Reading 101101000100011101101 from address 000000 (from port 0) during cycle 99 (495ns - 500ns)
*	Reading 111100001100010010111 from address 111101 (from port 0) during cycle 100 (500ns - 505ns)
*	Reading 011001010101011101101 from address 000001 (from port 0) during cycle 101 (505ns - 510ns)
*	Reading 111100001100010010111 from address 111101 (from port 0) during cycle 103 (515ns - 520ns)
*	Reading 111100001100010010111 from address 111101 (from port 0) during cycle 105 (525ns - 530ns)
*	Reading 101101000100011101101 from address 000000 (from port 0) during cycle 106 (530ns - 535ns)
*	Reading 101101000100011101101 from address 000000 (from port 0) during cycle 107 (535ns - 540ns)
*	Reading 110010010110000011110 from address 111110 (from port 0) during cycle 108 (540ns - 545ns)
*	Reading 101101000100011101101 from address 000000 (from port 0) during cycle 109 (545ns - 550ns)
*	Reading 110010010110000011110 from address 111110 (from port 0) during cycle 111 (555ns - 560ns)
*	Reading 011001010101011101101 from address 000001 (from port 0) during cycle 113 (565ns - 570ns)
*	Writing 111011100000001011111  to  address 000001 (from port 0) during cycle 116 (580ns - 585ns)
*	Reading 110010010110000011110 from address 111110 (from port 0) during cycle 117 (585ns - 590ns)
*	Writing 110011010011101110000  to  address 000000 (from port 0) during cycle 118 (590ns - 595ns)
*	Writing 011111010110110111100  to  address 111101 (from port 0) during cycle 120 (600ns - 605ns)
*	Reading 111011100000001011111 from address 000001 (from port 0) during cycle 121 (605ns - 610ns)
*	Writing 100010111101001110111  to  address 000001 (from port 0) during cycle 122 (610ns - 615ns)
*	Writing 111001001110010110100  to  address 000001 (from port 0) during cycle 123 (615ns - 620ns)
*	Writing 100010111011100010100  to  address 000001 (from port 0) during cycle 124 (620ns - 625ns)
*	Reading 011111010110110111100 from address 111101 (from port 0) during cycle 125 (625ns - 630ns)
*	Reading 110010010110000011110 from address 111110 (from port 0) during cycle 126 (630ns - 635ns)
*	Reading 110011010011101110000 from address 000000 (from port 0) during cycle 127 (635ns - 640ns)
*	Reading 110010010110000011110 from address 111110 (from port 0) during cycle 128 (640ns - 645ns)
*	Reading 011111010110110111100 from address 111101 (from port 0) during cycle 129 (645ns - 650ns)
*	Reading 100010111011100010100 from address 000001 (from port 0) during cycle 130 (650ns - 655ns)
*	Reading 110010010110000011110 from address 111110 (from port 0) during cycle 131 (655ns - 660ns)
*	Writing 110100100111110001101  to  address 000001 (from port 0) during cycle 132 (660ns - 665ns)
*	Reading 011111010110110111100 from address 111101 (from port 0) during cycle 134 (670ns - 675ns)
*	Writing 110001000101000101100  to  address 111110 (from port 0) during cycle 135 (675ns - 680ns)
*	Reading 110100100111110001101 from address 000001 (from port 0) during cycle 136 (680ns - 685ns)
*	Writing 011011111000010001001  to  address 000001 (from port 0) during cycle 137 (685ns - 690ns)
*	Reading 011011111000010001001 from address 000001 (from port 0) during cycle 140 (700ns - 705ns)
*	Writing 000101111000000001100  to  address 111110 (from port 0) during cycle 141 (705ns - 710ns)
*	Writing 011011010111000101010  to  address 111110 (from port 0) during cycle 142 (710ns - 715ns)
*	Reading 110011010011101110000 from address 000000 (from port 0) during cycle 143 (715ns - 720ns)
*	Reading 011011111000010001001 from address 000001 (from port 0) during cycle 145 (725ns - 730ns)
*	Writing 110100111100010011011  to  address 000001 (from port 0) during cycle 146 (730ns - 735ns)
*	Writing 100101111110010001011  to  address 000000 (from port 0) during cycle 147 (735ns - 740ns)
*	Writing 010010011011000000010  to  address 000000 (from port 0) during cycle 148 (740ns - 745ns)
*	Reading 110100111100010011011 from address 000001 (from port 0) during cycle 149 (745ns - 750ns)
*	Reading 010010011011000000010 from address 000000 (from port 0) during cycle 150 (750ns - 755ns)
*	Reading 011011010111000101010 from address 111110 (from port 0) during cycle 152 (760ns - 765ns)
*	Reading 011111010110110111100 from address 111101 (from port 0) during cycle 154 (770ns - 775ns)
*	Writing 000111101011011101101  to  address 111101 (from port 0) during cycle 156 (780ns - 785ns)
*	Reading 000111101011011101101 from address 111101 (from port 0) during cycle 157 (785ns - 790ns)
*	Reading 110100111100010011011 from address 000001 (from port 0) during cycle 158 (790ns - 795ns)
*	Reading 010010011011000000010 from address 000000 (from port 0) during cycle 159 (795ns - 800ns)
*	Writing 000101011001000001010  to  address 000001 (from port 0) during cycle 160 (800ns - 805ns)
*	Reading 000111101011011101101 from address 111101 (from port 0) during cycle 162 (810ns - 815ns)
*	Reading 011011010111000101010 from address 111110 (from port 0) during cycle 163 (815ns - 820ns)
*	Writing 001110010111011101110  to  address 000001 (from port 0) during cycle 164 (820ns - 825ns)
*	Reading 000111101011011101101 from address 111101 (from port 0) during cycle 165 (825ns - 830ns)
*	Writing 100001001101100000101  to  address 111101 (from port 0) during cycle 166 (830ns - 835ns)
*	Reading 011011010111000101010 from address 111110 (from port 0) during cycle 169 (845ns - 850ns)
*	Reading 011011010111000101010 from address 111110 (from port 0) during cycle 170 (850ns - 855ns)
*	Writing 011011110001011100111  to  address 000001 (from port 0) during cycle 171 (855ns - 860ns)
*	Reading 010010011011000000010 from address 000000 (from port 0) during cycle 172 (860ns - 865ns)
*	Reading 011011110001011100111 from address 000001 (from port 0) during cycle 174 (870ns - 875ns)
*	Reading 100001001101100000101 from address 111101 (from port 0) during cycle 175 (875ns - 880ns)
*	Writing 000101110011111101111  to  address 111110 (from port 0) during cycle 176 (880ns - 885ns)
*	Writing 110100000101000100011  to  address 111101 (from port 0) during cycle 178 (890ns - 895ns)
*	Reading 010010011011000000010 from address 000000 (from port 0) during cycle 179 (895ns - 900ns)
*	Reading 000101110011111101111 from address 111110 (from port 0) during cycle 180 (900ns - 905ns)
*	Reading 110100000101000100011 from address 111101 (from port 0) during cycle 181 (905ns - 910ns)
*	Writing 010100010110111000101  to  address 000000 (from port 0) during cycle 182 (910ns - 915ns)
*	Reading 011011110001011100111 from address 000001 (from port 0) during cycle 183 (915ns - 920ns)
*	Writing 010111111110001000000  to  address 000000 (from port 0) during cycle 184 (920ns - 925ns)
*	Reading 011011110001011100111 from address 000001 (from port 0) during cycle 185 (925ns - 930ns)
*	Reading 000101110011111101111 from address 111110 (from port 0) during cycle 188 (940ns - 945ns)
*	Writing 000110000000000000000  to  address 000001 (from port 0) during cycle 189 (945ns - 950ns)
*	Writing 100000101100001000010  to  address 000000 (from port 0) during cycle 190 (950ns - 955ns)
*	Reading 000110000000000000000 from address 000001 (from port 0) during cycle 191 (955ns - 960ns)
*	Writing 111110011000001001110  to  address 000000 (from port 0) during cycle 192 (960ns - 965ns)
*	Reading 111110011000001001110 from address 000000 (from port 0) during cycle 193 (965ns - 970ns)
*	Reading 111110011000001001110 from address 000000 (from port 0) during cycle 194 (970ns - 975ns)
*	Reading 000110000000000000000 from address 000001 (from port 0) during cycle 195 (975ns - 980ns)
*	Writing 110010011111000000001  to  address 000001 (from port 0) during cycle 197 (985ns - 990ns)
*	Reading 110100000101000100011 from address 111101 (from port 0) during cycle 199 (995ns - 1000ns)
*	Reading 000101110011111101111 from address 111110 (from port 0) during cycle 200 (1000ns - 1005ns)
*	Writing 011100010000110001111  to  address 000000 (from port 0) during cycle 201 (1005ns - 1010ns)
*	Reading 000101110011111101111 from address 111110 (from port 0) during cycle 204 (1020ns - 1025ns)
*	Idle during cycle 205 (1025ns - 1030ns)

* Generation of data and address signals
* (time, data): [(0, 0), (5, 1), (10, 0), (15, 1), (20, 1), (25, 1), (30, 1), (35, 1), (40, 1), (45, 1), (50, 1), (55, 1), (60, 1), (65, 1), (70, 1), (75, 1), (80, 1), (85, 1), (90, 1), (95, 1), (100, 1), (105, 1), (110, 1), (115, 1), (120, 1), (125, 1), (130, 1), (135, 1), (140, 1), (145, 1), (150, 1), (155, 0), (160, 0), (165, 0), (170, 0), (175, 0), (180, 0), (185, 1), (190, 1), (195, 1), (200, 1), (205, 1), (210, 1), (215, 0), (220, 1), (225, 1), (230, 1), (235, 1), (240, 0), (245, 0), (250, 0), (255, 0), (260, 1), (265, 0), (270, 0), (275, 0), (280, 0), (285, 0), (290, 0), (295, 0), (300, 0), (305, 0), (310, 0), (315, 0), (320, 0), (325, 0), (330, 0), (335, 0), (340, 0), (345, 0), (350, 0), (355, 1), (360, 1), (365, 1), (370, 1), (375, 1), (380, 1), (385, 1), (390, 1), (395, 1), (400, 1), (405, 1), (410, 1), (415, 1), (420, 1), (425, 1), (430, 1), (435, 1), (440, 1), (445, 1), (450, 1), (455, 1), (460, 1), (465, 1), (470, 0), (475, 0), (480, 0), (485, 1), (490, 1), (495, 1), (500, 1), (505, 1), (510, 1), (515, 1), (520, 1), (525, 1), (530, 1), (535, 1), (540, 1), (545, 1), (550, 1), (555, 1), (560, 1), (565, 1), (570, 1), (575, 1), (580, 1), (585, 1), (590, 0), (595, 0), (600, 0), (605, 0), (610, 1), (615, 0), (620, 0), (625, 0), (630, 0), (635, 0), (640, 0), (645, 0), (650, 0), (655, 0), (660, 1), (665, 1), (670, 1), (675, 0), (680, 0), (685, 1), (690, 1), (695, 1), (700, 1), (705, 0), (710, 0), (715, 0), (720, 0), (725, 0), (730, 1), (735, 1), (740, 0), (745, 0), (750, 0), (755, 0), (760, 0), (765, 0), (770, 0), (775, 0), (780, 1), (785, 1), (790, 1), (795, 1), (800, 0), (805, 0), (810, 0), (815, 0), (820, 0), (825, 0), (830, 1), (835, 1), (840, 1), (845, 1), (850, 1), (855, 1), (860, 1), (865, 1), (870, 1), (875, 1), (880, 1), (885, 1), (890, 1), (895, 1), (900, 1), (905, 1), (910, 1), (915, 1), (920, 0), (925, 0), (930, 0), (935, 0), (940, 0), (945, 0), (950, 0), (955, 0), (960, 0), (965, 0), (970, 0), (975, 0), (980, 0), (985, 1), (990, 1), (995, 1), (1000, 1), (1005, 1), (1010, 1), (1015, 1), (1020, 1), (1025, 1)]
Vdin0_0  din0_0  0 PWL (0n 0.0v 4.745n 0.0v 4.755n 0.95v 9.745n 0.95v 9.755n 0.0v 14.745n 0.0v 14.755n 0.95v 19.745n 0.95v 19.755n 0.95v 24.745n 0.95v 24.755n 0.95v 29.745n 0.95v 29.755n 0.95v 34.745n 0.95v 34.755n 0.95v 39.745n 0.95v 39.755n 0.95v 44.745n 0.95v 44.755n 0.95v 49.745n 0.95v 49.755n 0.95v 54.745n 0.95v 54.755n 0.95v 59.745n 0.95v 59.755n 0.95v 64.745n 0.95v 64.755n 0.95v 69.745n 0.95v 69.755n 0.95v 74.745n 0.95v 74.755n 0.95v 79.745n 0.95v 79.755n 0.95v 84.745n 0.95v 84.755n 0.95v 89.745n 0.95v 89.755n 0.95v 94.745n 0.95v 94.755n 0.95v 99.745n 0.95v 99.755n 0.95v 104.745n 0.95v 104.755n 0.95v 109.745n 0.95v 109.755n 0.95v 114.745n 0.95v 114.755n 0.95v 119.745n 0.95v 119.755n 0.95v 124.745n 0.95v 124.755n 0.95v 129.745n 0.95v 129.755n 0.95v 134.745n 0.95v 134.755n 0.95v 139.745n 0.95v 139.755n 0.95v 144.745n 0.95v 144.755n 0.95v 149.745n 0.95v 149.755n 0.95v 154.745n 0.95v 154.755n 0.0v 159.745n 0.0v 159.755n 0.0v 164.745n 0.0v 164.755n 0.0v 169.745n 0.0v 169.755n 0.0v 174.745n 0.0v 174.755n 0.0v 179.745n 0.0v 179.755n 0.0v 184.745n 0.0v 184.755n 0.95v 189.745n 0.95v 189.755n 0.95v 194.745n 0.95v 194.755n 0.95v 199.745n 0.95v 199.755n 0.95v 204.745n 0.95v 204.755n 0.95v 209.745n 0.95v 209.755n 0.95v 214.745n 0.95v 214.755n 0.0v 219.745n 0.0v 219.755n 0.95v 224.745n 0.95v 224.755n 0.95v 229.745n 0.95v 229.755n 0.95v 234.745n 0.95v 234.755n 0.95v 239.745n 0.95v 239.755n 0.0v 244.745n 0.0v 244.755n 0.0v 249.745n 0.0v 249.755n 0.0v 254.745n 0.0v 254.755n 0.0v 259.745n 0.0v 259.755n 0.95v 264.745n 0.95v 264.755n 0.0v 269.745n 0.0v 269.755n 0.0v 274.745n 0.0v 274.755n 0.0v 279.745n 0.0v 279.755n 0.0v 284.745n 0.0v 284.755n 0.0v 289.745n 0.0v 289.755n 0.0v 294.745n 0.0v 294.755n 0.0v 299.745n 0.0v 299.755n 0.0v 304.745n 0.0v 304.755n 0.0v 309.745n 0.0v 309.755n 0.0v 314.745n 0.0v 314.755n 0.0v 319.745n 0.0v 319.755n 0.0v 324.745n 0.0v 324.755n 0.0v 329.745n 0.0v 329.755n 0.0v 334.745n 0.0v 334.755n 0.0v 339.745n 0.0v 339.755n 0.0v 344.745n 0.0v 344.755n 0.0v 349.745n 0.0v 349.755n 0.0v 354.745n 0.0v 354.755n 0.95v 359.745n 0.95v 359.755n 0.95v 364.745n 0.95v 364.755n 0.95v 369.745n 0.95v 369.755n 0.95v 374.745n 0.95v 374.755n 0.95v 379.745n 0.95v 379.755n 0.95v 384.745n 0.95v 384.755n 0.95v 389.745n 0.95v 389.755n 0.95v 394.745n 0.95v 394.755n 0.95v 399.745n 0.95v 399.755n 0.95v 404.745n 0.95v 404.755n 0.95v 409.745n 0.95v 409.755n 0.95v 414.745n 0.95v 414.755n 0.95v 419.745n 0.95v 419.755n 0.95v 424.745n 0.95v 424.755n 0.95v 429.745n 0.95v 429.755n 0.95v 434.745n 0.95v 434.755n 0.95v 439.745n 0.95v 439.755n 0.95v 444.745n 0.95v 444.755n 0.95v 449.745n 0.95v 449.755n 0.95v 454.745n 0.95v 454.755n 0.95v 459.745n 0.95v 459.755n 0.95v 464.745n 0.95v 464.755n 0.95v 469.745n 0.95v 469.755n 0.0v 474.745n 0.0v 474.755n 0.0v 479.745n 0.0v 479.755n 0.0v 484.745n 0.0v 484.755n 0.95v 489.745n 0.95v 489.755n 0.95v 494.745n 0.95v 494.755n 0.95v 499.745n 0.95v 499.755n 0.95v 504.745n 0.95v 504.755n 0.95v 509.745n 0.95v 509.755n 0.95v 514.745n 0.95v 514.755n 0.95v 519.745n 0.95v 519.755n 0.95v 524.745n 0.95v 524.755n 0.95v 529.745n 0.95v 529.755n 0.95v 534.745n 0.95v 534.755n 0.95v 539.745n 0.95v 539.755n 0.95v 544.745n 0.95v 544.755n 0.95v 549.745n 0.95v 549.755n 0.95v 554.745n 0.95v 554.755n 0.95v 559.745n 0.95v 559.755n 0.95v 564.745n 0.95v 564.755n 0.95v 569.745n 0.95v 569.755n 0.95v 574.745n 0.95v 574.755n 0.95v 579.745n 0.95v 579.755n 0.95v 584.745n 0.95v 584.755n 0.95v 589.745n 0.95v 589.755n 0.0v 594.745n 0.0v 594.755n 0.0v 599.745n 0.0v 599.755n 0.0v 604.745n 0.0v 604.755n 0.0v 609.745n 0.0v 609.755n 0.95v 614.745n 0.95v 614.755n 0.0v 619.745n 0.0v 619.755n 0.0v 624.745n 0.0v 624.755n 0.0v 629.745n 0.0v 629.755n 0.0v 634.745n 0.0v 634.755n 0.0v 639.745n 0.0v 639.755n 0.0v 644.745n 0.0v 644.755n 0.0v 649.745n 0.0v 649.755n 0.0v 654.745n 0.0v 654.755n 0.0v 659.745n 0.0v 659.755n 0.95v 664.745n 0.95v 664.755n 0.95v 669.745n 0.95v 669.755n 0.95v 674.745n 0.95v 674.755n 0.0v 679.745n 0.0v 679.755n 0.0v 684.745n 0.0v 684.755n 0.95v 689.745n 0.95v 689.755n 0.95v 694.745n 0.95v 694.755n 0.95v 699.745n 0.95v 699.755n 0.95v 704.745n 0.95v 704.755n 0.0v 709.745n 0.0v 709.755n 0.0v 714.745n 0.0v 714.755n 0.0v 719.745n 0.0v 719.755n 0.0v 724.745n 0.0v 724.755n 0.0v 729.745n 0.0v 729.755n 0.95v 734.745n 0.95v 734.755n 0.95v 739.745n 0.95v 739.755n 0.0v 744.745n 0.0v 744.755n 0.0v 749.745n 0.0v 749.755n 0.0v 754.745n 0.0v 754.755n 0.0v 759.745n 0.0v 759.755n 0.0v 764.745n 0.0v 764.755n 0.0v 769.745n 0.0v 769.755n 0.0v 774.745n 0.0v 774.755n 0.0v 779.745n 0.0v 779.755n 0.95v 784.745n 0.95v 784.755n 0.95v 789.745n 0.95v 789.755n 0.95v 794.745n 0.95v 794.755n 0.95v 799.745n 0.95v 799.755n 0.0v 804.745n 0.0v 804.755n 0.0v 809.745n 0.0v 809.755n 0.0v 814.745n 0.0v 814.755n 0.0v 819.745n 0.0v 819.755n 0.0v 824.745n 0.0v 824.755n 0.0v 829.745n 0.0v 829.755n 0.95v 834.745n 0.95v 834.755n 0.95v 839.745n 0.95v 839.755n 0.95v 844.745n 0.95v 844.755n 0.95v 849.745n 0.95v 849.755n 0.95v 854.745n 0.95v 854.755n 0.95v 859.745n 0.95v 859.755n 0.95v 864.745n 0.95v 864.755n 0.95v 869.745n 0.95v 869.755n 0.95v 874.745n 0.95v 874.755n 0.95v 879.745n 0.95v 879.755n 0.95v 884.745n 0.95v 884.755n 0.95v 889.745n 0.95v 889.755n 0.95v 894.745n 0.95v 894.755n 0.95v 899.745n 0.95v 899.755n 0.95v 904.745n 0.95v 904.755n 0.95v 909.745n 0.95v 909.755n 0.95v 914.745n 0.95v 914.755n 0.95v 919.745n 0.95v 919.755n 0.0v 924.745n 0.0v 924.755n 0.0v 929.745n 0.0v 929.755n 0.0v 934.745n 0.0v 934.755n 0.0v 939.745n 0.0v 939.755n 0.0v 944.745n 0.0v 944.755n 0.0v 949.745n 0.0v 949.755n 0.0v 954.745n 0.0v 954.755n 0.0v 959.745n 0.0v 959.755n 0.0v 964.745n 0.0v 964.755n 0.0v 969.745n 0.0v 969.755n 0.0v 974.745n 0.0v 974.755n 0.0v 979.745n 0.0v 979.755n 0.0v 984.745n 0.0v 984.755n 0.95v 989.745n 0.95v 989.755n 0.95v 994.745n 0.95v 994.755n 0.95v 999.745n 0.95v 999.755n 0.95v 1004.745n 0.95v 1004.755n 0.95v 1009.745n 0.95v 1009.755n 0.95v 1014.745n 0.95v 1014.755n 0.95v 1019.745n 0.95v 1019.755n 0.95v 1024.745n 0.95v 1024.755n 0.95v )
* (time, data): [(0, 0), (5, 0), (10, 1), (15, 1), (20, 1), (25, 1), (30, 1), (35, 1), (40, 1), (45, 1), (50, 1), (55, 1), (60, 1), (65, 1), (70, 1), (75, 1), (80, 1), (85, 1), (90, 1), (95, 1), (100, 1), (105, 1), (110, 1), (115, 1), (120, 1), (125, 0), (130, 0), (135, 0), (140, 0), (145, 0), (150, 0), (155, 0), (160, 0), (165, 0), (170, 0), (175, 0), (180, 0), (185, 0), (190, 0), (195, 0), (200, 0), (205, 0), (210, 0), (215, 0), (220, 1), (225, 1), (230, 1), (235, 1), (240, 1), (245, 1), (250, 1), (255, 1), (260, 0), (265, 0), (270, 0), (275, 0), (280, 0), (285, 1), (290, 1), (295, 1), (300, 1), (305, 1), (310, 1), (315, 1), (320, 1), (325, 1), (330, 1), (335, 1), (340, 1), (345, 1), (350, 1), (355, 1), (360, 1), (365, 0), (370, 0), (375, 0), (380, 0), (385, 0), (390, 1), (395, 1), (400, 1), (405, 0), (410, 0), (415, 0), (420, 0), (425, 0), (430, 0), (435, 0), (440, 0), (445, 0), (450, 0), (455, 0), (460, 0), (465, 0), (470, 0), (475, 0), (480, 0), (485, 1), (490, 0), (495, 0), (500, 0), (505, 0), (510, 0), (515, 0), (520, 0), (525, 0), (530, 0), (535, 0), (540, 0), (545, 0), (550, 0), (555, 0), (560, 0), (565, 0), (570, 0), (575, 0), (580, 1), (585, 1), (590, 0), (595, 0), (600, 0), (605, 0), (610, 1), (615, 0), (620, 0), (625, 0), (630, 0), (635, 0), (640, 0), (645, 0), (650, 0), (655, 0), (660, 0), (665, 0), (670, 0), (675, 0), (680, 0), (685, 0), (690, 0), (695, 0), (700, 0), (705, 0), (710, 1), (715, 1), (720, 1), (725, 1), (730, 1), (735, 1), (740, 1), (745, 1), (750, 1), (755, 1), (760, 1), (765, 1), (770, 1), (775, 1), (780, 0), (785, 0), (790, 0), (795, 0), (800, 1), (805, 1), (810, 1), (815, 1), (820, 1), (825, 1), (830, 0), (835, 0), (840, 0), (845, 0), (850, 0), (855, 1), (860, 1), (865, 1), (870, 1), (875, 1), (880, 1), (885, 1), (890, 1), (895, 1), (900, 1), (905, 1), (910, 0), (915, 0), (920, 0), (925, 0), (930, 0), (935, 0), (940, 0), (945, 0), (950, 1), (955, 1), (960, 1), (965, 1), (970, 1), (975, 1), (980, 1), (985, 0), (990, 0), (995, 0), (1000, 0), (1005, 1), (1010, 1), (1015, 1), (1020, 1), (1025, 1)]
Vdin0_1  din0_1  0 PWL (0n 0.0v 4.745n 0.0v 4.755n 0.0v 9.745n 0.0v 9.755n 0.95v 14.745n 0.95v 14.755n 0.95v 19.745n 0.95v 19.755n 0.95v 24.745n 0.95v 24.755n 0.95v 29.745n 0.95v 29.755n 0.95v 34.745n 0.95v 34.755n 0.95v 39.745n 0.95v 39.755n 0.95v 44.745n 0.95v 44.755n 0.95v 49.745n 0.95v 49.755n 0.95v 54.745n 0.95v 54.755n 0.95v 59.745n 0.95v 59.755n 0.95v 64.745n 0.95v 64.755n 0.95v 69.745n 0.95v 69.755n 0.95v 74.745n 0.95v 74.755n 0.95v 79.745n 0.95v 79.755n 0.95v 84.745n 0.95v 84.755n 0.95v 89.745n 0.95v 89.755n 0.95v 94.745n 0.95v 94.755n 0.95v 99.745n 0.95v 99.755n 0.95v 104.745n 0.95v 104.755n 0.95v 109.745n 0.95v 109.755n 0.95v 114.745n 0.95v 114.755n 0.95v 119.745n 0.95v 119.755n 0.95v 124.745n 0.95v 124.755n 0.0v 129.745n 0.0v 129.755n 0.0v 134.745n 0.0v 134.755n 0.0v 139.745n 0.0v 139.755n 0.0v 144.745n 0.0v 144.755n 0.0v 149.745n 0.0v 149.755n 0.0v 154.745n 0.0v 154.755n 0.0v 159.745n 0.0v 159.755n 0.0v 164.745n 0.0v 164.755n 0.0v 169.745n 0.0v 169.755n 0.0v 174.745n 0.0v 174.755n 0.0v 179.745n 0.0v 179.755n 0.0v 184.745n 0.0v 184.755n 0.0v 189.745n 0.0v 189.755n 0.0v 194.745n 0.0v 194.755n 0.0v 199.745n 0.0v 199.755n 0.0v 204.745n 0.0v 204.755n 0.0v 209.745n 0.0v 209.755n 0.0v 214.745n 0.0v 214.755n 0.0v 219.745n 0.0v 219.755n 0.95v 224.745n 0.95v 224.755n 0.95v 229.745n 0.95v 229.755n 0.95v 234.745n 0.95v 234.755n 0.95v 239.745n 0.95v 239.755n 0.95v 244.745n 0.95v 244.755n 0.95v 249.745n 0.95v 249.755n 0.95v 254.745n 0.95v 254.755n 0.95v 259.745n 0.95v 259.755n 0.0v 264.745n 0.0v 264.755n 0.0v 269.745n 0.0v 269.755n 0.0v 274.745n 0.0v 274.755n 0.0v 279.745n 0.0v 279.755n 0.0v 284.745n 0.0v 284.755n 0.95v 289.745n 0.95v 289.755n 0.95v 294.745n 0.95v 294.755n 0.95v 299.745n 0.95v 299.755n 0.95v 304.745n 0.95v 304.755n 0.95v 309.745n 0.95v 309.755n 0.95v 314.745n 0.95v 314.755n 0.95v 319.745n 0.95v 319.755n 0.95v 324.745n 0.95v 324.755n 0.95v 329.745n 0.95v 329.755n 0.95v 334.745n 0.95v 334.755n 0.95v 339.745n 0.95v 339.755n 0.95v 344.745n 0.95v 344.755n 0.95v 349.745n 0.95v 349.755n 0.95v 354.745n 0.95v 354.755n 0.95v 359.745n 0.95v 359.755n 0.95v 364.745n 0.95v 364.755n 0.0v 369.745n 0.0v 369.755n 0.0v 374.745n 0.0v 374.755n 0.0v 379.745n 0.0v 379.755n 0.0v 384.745n 0.0v 384.755n 0.0v 389.745n 0.0v 389.755n 0.95v 394.745n 0.95v 394.755n 0.95v 399.745n 0.95v 399.755n 0.95v 404.745n 0.95v 404.755n 0.0v 409.745n 0.0v 409.755n 0.0v 414.745n 0.0v 414.755n 0.0v 419.745n 0.0v 419.755n 0.0v 424.745n 0.0v 424.755n 0.0v 429.745n 0.0v 429.755n 0.0v 434.745n 0.0v 434.755n 0.0v 439.745n 0.0v 439.755n 0.0v 444.745n 0.0v 444.755n 0.0v 449.745n 0.0v 449.755n 0.0v 454.745n 0.0v 454.755n 0.0v 459.745n 0.0v 459.755n 0.0v 464.745n 0.0v 464.755n 0.0v 469.745n 0.0v 469.755n 0.0v 474.745n 0.0v 474.755n 0.0v 479.745n 0.0v 479.755n 0.0v 484.745n 0.0v 484.755n 0.95v 489.745n 0.95v 489.755n 0.0v 494.745n 0.0v 494.755n 0.0v 499.745n 0.0v 499.755n 0.0v 504.745n 0.0v 504.755n 0.0v 509.745n 0.0v 509.755n 0.0v 514.745n 0.0v 514.755n 0.0v 519.745n 0.0v 519.755n 0.0v 524.745n 0.0v 524.755n 0.0v 529.745n 0.0v 529.755n 0.0v 534.745n 0.0v 534.755n 0.0v 539.745n 0.0v 539.755n 0.0v 544.745n 0.0v 544.755n 0.0v 549.745n 0.0v 549.755n 0.0v 554.745n 0.0v 554.755n 0.0v 559.745n 0.0v 559.755n 0.0v 564.745n 0.0v 564.755n 0.0v 569.745n 0.0v 569.755n 0.0v 574.745n 0.0v 574.755n 0.0v 579.745n 0.0v 579.755n 0.95v 584.745n 0.95v 584.755n 0.95v 589.745n 0.95v 589.755n 0.0v 594.745n 0.0v 594.755n 0.0v 599.745n 0.0v 599.755n 0.0v 604.745n 0.0v 604.755n 0.0v 609.745n 0.0v 609.755n 0.95v 614.745n 0.95v 614.755n 0.0v 619.745n 0.0v 619.755n 0.0v 624.745n 0.0v 624.755n 0.0v 629.745n 0.0v 629.755n 0.0v 634.745n 0.0v 634.755n 0.0v 639.745n 0.0v 639.755n 0.0v 644.745n 0.0v 644.755n 0.0v 649.745n 0.0v 649.755n 0.0v 654.745n 0.0v 654.755n 0.0v 659.745n 0.0v 659.755n 0.0v 664.745n 0.0v 664.755n 0.0v 669.745n 0.0v 669.755n 0.0v 674.745n 0.0v 674.755n 0.0v 679.745n 0.0v 679.755n 0.0v 684.745n 0.0v 684.755n 0.0v 689.745n 0.0v 689.755n 0.0v 694.745n 0.0v 694.755n 0.0v 699.745n 0.0v 699.755n 0.0v 704.745n 0.0v 704.755n 0.0v 709.745n 0.0v 709.755n 0.95v 714.745n 0.95v 714.755n 0.95v 719.745n 0.95v 719.755n 0.95v 724.745n 0.95v 724.755n 0.95v 729.745n 0.95v 729.755n 0.95v 734.745n 0.95v 734.755n 0.95v 739.745n 0.95v 739.755n 0.95v 744.745n 0.95v 744.755n 0.95v 749.745n 0.95v 749.755n 0.95v 754.745n 0.95v 754.755n 0.95v 759.745n 0.95v 759.755n 0.95v 764.745n 0.95v 764.755n 0.95v 769.745n 0.95v 769.755n 0.95v 774.745n 0.95v 774.755n 0.95v 779.745n 0.95v 779.755n 0.0v 784.745n 0.0v 784.755n 0.0v 789.745n 0.0v 789.755n 0.0v 794.745n 0.0v 794.755n 0.0v 799.745n 0.0v 799.755n 0.95v 804.745n 0.95v 804.755n 0.95v 809.745n 0.95v 809.755n 0.95v 814.745n 0.95v 814.755n 0.95v 819.745n 0.95v 819.755n 0.95v 824.745n 0.95v 824.755n 0.95v 829.745n 0.95v 829.755n 0.0v 834.745n 0.0v 834.755n 0.0v 839.745n 0.0v 839.755n 0.0v 844.745n 0.0v 844.755n 0.0v 849.745n 0.0v 849.755n 0.0v 854.745n 0.0v 854.755n 0.95v 859.745n 0.95v 859.755n 0.95v 864.745n 0.95v 864.755n 0.95v 869.745n 0.95v 869.755n 0.95v 874.745n 0.95v 874.755n 0.95v 879.745n 0.95v 879.755n 0.95v 884.745n 0.95v 884.755n 0.95v 889.745n 0.95v 889.755n 0.95v 894.745n 0.95v 894.755n 0.95v 899.745n 0.95v 899.755n 0.95v 904.745n 0.95v 904.755n 0.95v 909.745n 0.95v 909.755n 0.0v 914.745n 0.0v 914.755n 0.0v 919.745n 0.0v 919.755n 0.0v 924.745n 0.0v 924.755n 0.0v 929.745n 0.0v 929.755n 0.0v 934.745n 0.0v 934.755n 0.0v 939.745n 0.0v 939.755n 0.0v 944.745n 0.0v 944.755n 0.0v 949.745n 0.0v 949.755n 0.95v 954.745n 0.95v 954.755n 0.95v 959.745n 0.95v 959.755n 0.95v 964.745n 0.95v 964.755n 0.95v 969.745n 0.95v 969.755n 0.95v 974.745n 0.95v 974.755n 0.95v 979.745n 0.95v 979.755n 0.95v 984.745n 0.95v 984.755n 0.0v 989.745n 0.0v 989.755n 0.0v 994.745n 0.0v 994.755n 0.0v 999.745n 0.0v 999.755n 0.0v 1004.745n 0.0v 1004.755n 0.95v 1009.745n 0.95v 1009.755n 0.95v 1014.745n 0.95v 1014.755n 0.95v 1019.745n 0.95v 1019.755n 0.95v 1024.745n 0.95v 1024.755n 0.95v )
* (time, data): [(0, 0), (5, 0), (10, 1), (15, 0), (20, 0), (25, 0), (30, 0), (35, 0), (40, 0), (45, 1), (50, 1), (55, 1), (60, 1), (65, 1), (70, 1), (75, 1), (80, 1), (85, 1), (90, 1), (95, 1), (100, 1), (105, 1), (110, 1), (115, 1), (120, 1), (125, 0), (130, 0), (135, 0), (140, 0), (145, 0), (150, 0), (155, 0), (160, 0), (165, 0), (170, 0), (175, 0), (180, 0), (185, 1), (190, 1), (195, 1), (200, 1), (205, 1), (210, 1), (215, 0), (220, 0), (225, 0), (230, 0), (235, 0), (240, 1), (245, 1), (250, 1), (255, 1), (260, 0), (265, 1), (270, 1), (275, 1), (280, 1), (285, 0), (290, 0), (295, 0), (300, 0), (305, 0), (310, 0), (315, 0), (320, 0), (325, 0), (330, 0), (335, 0), (340, 0), (345, 0), (350, 0), (355, 1), (360, 1), (365, 0), (370, 0), (375, 0), (380, 1), (385, 1), (390, 0), (395, 0), (400, 0), (405, 1), (410, 1), (415, 1), (420, 1), (425, 1), (430, 1), (435, 1), (440, 1), (445, 1), (450, 1), (455, 1), (460, 1), (465, 1), (470, 0), (475, 0), (480, 0), (485, 1), (490, 1), (495, 1), (500, 1), (505, 1), (510, 1), (515, 1), (520, 1), (525, 1), (530, 1), (535, 1), (540, 1), (545, 1), (550, 1), (555, 1), (560, 1), (565, 1), (570, 1), (575, 1), (580, 1), (585, 1), (590, 0), (595, 0), (600, 1), (605, 1), (610, 1), (615, 1), (620, 1), (625, 1), (630, 1), (635, 1), (640, 1), (645, 1), (650, 1), (655, 1), (660, 1), (665, 1), (670, 1), (675, 1), (680, 1), (685, 0), (690, 0), (695, 0), (700, 0), (705, 1), (710, 0), (715, 0), (720, 0), (725, 0), (730, 0), (735, 0), (740, 0), (745, 0), (750, 0), (755, 0), (760, 0), (765, 0), (770, 0), (775, 0), (780, 1), (785, 1), (790, 1), (795, 1), (800, 0), (805, 0), (810, 0), (815, 0), (820, 1), (825, 1), (830, 1), (835, 1), (840, 1), (845, 1), (850, 1), (855, 1), (860, 1), (865, 1), (870, 1), (875, 1), (880, 1), (885, 1), (890, 0), (895, 0), (900, 0), (905, 0), (910, 1), (915, 1), (920, 0), (925, 0), (930, 0), (935, 0), (940, 0), (945, 0), (950, 0), (955, 0), (960, 1), (965, 1), (970, 1), (975, 1), (980, 1), (985, 0), (990, 0), (995, 0), (1000, 0), (1005, 1), (1010, 1), (1015, 1), (1020, 1), (1025, 1)]
Vdin0_2  din0_2  0 PWL (0n 0.0v 4.745n 0.0v 4.755n 0.0v 9.745n 0.0v 9.755n 0.95v 14.745n 0.95v 14.755n 0.0v 19.745n 0.0v 19.755n 0.0v 24.745n 0.0v 24.755n 0.0v 29.745n 0.0v 29.755n 0.0v 34.745n 0.0v 34.755n 0.0v 39.745n 0.0v 39.755n 0.0v 44.745n 0.0v 44.755n 0.95v 49.745n 0.95v 49.755n 0.95v 54.745n 0.95v 54.755n 0.95v 59.745n 0.95v 59.755n 0.95v 64.745n 0.95v 64.755n 0.95v 69.745n 0.95v 69.755n 0.95v 74.745n 0.95v 74.755n 0.95v 79.745n 0.95v 79.755n 0.95v 84.745n 0.95v 84.755n 0.95v 89.745n 0.95v 89.755n 0.95v 94.745n 0.95v 94.755n 0.95v 99.745n 0.95v 99.755n 0.95v 104.745n 0.95v 104.755n 0.95v 109.745n 0.95v 109.755n 0.95v 114.745n 0.95v 114.755n 0.95v 119.745n 0.95v 119.755n 0.95v 124.745n 0.95v 124.755n 0.0v 129.745n 0.0v 129.755n 0.0v 134.745n 0.0v 134.755n 0.0v 139.745n 0.0v 139.755n 0.0v 144.745n 0.0v 144.755n 0.0v 149.745n 0.0v 149.755n 0.0v 154.745n 0.0v 154.755n 0.0v 159.745n 0.0v 159.755n 0.0v 164.745n 0.0v 164.755n 0.0v 169.745n 0.0v 169.755n 0.0v 174.745n 0.0v 174.755n 0.0v 179.745n 0.0v 179.755n 0.0v 184.745n 0.0v 184.755n 0.95v 189.745n 0.95v 189.755n 0.95v 194.745n 0.95v 194.755n 0.95v 199.745n 0.95v 199.755n 0.95v 204.745n 0.95v 204.755n 0.95v 209.745n 0.95v 209.755n 0.95v 214.745n 0.95v 214.755n 0.0v 219.745n 0.0v 219.755n 0.0v 224.745n 0.0v 224.755n 0.0v 229.745n 0.0v 229.755n 0.0v 234.745n 0.0v 234.755n 0.0v 239.745n 0.0v 239.755n 0.95v 244.745n 0.95v 244.755n 0.95v 249.745n 0.95v 249.755n 0.95v 254.745n 0.95v 254.755n 0.95v 259.745n 0.95v 259.755n 0.0v 264.745n 0.0v 264.755n 0.95v 269.745n 0.95v 269.755n 0.95v 274.745n 0.95v 274.755n 0.95v 279.745n 0.95v 279.755n 0.95v 284.745n 0.95v 284.755n 0.0v 289.745n 0.0v 289.755n 0.0v 294.745n 0.0v 294.755n 0.0v 299.745n 0.0v 299.755n 0.0v 304.745n 0.0v 304.755n 0.0v 309.745n 0.0v 309.755n 0.0v 314.745n 0.0v 314.755n 0.0v 319.745n 0.0v 319.755n 0.0v 324.745n 0.0v 324.755n 0.0v 329.745n 0.0v 329.755n 0.0v 334.745n 0.0v 334.755n 0.0v 339.745n 0.0v 339.755n 0.0v 344.745n 0.0v 344.755n 0.0v 349.745n 0.0v 349.755n 0.0v 354.745n 0.0v 354.755n 0.95v 359.745n 0.95v 359.755n 0.95v 364.745n 0.95v 364.755n 0.0v 369.745n 0.0v 369.755n 0.0v 374.745n 0.0v 374.755n 0.0v 379.745n 0.0v 379.755n 0.95v 384.745n 0.95v 384.755n 0.95v 389.745n 0.95v 389.755n 0.0v 394.745n 0.0v 394.755n 0.0v 399.745n 0.0v 399.755n 0.0v 404.745n 0.0v 404.755n 0.95v 409.745n 0.95v 409.755n 0.95v 414.745n 0.95v 414.755n 0.95v 419.745n 0.95v 419.755n 0.95v 424.745n 0.95v 424.755n 0.95v 429.745n 0.95v 429.755n 0.95v 434.745n 0.95v 434.755n 0.95v 439.745n 0.95v 439.755n 0.95v 444.745n 0.95v 444.755n 0.95v 449.745n 0.95v 449.755n 0.95v 454.745n 0.95v 454.755n 0.95v 459.745n 0.95v 459.755n 0.95v 464.745n 0.95v 464.755n 0.95v 469.745n 0.95v 469.755n 0.0v 474.745n 0.0v 474.755n 0.0v 479.745n 0.0v 479.755n 0.0v 484.745n 0.0v 484.755n 0.95v 489.745n 0.95v 489.755n 0.95v 494.745n 0.95v 494.755n 0.95v 499.745n 0.95v 499.755n 0.95v 504.745n 0.95v 504.755n 0.95v 509.745n 0.95v 509.755n 0.95v 514.745n 0.95v 514.755n 0.95v 519.745n 0.95v 519.755n 0.95v 524.745n 0.95v 524.755n 0.95v 529.745n 0.95v 529.755n 0.95v 534.745n 0.95v 534.755n 0.95v 539.745n 0.95v 539.755n 0.95v 544.745n 0.95v 544.755n 0.95v 549.745n 0.95v 549.755n 0.95v 554.745n 0.95v 554.755n 0.95v 559.745n 0.95v 559.755n 0.95v 564.745n 0.95v 564.755n 0.95v 569.745n 0.95v 569.755n 0.95v 574.745n 0.95v 574.755n 0.95v 579.745n 0.95v 579.755n 0.95v 584.745n 0.95v 584.755n 0.95v 589.745n 0.95v 589.755n 0.0v 594.745n 0.0v 594.755n 0.0v 599.745n 0.0v 599.755n 0.95v 604.745n 0.95v 604.755n 0.95v 609.745n 0.95v 609.755n 0.95v 614.745n 0.95v 614.755n 0.95v 619.745n 0.95v 619.755n 0.95v 624.745n 0.95v 624.755n 0.95v 629.745n 0.95v 629.755n 0.95v 634.745n 0.95v 634.755n 0.95v 639.745n 0.95v 639.755n 0.95v 644.745n 0.95v 644.755n 0.95v 649.745n 0.95v 649.755n 0.95v 654.745n 0.95v 654.755n 0.95v 659.745n 0.95v 659.755n 0.95v 664.745n 0.95v 664.755n 0.95v 669.745n 0.95v 669.755n 0.95v 674.745n 0.95v 674.755n 0.95v 679.745n 0.95v 679.755n 0.95v 684.745n 0.95v 684.755n 0.0v 689.745n 0.0v 689.755n 0.0v 694.745n 0.0v 694.755n 0.0v 699.745n 0.0v 699.755n 0.0v 704.745n 0.0v 704.755n 0.95v 709.745n 0.95v 709.755n 0.0v 714.745n 0.0v 714.755n 0.0v 719.745n 0.0v 719.755n 0.0v 724.745n 0.0v 724.755n 0.0v 729.745n 0.0v 729.755n 0.0v 734.745n 0.0v 734.755n 0.0v 739.745n 0.0v 739.755n 0.0v 744.745n 0.0v 744.755n 0.0v 749.745n 0.0v 749.755n 0.0v 754.745n 0.0v 754.755n 0.0v 759.745n 0.0v 759.755n 0.0v 764.745n 0.0v 764.755n 0.0v 769.745n 0.0v 769.755n 0.0v 774.745n 0.0v 774.755n 0.0v 779.745n 0.0v 779.755n 0.95v 784.745n 0.95v 784.755n 0.95v 789.745n 0.95v 789.755n 0.95v 794.745n 0.95v 794.755n 0.95v 799.745n 0.95v 799.755n 0.0v 804.745n 0.0v 804.755n 0.0v 809.745n 0.0v 809.755n 0.0v 814.745n 0.0v 814.755n 0.0v 819.745n 0.0v 819.755n 0.95v 824.745n 0.95v 824.755n 0.95v 829.745n 0.95v 829.755n 0.95v 834.745n 0.95v 834.755n 0.95v 839.745n 0.95v 839.755n 0.95v 844.745n 0.95v 844.755n 0.95v 849.745n 0.95v 849.755n 0.95v 854.745n 0.95v 854.755n 0.95v 859.745n 0.95v 859.755n 0.95v 864.745n 0.95v 864.755n 0.95v 869.745n 0.95v 869.755n 0.95v 874.745n 0.95v 874.755n 0.95v 879.745n 0.95v 879.755n 0.95v 884.745n 0.95v 884.755n 0.95v 889.745n 0.95v 889.755n 0.0v 894.745n 0.0v 894.755n 0.0v 899.745n 0.0v 899.755n 0.0v 904.745n 0.0v 904.755n 0.0v 909.745n 0.0v 909.755n 0.95v 914.745n 0.95v 914.755n 0.95v 919.745n 0.95v 919.755n 0.0v 924.745n 0.0v 924.755n 0.0v 929.745n 0.0v 929.755n 0.0v 934.745n 0.0v 934.755n 0.0v 939.745n 0.0v 939.755n 0.0v 944.745n 0.0v 944.755n 0.0v 949.745n 0.0v 949.755n 0.0v 954.745n 0.0v 954.755n 0.0v 959.745n 0.0v 959.755n 0.95v 964.745n 0.95v 964.755n 0.95v 969.745n 0.95v 969.755n 0.95v 974.745n 0.95v 974.755n 0.95v 979.745n 0.95v 979.755n 0.95v 984.745n 0.95v 984.755n 0.0v 989.745n 0.0v 989.755n 0.0v 994.745n 0.0v 994.755n 0.0v 999.745n 0.0v 999.755n 0.0v 1004.745n 0.0v 1004.755n 0.95v 1009.745n 0.95v 1009.755n 0.95v 1014.745n 0.95v 1014.755n 0.95v 1019.745n 0.95v 1019.755n 0.95v 1024.745n 0.95v 1024.755n 0.95v )
* (time, data): [(0, 0), (5, 1), (10, 1), (15, 1), (20, 1), (25, 1), (30, 0), (35, 0), (40, 0), (45, 1), (50, 1), (55, 1), (60, 1), (65, 1), (70, 1), (75, 1), (80, 1), (85, 1), (90, 1), (95, 1), (100, 1), (105, 1), (110, 1), (115, 1), (120, 1), (125, 0), (130, 0), (135, 0), (140, 0), (145, 0), (150, 0), (155, 0), (160, 0), (165, 0), (170, 0), (175, 0), (180, 0), (185, 1), (190, 1), (195, 1), (200, 1), (205, 1), (210, 1), (215, 0), (220, 1), (225, 1), (230, 1), (235, 1), (240, 0), (245, 1), (250, 1), (255, 1), (260, 0), (265, 1), (270, 1), (275, 1), (280, 1), (285, 1), (290, 1), (295, 1), (300, 1), (305, 1), (310, 1), (315, 1), (320, 1), (325, 1), (330, 1), (335, 1), (340, 1), (345, 1), (350, 1), (355, 0), (360, 0), (365, 0), (370, 0), (375, 0), (380, 0), (385, 0), (390, 1), (395, 1), (400, 1), (405, 0), (410, 0), (415, 0), (420, 0), (425, 0), (430, 1), (435, 1), (440, 1), (445, 1), (450, 1), (455, 1), (460, 1), (465, 1), (470, 1), (475, 1), (480, 1), (485, 0), (490, 1), (495, 1), (500, 1), (505, 1), (510, 1), (515, 1), (520, 1), (525, 1), (530, 1), (535, 1), (540, 1), (545, 1), (550, 1), (555, 1), (560, 1), (565, 1), (570, 1), (575, 1), (580, 1), (585, 1), (590, 0), (595, 0), (600, 1), (605, 1), (610, 0), (615, 0), (620, 0), (625, 0), (630, 0), (635, 0), (640, 0), (645, 0), (650, 0), (655, 0), (660, 1), (665, 1), (670, 1), (675, 1), (680, 1), (685, 1), (690, 1), (695, 1), (700, 1), (705, 1), (710, 1), (715, 1), (720, 1), (725, 1), (730, 1), (735, 1), (740, 0), (745, 0), (750, 0), (755, 0), (760, 0), (765, 0), (770, 0), (775, 0), (780, 1), (785, 1), (790, 1), (795, 1), (800, 1), (805, 1), (810, 1), (815, 1), (820, 1), (825, 1), (830, 0), (835, 0), (840, 0), (845, 0), (850, 0), (855, 0), (860, 0), (865, 0), (870, 0), (875, 0), (880, 1), (885, 1), (890, 0), (895, 0), (900, 0), (905, 0), (910, 0), (915, 0), (920, 0), (925, 0), (930, 0), (935, 0), (940, 0), (945, 0), (950, 0), (955, 0), (960, 1), (965, 1), (970, 1), (975, 1), (980, 1), (985, 0), (990, 0), (995, 0), (1000, 0), (1005, 1), (1010, 1), (1015, 1), (1020, 1), (1025, 1)]
Vdin0_3  din0_3  0 PWL (0n 0.0v 4.745n 0.0v 4.755n 0.95v 9.745n 0.95v 9.755n 0.95v 14.745n 0.95v 14.755n 0.95v 19.745n 0.95v 19.755n 0.95v 24.745n 0.95v 24.755n 0.95v 29.745n 0.95v 29.755n 0.0v 34.745n 0.0v 34.755n 0.0v 39.745n 0.0v 39.755n 0.0v 44.745n 0.0v 44.755n 0.95v 49.745n 0.95v 49.755n 0.95v 54.745n 0.95v 54.755n 0.95v 59.745n 0.95v 59.755n 0.95v 64.745n 0.95v 64.755n 0.95v 69.745n 0.95v 69.755n 0.95v 74.745n 0.95v 74.755n 0.95v 79.745n 0.95v 79.755n 0.95v 84.745n 0.95v 84.755n 0.95v 89.745n 0.95v 89.755n 0.95v 94.745n 0.95v 94.755n 0.95v 99.745n 0.95v 99.755n 0.95v 104.745n 0.95v 104.755n 0.95v 109.745n 0.95v 109.755n 0.95v 114.745n 0.95v 114.755n 0.95v 119.745n 0.95v 119.755n 0.95v 124.745n 0.95v 124.755n 0.0v 129.745n 0.0v 129.755n 0.0v 134.745n 0.0v 134.755n 0.0v 139.745n 0.0v 139.755n 0.0v 144.745n 0.0v 144.755n 0.0v 149.745n 0.0v 149.755n 0.0v 154.745n 0.0v 154.755n 0.0v 159.745n 0.0v 159.755n 0.0v 164.745n 0.0v 164.755n 0.0v 169.745n 0.0v 169.755n 0.0v 174.745n 0.0v 174.755n 0.0v 179.745n 0.0v 179.755n 0.0v 184.745n 0.0v 184.755n 0.95v 189.745n 0.95v 189.755n 0.95v 194.745n 0.95v 194.755n 0.95v 199.745n 0.95v 199.755n 0.95v 204.745n 0.95v 204.755n 0.95v 209.745n 0.95v 209.755n 0.95v 214.745n 0.95v 214.755n 0.0v 219.745n 0.0v 219.755n 0.95v 224.745n 0.95v 224.755n 0.95v 229.745n 0.95v 229.755n 0.95v 234.745n 0.95v 234.755n 0.95v 239.745n 0.95v 239.755n 0.0v 244.745n 0.0v 244.755n 0.95v 249.745n 0.95v 249.755n 0.95v 254.745n 0.95v 254.755n 0.95v 259.745n 0.95v 259.755n 0.0v 264.745n 0.0v 264.755n 0.95v 269.745n 0.95v 269.755n 0.95v 274.745n 0.95v 274.755n 0.95v 279.745n 0.95v 279.755n 0.95v 284.745n 0.95v 284.755n 0.95v 289.745n 0.95v 289.755n 0.95v 294.745n 0.95v 294.755n 0.95v 299.745n 0.95v 299.755n 0.95v 304.745n 0.95v 304.755n 0.95v 309.745n 0.95v 309.755n 0.95v 314.745n 0.95v 314.755n 0.95v 319.745n 0.95v 319.755n 0.95v 324.745n 0.95v 324.755n 0.95v 329.745n 0.95v 329.755n 0.95v 334.745n 0.95v 334.755n 0.95v 339.745n 0.95v 339.755n 0.95v 344.745n 0.95v 344.755n 0.95v 349.745n 0.95v 349.755n 0.95v 354.745n 0.95v 354.755n 0.0v 359.745n 0.0v 359.755n 0.0v 364.745n 0.0v 364.755n 0.0v 369.745n 0.0v 369.755n 0.0v 374.745n 0.0v 374.755n 0.0v 379.745n 0.0v 379.755n 0.0v 384.745n 0.0v 384.755n 0.0v 389.745n 0.0v 389.755n 0.95v 394.745n 0.95v 394.755n 0.95v 399.745n 0.95v 399.755n 0.95v 404.745n 0.95v 404.755n 0.0v 409.745n 0.0v 409.755n 0.0v 414.745n 0.0v 414.755n 0.0v 419.745n 0.0v 419.755n 0.0v 424.745n 0.0v 424.755n 0.0v 429.745n 0.0v 429.755n 0.95v 434.745n 0.95v 434.755n 0.95v 439.745n 0.95v 439.755n 0.95v 444.745n 0.95v 444.755n 0.95v 449.745n 0.95v 449.755n 0.95v 454.745n 0.95v 454.755n 0.95v 459.745n 0.95v 459.755n 0.95v 464.745n 0.95v 464.755n 0.95v 469.745n 0.95v 469.755n 0.95v 474.745n 0.95v 474.755n 0.95v 479.745n 0.95v 479.755n 0.95v 484.745n 0.95v 484.755n 0.0v 489.745n 0.0v 489.755n 0.95v 494.745n 0.95v 494.755n 0.95v 499.745n 0.95v 499.755n 0.95v 504.745n 0.95v 504.755n 0.95v 509.745n 0.95v 509.755n 0.95v 514.745n 0.95v 514.755n 0.95v 519.745n 0.95v 519.755n 0.95v 524.745n 0.95v 524.755n 0.95v 529.745n 0.95v 529.755n 0.95v 534.745n 0.95v 534.755n 0.95v 539.745n 0.95v 539.755n 0.95v 544.745n 0.95v 544.755n 0.95v 549.745n 0.95v 549.755n 0.95v 554.745n 0.95v 554.755n 0.95v 559.745n 0.95v 559.755n 0.95v 564.745n 0.95v 564.755n 0.95v 569.745n 0.95v 569.755n 0.95v 574.745n 0.95v 574.755n 0.95v 579.745n 0.95v 579.755n 0.95v 584.745n 0.95v 584.755n 0.95v 589.745n 0.95v 589.755n 0.0v 594.745n 0.0v 594.755n 0.0v 599.745n 0.0v 599.755n 0.95v 604.745n 0.95v 604.755n 0.95v 609.745n 0.95v 609.755n 0.0v 614.745n 0.0v 614.755n 0.0v 619.745n 0.0v 619.755n 0.0v 624.745n 0.0v 624.755n 0.0v 629.745n 0.0v 629.755n 0.0v 634.745n 0.0v 634.755n 0.0v 639.745n 0.0v 639.755n 0.0v 644.745n 0.0v 644.755n 0.0v 649.745n 0.0v 649.755n 0.0v 654.745n 0.0v 654.755n 0.0v 659.745n 0.0v 659.755n 0.95v 664.745n 0.95v 664.755n 0.95v 669.745n 0.95v 669.755n 0.95v 674.745n 0.95v 674.755n 0.95v 679.745n 0.95v 679.755n 0.95v 684.745n 0.95v 684.755n 0.95v 689.745n 0.95v 689.755n 0.95v 694.745n 0.95v 694.755n 0.95v 699.745n 0.95v 699.755n 0.95v 704.745n 0.95v 704.755n 0.95v 709.745n 0.95v 709.755n 0.95v 714.745n 0.95v 714.755n 0.95v 719.745n 0.95v 719.755n 0.95v 724.745n 0.95v 724.755n 0.95v 729.745n 0.95v 729.755n 0.95v 734.745n 0.95v 734.755n 0.95v 739.745n 0.95v 739.755n 0.0v 744.745n 0.0v 744.755n 0.0v 749.745n 0.0v 749.755n 0.0v 754.745n 0.0v 754.755n 0.0v 759.745n 0.0v 759.755n 0.0v 764.745n 0.0v 764.755n 0.0v 769.745n 0.0v 769.755n 0.0v 774.745n 0.0v 774.755n 0.0v 779.745n 0.0v 779.755n 0.95v 784.745n 0.95v 784.755n 0.95v 789.745n 0.95v 789.755n 0.95v 794.745n 0.95v 794.755n 0.95v 799.745n 0.95v 799.755n 0.95v 804.745n 0.95v 804.755n 0.95v 809.745n 0.95v 809.755n 0.95v 814.745n 0.95v 814.755n 0.95v 819.745n 0.95v 819.755n 0.95v 824.745n 0.95v 824.755n 0.95v 829.745n 0.95v 829.755n 0.0v 834.745n 0.0v 834.755n 0.0v 839.745n 0.0v 839.755n 0.0v 844.745n 0.0v 844.755n 0.0v 849.745n 0.0v 849.755n 0.0v 854.745n 0.0v 854.755n 0.0v 859.745n 0.0v 859.755n 0.0v 864.745n 0.0v 864.755n 0.0v 869.745n 0.0v 869.755n 0.0v 874.745n 0.0v 874.755n 0.0v 879.745n 0.0v 879.755n 0.95v 884.745n 0.95v 884.755n 0.95v 889.745n 0.95v 889.755n 0.0v 894.745n 0.0v 894.755n 0.0v 899.745n 0.0v 899.755n 0.0v 904.745n 0.0v 904.755n 0.0v 909.745n 0.0v 909.755n 0.0v 914.745n 0.0v 914.755n 0.0v 919.745n 0.0v 919.755n 0.0v 924.745n 0.0v 924.755n 0.0v 929.745n 0.0v 929.755n 0.0v 934.745n 0.0v 934.755n 0.0v 939.745n 0.0v 939.755n 0.0v 944.745n 0.0v 944.755n 0.0v 949.745n 0.0v 949.755n 0.0v 954.745n 0.0v 954.755n 0.0v 959.745n 0.0v 959.755n 0.95v 964.745n 0.95v 964.755n 0.95v 969.745n 0.95v 969.755n 0.95v 974.745n 0.95v 974.755n 0.95v 979.745n 0.95v 979.755n 0.95v 984.745n 0.95v 984.755n 0.0v 989.745n 0.0v 989.755n 0.0v 994.745n 0.0v 994.755n 0.0v 999.745n 0.0v 999.755n 0.0v 1004.745n 0.0v 1004.755n 0.95v 1009.745n 0.95v 1009.755n 0.95v 1014.745n 0.95v 1014.755n 0.95v 1019.745n 0.95v 1019.755n 0.95v 1024.745n 0.95v 1024.755n 0.95v )
* (time, data): [(0, 0), (5, 1), (10, 0), (15, 1), (20, 1), (25, 1), (30, 0), (35, 0), (40, 0), (45, 0), (50, 0), (55, 0), (60, 0), (65, 1), (70, 1), (75, 1), (80, 1), (85, 1), (90, 1), (95, 1), (100, 1), (105, 1), (110, 1), (115, 1), (120, 1), (125, 1), (130, 1), (135, 1), (140, 1), (145, 1), (150, 1), (155, 1), (160, 1), (165, 1), (170, 1), (175, 1), (180, 1), (185, 1), (190, 1), (195, 1), (200, 1), (205, 1), (210, 1), (215, 1), (220, 1), (225, 1), (230, 0), (235, 0), (240, 1), (245, 1), (250, 1), (255, 1), (260, 1), (265, 1), (270, 1), (275, 1), (280, 1), (285, 1), (290, 1), (295, 1), (300, 1), (305, 1), (310, 1), (315, 1), (320, 1), (325, 1), (330, 1), (335, 1), (340, 1), (345, 1), (350, 1), (355, 0), (360, 0), (365, 1), (370, 1), (375, 1), (380, 1), (385, 1), (390, 1), (395, 1), (400, 1), (405, 0), (410, 0), (415, 0), (420, 0), (425, 0), (430, 0), (435, 0), (440, 0), (445, 0), (450, 0), (455, 0), (460, 0), (465, 0), (470, 0), (475, 0), (480, 0), (485, 1), (490, 0), (495, 0), (500, 0), (505, 0), (510, 0), (515, 0), (520, 0), (525, 0), (530, 0), (535, 0), (540, 0), (545, 0), (550, 0), (555, 0), (560, 0), (565, 0), (570, 0), (575, 0), (580, 1), (585, 1), (590, 1), (595, 1), (600, 1), (605, 1), (610, 1), (615, 1), (620, 1), (625, 1), (630, 1), (635, 1), (640, 1), (645, 1), (650, 1), (655, 1), (660, 0), (665, 0), (670, 0), (675, 0), (680, 0), (685, 0), (690, 0), (695, 0), (700, 0), (705, 0), (710, 0), (715, 0), (720, 0), (725, 0), (730, 1), (735, 0), (740, 0), (745, 0), (750, 0), (755, 0), (760, 0), (765, 0), (770, 0), (775, 0), (780, 0), (785, 0), (790, 0), (795, 0), (800, 0), (805, 0), (810, 0), (815, 0), (820, 0), (825, 0), (830, 0), (835, 0), (840, 0), (845, 0), (850, 0), (855, 0), (860, 0), (865, 0), (870, 0), (875, 0), (880, 0), (885, 0), (890, 0), (895, 0), (900, 0), (905, 0), (910, 0), (915, 0), (920, 0), (925, 0), (930, 0), (935, 0), (940, 0), (945, 0), (950, 0), (955, 0), (960, 0), (965, 0), (970, 0), (975, 0), (980, 0), (985, 0), (990, 0), (995, 0), (1000, 0), (1005, 0), (1010, 0), (1015, 0), (1020, 0), (1025, 0)]
Vdin0_4  din0_4  0 PWL (0n 0.0v 4.745n 0.0v 4.755n 0.95v 9.745n 0.95v 9.755n 0.0v 14.745n 0.0v 14.755n 0.95v 19.745n 0.95v 19.755n 0.95v 24.745n 0.95v 24.755n 0.95v 29.745n 0.95v 29.755n 0.0v 34.745n 0.0v 34.755n 0.0v 39.745n 0.0v 39.755n 0.0v 44.745n 0.0v 44.755n 0.0v 49.745n 0.0v 49.755n 0.0v 54.745n 0.0v 54.755n 0.0v 59.745n 0.0v 59.755n 0.0v 64.745n 0.0v 64.755n 0.95v 69.745n 0.95v 69.755n 0.95v 74.745n 0.95v 74.755n 0.95v 79.745n 0.95v 79.755n 0.95v 84.745n 0.95v 84.755n 0.95v 89.745n 0.95v 89.755n 0.95v 94.745n 0.95v 94.755n 0.95v 99.745n 0.95v 99.755n 0.95v 104.745n 0.95v 104.755n 0.95v 109.745n 0.95v 109.755n 0.95v 114.745n 0.95v 114.755n 0.95v 119.745n 0.95v 119.755n 0.95v 124.745n 0.95v 124.755n 0.95v 129.745n 0.95v 129.755n 0.95v 134.745n 0.95v 134.755n 0.95v 139.745n 0.95v 139.755n 0.95v 144.745n 0.95v 144.755n 0.95v 149.745n 0.95v 149.755n 0.95v 154.745n 0.95v 154.755n 0.95v 159.745n 0.95v 159.755n 0.95v 164.745n 0.95v 164.755n 0.95v 169.745n 0.95v 169.755n 0.95v 174.745n 0.95v 174.755n 0.95v 179.745n 0.95v 179.755n 0.95v 184.745n 0.95v 184.755n 0.95v 189.745n 0.95v 189.755n 0.95v 194.745n 0.95v 194.755n 0.95v 199.745n 0.95v 199.755n 0.95v 204.745n 0.95v 204.755n 0.95v 209.745n 0.95v 209.755n 0.95v 214.745n 0.95v 214.755n 0.95v 219.745n 0.95v 219.755n 0.95v 224.745n 0.95v 224.755n 0.95v 229.745n 0.95v 229.755n 0.0v 234.745n 0.0v 234.755n 0.0v 239.745n 0.0v 239.755n 0.95v 244.745n 0.95v 244.755n 0.95v 249.745n 0.95v 249.755n 0.95v 254.745n 0.95v 254.755n 0.95v 259.745n 0.95v 259.755n 0.95v 264.745n 0.95v 264.755n 0.95v 269.745n 0.95v 269.755n 0.95v 274.745n 0.95v 274.755n 0.95v 279.745n 0.95v 279.755n 0.95v 284.745n 0.95v 284.755n 0.95v 289.745n 0.95v 289.755n 0.95v 294.745n 0.95v 294.755n 0.95v 299.745n 0.95v 299.755n 0.95v 304.745n 0.95v 304.755n 0.95v 309.745n 0.95v 309.755n 0.95v 314.745n 0.95v 314.755n 0.95v 319.745n 0.95v 319.755n 0.95v 324.745n 0.95v 324.755n 0.95v 329.745n 0.95v 329.755n 0.95v 334.745n 0.95v 334.755n 0.95v 339.745n 0.95v 339.755n 0.95v 344.745n 0.95v 344.755n 0.95v 349.745n 0.95v 349.755n 0.95v 354.745n 0.95v 354.755n 0.0v 359.745n 0.0v 359.755n 0.0v 364.745n 0.0v 364.755n 0.95v 369.745n 0.95v 369.755n 0.95v 374.745n 0.95v 374.755n 0.95v 379.745n 0.95v 379.755n 0.95v 384.745n 0.95v 384.755n 0.95v 389.745n 0.95v 389.755n 0.95v 394.745n 0.95v 394.755n 0.95v 399.745n 0.95v 399.755n 0.95v 404.745n 0.95v 404.755n 0.0v 409.745n 0.0v 409.755n 0.0v 414.745n 0.0v 414.755n 0.0v 419.745n 0.0v 419.755n 0.0v 424.745n 0.0v 424.755n 0.0v 429.745n 0.0v 429.755n 0.0v 434.745n 0.0v 434.755n 0.0v 439.745n 0.0v 439.755n 0.0v 444.745n 0.0v 444.755n 0.0v 449.745n 0.0v 449.755n 0.0v 454.745n 0.0v 454.755n 0.0v 459.745n 0.0v 459.755n 0.0v 464.745n 0.0v 464.755n 0.0v 469.745n 0.0v 469.755n 0.0v 474.745n 0.0v 474.755n 0.0v 479.745n 0.0v 479.755n 0.0v 484.745n 0.0v 484.755n 0.95v 489.745n 0.95v 489.755n 0.0v 494.745n 0.0v 494.755n 0.0v 499.745n 0.0v 499.755n 0.0v 504.745n 0.0v 504.755n 0.0v 509.745n 0.0v 509.755n 0.0v 514.745n 0.0v 514.755n 0.0v 519.745n 0.0v 519.755n 0.0v 524.745n 0.0v 524.755n 0.0v 529.745n 0.0v 529.755n 0.0v 534.745n 0.0v 534.755n 0.0v 539.745n 0.0v 539.755n 0.0v 544.745n 0.0v 544.755n 0.0v 549.745n 0.0v 549.755n 0.0v 554.745n 0.0v 554.755n 0.0v 559.745n 0.0v 559.755n 0.0v 564.745n 0.0v 564.755n 0.0v 569.745n 0.0v 569.755n 0.0v 574.745n 0.0v 574.755n 0.0v 579.745n 0.0v 579.755n 0.95v 584.745n 0.95v 584.755n 0.95v 589.745n 0.95v 589.755n 0.95v 594.745n 0.95v 594.755n 0.95v 599.745n 0.95v 599.755n 0.95v 604.745n 0.95v 604.755n 0.95v 609.745n 0.95v 609.755n 0.95v 614.745n 0.95v 614.755n 0.95v 619.745n 0.95v 619.755n 0.95v 624.745n 0.95v 624.755n 0.95v 629.745n 0.95v 629.755n 0.95v 634.745n 0.95v 634.755n 0.95v 639.745n 0.95v 639.755n 0.95v 644.745n 0.95v 644.755n 0.95v 649.745n 0.95v 649.755n 0.95v 654.745n 0.95v 654.755n 0.95v 659.745n 0.95v 659.755n 0.0v 664.745n 0.0v 664.755n 0.0v 669.745n 0.0v 669.755n 0.0v 674.745n 0.0v 674.755n 0.0v 679.745n 0.0v 679.755n 0.0v 684.745n 0.0v 684.755n 0.0v 689.745n 0.0v 689.755n 0.0v 694.745n 0.0v 694.755n 0.0v 699.745n 0.0v 699.755n 0.0v 704.745n 0.0v 704.755n 0.0v 709.745n 0.0v 709.755n 0.0v 714.745n 0.0v 714.755n 0.0v 719.745n 0.0v 719.755n 0.0v 724.745n 0.0v 724.755n 0.0v 729.745n 0.0v 729.755n 0.95v 734.745n 0.95v 734.755n 0.0v 739.745n 0.0v 739.755n 0.0v 744.745n 0.0v 744.755n 0.0v 749.745n 0.0v 749.755n 0.0v 754.745n 0.0v 754.755n 0.0v 759.745n 0.0v 759.755n 0.0v 764.745n 0.0v 764.755n 0.0v 769.745n 0.0v 769.755n 0.0v 774.745n 0.0v 774.755n 0.0v 779.745n 0.0v 779.755n 0.0v 784.745n 0.0v 784.755n 0.0v 789.745n 0.0v 789.755n 0.0v 794.745n 0.0v 794.755n 0.0v 799.745n 0.0v 799.755n 0.0v 804.745n 0.0v 804.755n 0.0v 809.745n 0.0v 809.755n 0.0v 814.745n 0.0v 814.755n 0.0v 819.745n 0.0v 819.755n 0.0v 824.745n 0.0v 824.755n 0.0v 829.745n 0.0v 829.755n 0.0v 834.745n 0.0v 834.755n 0.0v 839.745n 0.0v 839.755n 0.0v 844.745n 0.0v 844.755n 0.0v 849.745n 0.0v 849.755n 0.0v 854.745n 0.0v 854.755n 0.0v 859.745n 0.0v 859.755n 0.0v 864.745n 0.0v 864.755n 0.0v 869.745n 0.0v 869.755n 0.0v 874.745n 0.0v 874.755n 0.0v 879.745n 0.0v 879.755n 0.0v 884.745n 0.0v 884.755n 0.0v 889.745n 0.0v 889.755n 0.0v 894.745n 0.0v 894.755n 0.0v 899.745n 0.0v 899.755n 0.0v 904.745n 0.0v 904.755n 0.0v 909.745n 0.0v 909.755n 0.0v 914.745n 0.0v 914.755n 0.0v 919.745n 0.0v 919.755n 0.0v 924.745n 0.0v 924.755n 0.0v 929.745n 0.0v 929.755n 0.0v 934.745n 0.0v 934.755n 0.0v 939.745n 0.0v 939.755n 0.0v 944.745n 0.0v 944.755n 0.0v 949.745n 0.0v 949.755n 0.0v 954.745n 0.0v 954.755n 0.0v 959.745n 0.0v 959.755n 0.0v 964.745n 0.0v 964.755n 0.0v 969.745n 0.0v 969.755n 0.0v 974.745n 0.0v 974.755n 0.0v 979.745n 0.0v 979.755n 0.0v 984.745n 0.0v 984.755n 0.0v 989.745n 0.0v 989.755n 0.0v 994.745n 0.0v 994.755n 0.0v 999.745n 0.0v 999.755n 0.0v 1004.745n 0.0v 1004.755n 0.0v 1009.745n 0.0v 1009.755n 0.0v 1014.745n 0.0v 1014.755n 0.0v 1019.745n 0.0v 1019.755n 0.0v 1024.745n 0.0v 1024.755n 0.0v )
* (time, data): [(0, 0), (5, 1), (10, 1), (15, 1), (20, 1), (25, 1), (30, 0), (35, 0), (40, 0), (45, 1), (50, 1), (55, 1), (60, 1), (65, 0), (70, 0), (75, 0), (80, 0), (85, 0), (90, 0), (95, 0), (100, 0), (105, 0), (110, 0), (115, 0), (120, 0), (125, 1), (130, 1), (135, 1), (140, 1), (145, 1), (150, 1), (155, 1), (160, 1), (165, 1), (170, 1), (175, 1), (180, 1), (185, 1), (190, 1), (195, 1), (200, 1), (205, 1), (210, 1), (215, 0), (220, 0), (225, 0), (230, 0), (235, 0), (240, 1), (245, 0), (250, 0), (255, 0), (260, 0), (265, 0), (270, 0), (275, 0), (280, 0), (285, 1), (290, 1), (295, 1), (300, 1), (305, 1), (310, 1), (315, 1), (320, 1), (325, 1), (330, 1), (335, 1), (340, 1), (345, 1), (350, 1), (355, 0), (360, 0), (365, 1), (370, 1), (375, 1), (380, 0), (385, 0), (390, 0), (395, 0), (400, 0), (405, 1), (410, 1), (415, 1), (420, 1), (425, 1), (430, 1), (435, 1), (440, 1), (445, 1), (450, 1), (455, 1), (460, 1), (465, 1), (470, 0), (475, 0), (480, 0), (485, 0), (490, 1), (495, 1), (500, 1), (505, 1), (510, 1), (515, 1), (520, 1), (525, 1), (530, 1), (535, 1), (540, 1), (545, 1), (550, 1), (555, 1), (560, 1), (565, 1), (570, 1), (575, 1), (580, 0), (585, 0), (590, 1), (595, 1), (600, 1), (605, 1), (610, 1), (615, 1), (620, 0), (625, 0), (630, 0), (635, 0), (640, 0), (645, 0), (650, 0), (655, 0), (660, 0), (665, 0), (670, 0), (675, 1), (680, 1), (685, 0), (690, 0), (695, 0), (700, 0), (705, 0), (710, 1), (715, 1), (720, 1), (725, 1), (730, 0), (735, 0), (740, 0), (745, 0), (750, 0), (755, 0), (760, 0), (765, 0), (770, 0), (775, 0), (780, 1), (785, 1), (790, 1), (795, 1), (800, 0), (805, 0), (810, 0), (815, 0), (820, 1), (825, 1), (830, 0), (835, 0), (840, 0), (845, 0), (850, 0), (855, 1), (860, 1), (865, 1), (870, 1), (875, 1), (880, 1), (885, 1), (890, 1), (895, 1), (900, 1), (905, 1), (910, 0), (915, 0), (920, 0), (925, 0), (930, 0), (935, 0), (940, 0), (945, 0), (950, 0), (955, 0), (960, 0), (965, 0), (970, 0), (975, 0), (980, 0), (985, 0), (990, 0), (995, 0), (1000, 0), (1005, 0), (1010, 0), (1015, 0), (1020, 0), (1025, 0)]
Vdin0_5  din0_5  0 PWL (0n 0.0v 4.745n 0.0v 4.755n 0.95v 9.745n 0.95v 9.755n 0.95v 14.745n 0.95v 14.755n 0.95v 19.745n 0.95v 19.755n 0.95v 24.745n 0.95v 24.755n 0.95v 29.745n 0.95v 29.755n 0.0v 34.745n 0.0v 34.755n 0.0v 39.745n 0.0v 39.755n 0.0v 44.745n 0.0v 44.755n 0.95v 49.745n 0.95v 49.755n 0.95v 54.745n 0.95v 54.755n 0.95v 59.745n 0.95v 59.755n 0.95v 64.745n 0.95v 64.755n 0.0v 69.745n 0.0v 69.755n 0.0v 74.745n 0.0v 74.755n 0.0v 79.745n 0.0v 79.755n 0.0v 84.745n 0.0v 84.755n 0.0v 89.745n 0.0v 89.755n 0.0v 94.745n 0.0v 94.755n 0.0v 99.745n 0.0v 99.755n 0.0v 104.745n 0.0v 104.755n 0.0v 109.745n 0.0v 109.755n 0.0v 114.745n 0.0v 114.755n 0.0v 119.745n 0.0v 119.755n 0.0v 124.745n 0.0v 124.755n 0.95v 129.745n 0.95v 129.755n 0.95v 134.745n 0.95v 134.755n 0.95v 139.745n 0.95v 139.755n 0.95v 144.745n 0.95v 144.755n 0.95v 149.745n 0.95v 149.755n 0.95v 154.745n 0.95v 154.755n 0.95v 159.745n 0.95v 159.755n 0.95v 164.745n 0.95v 164.755n 0.95v 169.745n 0.95v 169.755n 0.95v 174.745n 0.95v 174.755n 0.95v 179.745n 0.95v 179.755n 0.95v 184.745n 0.95v 184.755n 0.95v 189.745n 0.95v 189.755n 0.95v 194.745n 0.95v 194.755n 0.95v 199.745n 0.95v 199.755n 0.95v 204.745n 0.95v 204.755n 0.95v 209.745n 0.95v 209.755n 0.95v 214.745n 0.95v 214.755n 0.0v 219.745n 0.0v 219.755n 0.0v 224.745n 0.0v 224.755n 0.0v 229.745n 0.0v 229.755n 0.0v 234.745n 0.0v 234.755n 0.0v 239.745n 0.0v 239.755n 0.95v 244.745n 0.95v 244.755n 0.0v 249.745n 0.0v 249.755n 0.0v 254.745n 0.0v 254.755n 0.0v 259.745n 0.0v 259.755n 0.0v 264.745n 0.0v 264.755n 0.0v 269.745n 0.0v 269.755n 0.0v 274.745n 0.0v 274.755n 0.0v 279.745n 0.0v 279.755n 0.0v 284.745n 0.0v 284.755n 0.95v 289.745n 0.95v 289.755n 0.95v 294.745n 0.95v 294.755n 0.95v 299.745n 0.95v 299.755n 0.95v 304.745n 0.95v 304.755n 0.95v 309.745n 0.95v 309.755n 0.95v 314.745n 0.95v 314.755n 0.95v 319.745n 0.95v 319.755n 0.95v 324.745n 0.95v 324.755n 0.95v 329.745n 0.95v 329.755n 0.95v 334.745n 0.95v 334.755n 0.95v 339.745n 0.95v 339.755n 0.95v 344.745n 0.95v 344.755n 0.95v 349.745n 0.95v 349.755n 0.95v 354.745n 0.95v 354.755n 0.0v 359.745n 0.0v 359.755n 0.0v 364.745n 0.0v 364.755n 0.95v 369.745n 0.95v 369.755n 0.95v 374.745n 0.95v 374.755n 0.95v 379.745n 0.95v 379.755n 0.0v 384.745n 0.0v 384.755n 0.0v 389.745n 0.0v 389.755n 0.0v 394.745n 0.0v 394.755n 0.0v 399.745n 0.0v 399.755n 0.0v 404.745n 0.0v 404.755n 0.95v 409.745n 0.95v 409.755n 0.95v 414.745n 0.95v 414.755n 0.95v 419.745n 0.95v 419.755n 0.95v 424.745n 0.95v 424.755n 0.95v 429.745n 0.95v 429.755n 0.95v 434.745n 0.95v 434.755n 0.95v 439.745n 0.95v 439.755n 0.95v 444.745n 0.95v 444.755n 0.95v 449.745n 0.95v 449.755n 0.95v 454.745n 0.95v 454.755n 0.95v 459.745n 0.95v 459.755n 0.95v 464.745n 0.95v 464.755n 0.95v 469.745n 0.95v 469.755n 0.0v 474.745n 0.0v 474.755n 0.0v 479.745n 0.0v 479.755n 0.0v 484.745n 0.0v 484.755n 0.0v 489.745n 0.0v 489.755n 0.95v 494.745n 0.95v 494.755n 0.95v 499.745n 0.95v 499.755n 0.95v 504.745n 0.95v 504.755n 0.95v 509.745n 0.95v 509.755n 0.95v 514.745n 0.95v 514.755n 0.95v 519.745n 0.95v 519.755n 0.95v 524.745n 0.95v 524.755n 0.95v 529.745n 0.95v 529.755n 0.95v 534.745n 0.95v 534.755n 0.95v 539.745n 0.95v 539.755n 0.95v 544.745n 0.95v 544.755n 0.95v 549.745n 0.95v 549.755n 0.95v 554.745n 0.95v 554.755n 0.95v 559.745n 0.95v 559.755n 0.95v 564.745n 0.95v 564.755n 0.95v 569.745n 0.95v 569.755n 0.95v 574.745n 0.95v 574.755n 0.95v 579.745n 0.95v 579.755n 0.0v 584.745n 0.0v 584.755n 0.0v 589.745n 0.0v 589.755n 0.95v 594.745n 0.95v 594.755n 0.95v 599.745n 0.95v 599.755n 0.95v 604.745n 0.95v 604.755n 0.95v 609.745n 0.95v 609.755n 0.95v 614.745n 0.95v 614.755n 0.95v 619.745n 0.95v 619.755n 0.0v 624.745n 0.0v 624.755n 0.0v 629.745n 0.0v 629.755n 0.0v 634.745n 0.0v 634.755n 0.0v 639.745n 0.0v 639.755n 0.0v 644.745n 0.0v 644.755n 0.0v 649.745n 0.0v 649.755n 0.0v 654.745n 0.0v 654.755n 0.0v 659.745n 0.0v 659.755n 0.0v 664.745n 0.0v 664.755n 0.0v 669.745n 0.0v 669.755n 0.0v 674.745n 0.0v 674.755n 0.95v 679.745n 0.95v 679.755n 0.95v 684.745n 0.95v 684.755n 0.0v 689.745n 0.0v 689.755n 0.0v 694.745n 0.0v 694.755n 0.0v 699.745n 0.0v 699.755n 0.0v 704.745n 0.0v 704.755n 0.0v 709.745n 0.0v 709.755n 0.95v 714.745n 0.95v 714.755n 0.95v 719.745n 0.95v 719.755n 0.95v 724.745n 0.95v 724.755n 0.95v 729.745n 0.95v 729.755n 0.0v 734.745n 0.0v 734.755n 0.0v 739.745n 0.0v 739.755n 0.0v 744.745n 0.0v 744.755n 0.0v 749.745n 0.0v 749.755n 0.0v 754.745n 0.0v 754.755n 0.0v 759.745n 0.0v 759.755n 0.0v 764.745n 0.0v 764.755n 0.0v 769.745n 0.0v 769.755n 0.0v 774.745n 0.0v 774.755n 0.0v 779.745n 0.0v 779.755n 0.95v 784.745n 0.95v 784.755n 0.95v 789.745n 0.95v 789.755n 0.95v 794.745n 0.95v 794.755n 0.95v 799.745n 0.95v 799.755n 0.0v 804.745n 0.0v 804.755n 0.0v 809.745n 0.0v 809.755n 0.0v 814.745n 0.0v 814.755n 0.0v 819.745n 0.0v 819.755n 0.95v 824.745n 0.95v 824.755n 0.95v 829.745n 0.95v 829.755n 0.0v 834.745n 0.0v 834.755n 0.0v 839.745n 0.0v 839.755n 0.0v 844.745n 0.0v 844.755n 0.0v 849.745n 0.0v 849.755n 0.0v 854.745n 0.0v 854.755n 0.95v 859.745n 0.95v 859.755n 0.95v 864.745n 0.95v 864.755n 0.95v 869.745n 0.95v 869.755n 0.95v 874.745n 0.95v 874.755n 0.95v 879.745n 0.95v 879.755n 0.95v 884.745n 0.95v 884.755n 0.95v 889.745n 0.95v 889.755n 0.95v 894.745n 0.95v 894.755n 0.95v 899.745n 0.95v 899.755n 0.95v 904.745n 0.95v 904.755n 0.95v 909.745n 0.95v 909.755n 0.0v 914.745n 0.0v 914.755n 0.0v 919.745n 0.0v 919.755n 0.0v 924.745n 0.0v 924.755n 0.0v 929.745n 0.0v 929.755n 0.0v 934.745n 0.0v 934.755n 0.0v 939.745n 0.0v 939.755n 0.0v 944.745n 0.0v 944.755n 0.0v 949.745n 0.0v 949.755n 0.0v 954.745n 0.0v 954.755n 0.0v 959.745n 0.0v 959.755n 0.0v 964.745n 0.0v 964.755n 0.0v 969.745n 0.0v 969.755n 0.0v 974.745n 0.0v 974.755n 0.0v 979.745n 0.0v 979.755n 0.0v 984.745n 0.0v 984.755n 0.0v 989.745n 0.0v 989.755n 0.0v 994.745n 0.0v 994.755n 0.0v 999.745n 0.0v 999.755n 0.0v 1004.745n 0.0v 1004.755n 0.0v 1009.745n 0.0v 1009.755n 0.0v 1014.745n 0.0v 1014.755n 0.0v 1019.745n 0.0v 1019.755n 0.0v 1024.745n 0.0v 1024.755n 0.0v )
* (time, data): [(0, 0), (5, 1), (10, 1), (15, 0), (20, 0), (25, 0), (30, 1), (35, 1), (40, 1), (45, 1), (50, 1), (55, 1), (60, 1), (65, 0), (70, 0), (75, 0), (80, 0), (85, 0), (90, 0), (95, 0), (100, 0), (105, 0), (110, 0), (115, 0), (120, 0), (125, 0), (130, 0), (135, 0), (140, 0), (145, 0), (150, 0), (155, 1), (160, 1), (165, 1), (170, 1), (175, 1), (180, 1), (185, 0), (190, 0), (195, 0), (200, 0), (205, 0), (210, 0), (215, 0), (220, 1), (225, 1), (230, 1), (235, 1), (240, 0), (245, 0), (250, 0), (255, 0), (260, 0), (265, 0), (270, 0), (275, 0), (280, 0), (285, 0), (290, 0), (295, 0), (300, 0), (305, 0), (310, 0), (315, 0), (320, 0), (325, 0), (330, 0), (335, 0), (340, 0), (345, 0), (350, 0), (355, 1), (360, 1), (365, 0), (370, 0), (375, 0), (380, 1), (385, 1), (390, 1), (395, 1), (400, 1), (405, 0), (410, 0), (415, 0), (420, 0), (425, 0), (430, 1), (435, 1), (440, 1), (445, 1), (450, 1), (455, 1), (460, 1), (465, 1), (470, 0), (475, 0), (480, 0), (485, 0), (490, 1), (495, 1), (500, 1), (505, 1), (510, 1), (515, 1), (520, 1), (525, 1), (530, 1), (535, 1), (540, 1), (545, 1), (550, 1), (555, 1), (560, 1), (565, 1), (570, 1), (575, 1), (580, 1), (585, 1), (590, 1), (595, 1), (600, 0), (605, 0), (610, 1), (615, 0), (620, 0), (625, 0), (630, 0), (635, 0), (640, 0), (645, 0), (650, 0), (655, 0), (660, 0), (665, 0), (670, 0), (675, 0), (680, 0), (685, 0), (690, 0), (695, 0), (700, 0), (705, 0), (710, 0), (715, 0), (720, 0), (725, 0), (730, 0), (735, 0), (740, 0), (745, 0), (750, 0), (755, 0), (760, 0), (765, 0), (770, 0), (775, 0), (780, 1), (785, 1), (790, 1), (795, 1), (800, 0), (805, 0), (810, 0), (815, 0), (820, 1), (825, 1), (830, 0), (835, 0), (840, 0), (845, 0), (850, 0), (855, 1), (860, 1), (865, 1), (870, 1), (875, 1), (880, 1), (885, 1), (890, 0), (895, 0), (900, 0), (905, 0), (910, 1), (915, 1), (920, 1), (925, 1), (930, 1), (935, 1), (940, 1), (945, 0), (950, 1), (955, 1), (960, 1), (965, 1), (970, 1), (975, 1), (980, 1), (985, 0), (990, 0), (995, 0), (1000, 0), (1005, 0), (1010, 0), (1015, 0), (1020, 0), (1025, 0)]
Vdin0_6  din0_6  0 PWL (0n 0.0v 4.745n 0.0v 4.755n 0.95v 9.745n 0.95v 9.755n 0.95v 14.745n 0.95v 14.755n 0.0v 19.745n 0.0v 19.755n 0.0v 24.745n 0.0v 24.755n 0.0v 29.745n 0.0v 29.755n 0.95v 34.745n 0.95v 34.755n 0.95v 39.745n 0.95v 39.755n 0.95v 44.745n 0.95v 44.755n 0.95v 49.745n 0.95v 49.755n 0.95v 54.745n 0.95v 54.755n 0.95v 59.745n 0.95v 59.755n 0.95v 64.745n 0.95v 64.755n 0.0v 69.745n 0.0v 69.755n 0.0v 74.745n 0.0v 74.755n 0.0v 79.745n 0.0v 79.755n 0.0v 84.745n 0.0v 84.755n 0.0v 89.745n 0.0v 89.755n 0.0v 94.745n 0.0v 94.755n 0.0v 99.745n 0.0v 99.755n 0.0v 104.745n 0.0v 104.755n 0.0v 109.745n 0.0v 109.755n 0.0v 114.745n 0.0v 114.755n 0.0v 119.745n 0.0v 119.755n 0.0v 124.745n 0.0v 124.755n 0.0v 129.745n 0.0v 129.755n 0.0v 134.745n 0.0v 134.755n 0.0v 139.745n 0.0v 139.755n 0.0v 144.745n 0.0v 144.755n 0.0v 149.745n 0.0v 149.755n 0.0v 154.745n 0.0v 154.755n 0.95v 159.745n 0.95v 159.755n 0.95v 164.745n 0.95v 164.755n 0.95v 169.745n 0.95v 169.755n 0.95v 174.745n 0.95v 174.755n 0.95v 179.745n 0.95v 179.755n 0.95v 184.745n 0.95v 184.755n 0.0v 189.745n 0.0v 189.755n 0.0v 194.745n 0.0v 194.755n 0.0v 199.745n 0.0v 199.755n 0.0v 204.745n 0.0v 204.755n 0.0v 209.745n 0.0v 209.755n 0.0v 214.745n 0.0v 214.755n 0.0v 219.745n 0.0v 219.755n 0.95v 224.745n 0.95v 224.755n 0.95v 229.745n 0.95v 229.755n 0.95v 234.745n 0.95v 234.755n 0.95v 239.745n 0.95v 239.755n 0.0v 244.745n 0.0v 244.755n 0.0v 249.745n 0.0v 249.755n 0.0v 254.745n 0.0v 254.755n 0.0v 259.745n 0.0v 259.755n 0.0v 264.745n 0.0v 264.755n 0.0v 269.745n 0.0v 269.755n 0.0v 274.745n 0.0v 274.755n 0.0v 279.745n 0.0v 279.755n 0.0v 284.745n 0.0v 284.755n 0.0v 289.745n 0.0v 289.755n 0.0v 294.745n 0.0v 294.755n 0.0v 299.745n 0.0v 299.755n 0.0v 304.745n 0.0v 304.755n 0.0v 309.745n 0.0v 309.755n 0.0v 314.745n 0.0v 314.755n 0.0v 319.745n 0.0v 319.755n 0.0v 324.745n 0.0v 324.755n 0.0v 329.745n 0.0v 329.755n 0.0v 334.745n 0.0v 334.755n 0.0v 339.745n 0.0v 339.755n 0.0v 344.745n 0.0v 344.755n 0.0v 349.745n 0.0v 349.755n 0.0v 354.745n 0.0v 354.755n 0.95v 359.745n 0.95v 359.755n 0.95v 364.745n 0.95v 364.755n 0.0v 369.745n 0.0v 369.755n 0.0v 374.745n 0.0v 374.755n 0.0v 379.745n 0.0v 379.755n 0.95v 384.745n 0.95v 384.755n 0.95v 389.745n 0.95v 389.755n 0.95v 394.745n 0.95v 394.755n 0.95v 399.745n 0.95v 399.755n 0.95v 404.745n 0.95v 404.755n 0.0v 409.745n 0.0v 409.755n 0.0v 414.745n 0.0v 414.755n 0.0v 419.745n 0.0v 419.755n 0.0v 424.745n 0.0v 424.755n 0.0v 429.745n 0.0v 429.755n 0.95v 434.745n 0.95v 434.755n 0.95v 439.745n 0.95v 439.755n 0.95v 444.745n 0.95v 444.755n 0.95v 449.745n 0.95v 449.755n 0.95v 454.745n 0.95v 454.755n 0.95v 459.745n 0.95v 459.755n 0.95v 464.745n 0.95v 464.755n 0.95v 469.745n 0.95v 469.755n 0.0v 474.745n 0.0v 474.755n 0.0v 479.745n 0.0v 479.755n 0.0v 484.745n 0.0v 484.755n 0.0v 489.745n 0.0v 489.755n 0.95v 494.745n 0.95v 494.755n 0.95v 499.745n 0.95v 499.755n 0.95v 504.745n 0.95v 504.755n 0.95v 509.745n 0.95v 509.755n 0.95v 514.745n 0.95v 514.755n 0.95v 519.745n 0.95v 519.755n 0.95v 524.745n 0.95v 524.755n 0.95v 529.745n 0.95v 529.755n 0.95v 534.745n 0.95v 534.755n 0.95v 539.745n 0.95v 539.755n 0.95v 544.745n 0.95v 544.755n 0.95v 549.745n 0.95v 549.755n 0.95v 554.745n 0.95v 554.755n 0.95v 559.745n 0.95v 559.755n 0.95v 564.745n 0.95v 564.755n 0.95v 569.745n 0.95v 569.755n 0.95v 574.745n 0.95v 574.755n 0.95v 579.745n 0.95v 579.755n 0.95v 584.745n 0.95v 584.755n 0.95v 589.745n 0.95v 589.755n 0.95v 594.745n 0.95v 594.755n 0.95v 599.745n 0.95v 599.755n 0.0v 604.745n 0.0v 604.755n 0.0v 609.745n 0.0v 609.755n 0.95v 614.745n 0.95v 614.755n 0.0v 619.745n 0.0v 619.755n 0.0v 624.745n 0.0v 624.755n 0.0v 629.745n 0.0v 629.755n 0.0v 634.745n 0.0v 634.755n 0.0v 639.745n 0.0v 639.755n 0.0v 644.745n 0.0v 644.755n 0.0v 649.745n 0.0v 649.755n 0.0v 654.745n 0.0v 654.755n 0.0v 659.745n 0.0v 659.755n 0.0v 664.745n 0.0v 664.755n 0.0v 669.745n 0.0v 669.755n 0.0v 674.745n 0.0v 674.755n 0.0v 679.745n 0.0v 679.755n 0.0v 684.745n 0.0v 684.755n 0.0v 689.745n 0.0v 689.755n 0.0v 694.745n 0.0v 694.755n 0.0v 699.745n 0.0v 699.755n 0.0v 704.745n 0.0v 704.755n 0.0v 709.745n 0.0v 709.755n 0.0v 714.745n 0.0v 714.755n 0.0v 719.745n 0.0v 719.755n 0.0v 724.745n 0.0v 724.755n 0.0v 729.745n 0.0v 729.755n 0.0v 734.745n 0.0v 734.755n 0.0v 739.745n 0.0v 739.755n 0.0v 744.745n 0.0v 744.755n 0.0v 749.745n 0.0v 749.755n 0.0v 754.745n 0.0v 754.755n 0.0v 759.745n 0.0v 759.755n 0.0v 764.745n 0.0v 764.755n 0.0v 769.745n 0.0v 769.755n 0.0v 774.745n 0.0v 774.755n 0.0v 779.745n 0.0v 779.755n 0.95v 784.745n 0.95v 784.755n 0.95v 789.745n 0.95v 789.755n 0.95v 794.745n 0.95v 794.755n 0.95v 799.745n 0.95v 799.755n 0.0v 804.745n 0.0v 804.755n 0.0v 809.745n 0.0v 809.755n 0.0v 814.745n 0.0v 814.755n 0.0v 819.745n 0.0v 819.755n 0.95v 824.745n 0.95v 824.755n 0.95v 829.745n 0.95v 829.755n 0.0v 834.745n 0.0v 834.755n 0.0v 839.745n 0.0v 839.755n 0.0v 844.745n 0.0v 844.755n 0.0v 849.745n 0.0v 849.755n 0.0v 854.745n 0.0v 854.755n 0.95v 859.745n 0.95v 859.755n 0.95v 864.745n 0.95v 864.755n 0.95v 869.745n 0.95v 869.755n 0.95v 874.745n 0.95v 874.755n 0.95v 879.745n 0.95v 879.755n 0.95v 884.745n 0.95v 884.755n 0.95v 889.745n 0.95v 889.755n 0.0v 894.745n 0.0v 894.755n 0.0v 899.745n 0.0v 899.755n 0.0v 904.745n 0.0v 904.755n 0.0v 909.745n 0.0v 909.755n 0.95v 914.745n 0.95v 914.755n 0.95v 919.745n 0.95v 919.755n 0.95v 924.745n 0.95v 924.755n 0.95v 929.745n 0.95v 929.755n 0.95v 934.745n 0.95v 934.755n 0.95v 939.745n 0.95v 939.755n 0.95v 944.745n 0.95v 944.755n 0.0v 949.745n 0.0v 949.755n 0.95v 954.745n 0.95v 954.755n 0.95v 959.745n 0.95v 959.755n 0.95v 964.745n 0.95v 964.755n 0.95v 969.745n 0.95v 969.755n 0.95v 974.745n 0.95v 974.755n 0.95v 979.745n 0.95v 979.755n 0.95v 984.745n 0.95v 984.755n 0.0v 989.745n 0.0v 989.755n 0.0v 994.745n 0.0v 994.755n 0.0v 999.745n 0.0v 999.755n 0.0v 1004.745n 0.0v 1004.755n 0.0v 1009.745n 0.0v 1009.755n 0.0v 1014.745n 0.0v 1014.755n 0.0v 1019.745n 0.0v 1019.755n 0.0v 1024.745n 0.0v 1024.755n 0.0v )
* (time, data): [(0, 0), (5, 0), (10, 0), (15, 0), (20, 0), (25, 0), (30, 1), (35, 1), (40, 1), (45, 0), (50, 0), (55, 0), (60, 0), (65, 0), (70, 0), (75, 0), (80, 0), (85, 0), (90, 0), (95, 0), (100, 0), (105, 0), (110, 0), (115, 0), (120, 0), (125, 1), (130, 1), (135, 1), (140, 1), (145, 1), (150, 1), (155, 1), (160, 1), (165, 1), (170, 1), (175, 1), (180, 1), (185, 1), (190, 1), (195, 1), (200, 1), (205, 1), (210, 1), (215, 0), (220, 0), (225, 0), (230, 0), (235, 0), (240, 0), (245, 0), (250, 0), (255, 0), (260, 1), (265, 1), (270, 1), (275, 1), (280, 1), (285, 1), (290, 1), (295, 1), (300, 1), (305, 1), (310, 1), (315, 1), (320, 1), (325, 1), (330, 1), (335, 1), (340, 1), (345, 1), (350, 1), (355, 0), (360, 0), (365, 0), (370, 0), (375, 0), (380, 0), (385, 0), (390, 0), (395, 0), (400, 0), (405, 0), (410, 0), (415, 0), (420, 0), (425, 0), (430, 1), (435, 1), (440, 1), (445, 1), (450, 1), (455, 1), (460, 1), (465, 1), (470, 0), (475, 0), (480, 0), (485, 1), (490, 1), (495, 1), (500, 1), (505, 1), (510, 1), (515, 1), (520, 1), (525, 1), (530, 1), (535, 1), (540, 1), (545, 1), (550, 1), (555, 1), (560, 1), (565, 1), (570, 1), (575, 1), (580, 0), (585, 0), (590, 0), (595, 0), (600, 1), (605, 1), (610, 0), (615, 1), (620, 0), (625, 0), (630, 0), (635, 0), (640, 0), (645, 0), (650, 0), (655, 0), (660, 1), (665, 1), (670, 1), (675, 0), (680, 0), (685, 1), (690, 1), (695, 1), (700, 1), (705, 0), (710, 0), (715, 0), (720, 0), (725, 0), (730, 1), (735, 1), (740, 0), (745, 0), (750, 0), (755, 0), (760, 0), (765, 0), (770, 0), (775, 0), (780, 1), (785, 1), (790, 1), (795, 1), (800, 0), (805, 0), (810, 0), (815, 0), (820, 1), (825, 1), (830, 0), (835, 0), (840, 0), (845, 0), (850, 0), (855, 1), (860, 1), (865, 1), (870, 1), (875, 1), (880, 1), (885, 1), (890, 0), (895, 0), (900, 0), (905, 0), (910, 1), (915, 1), (920, 0), (925, 0), (930, 0), (935, 0), (940, 0), (945, 0), (950, 0), (955, 0), (960, 0), (965, 0), (970, 0), (975, 0), (980, 0), (985, 0), (990, 0), (995, 0), (1000, 0), (1005, 1), (1010, 1), (1015, 1), (1020, 1), (1025, 1)]
Vdin0_7  din0_7  0 PWL (0n 0.0v 4.745n 0.0v 4.755n 0.0v 9.745n 0.0v 9.755n 0.0v 14.745n 0.0v 14.755n 0.0v 19.745n 0.0v 19.755n 0.0v 24.745n 0.0v 24.755n 0.0v 29.745n 0.0v 29.755n 0.95v 34.745n 0.95v 34.755n 0.95v 39.745n 0.95v 39.755n 0.95v 44.745n 0.95v 44.755n 0.0v 49.745n 0.0v 49.755n 0.0v 54.745n 0.0v 54.755n 0.0v 59.745n 0.0v 59.755n 0.0v 64.745n 0.0v 64.755n 0.0v 69.745n 0.0v 69.755n 0.0v 74.745n 0.0v 74.755n 0.0v 79.745n 0.0v 79.755n 0.0v 84.745n 0.0v 84.755n 0.0v 89.745n 0.0v 89.755n 0.0v 94.745n 0.0v 94.755n 0.0v 99.745n 0.0v 99.755n 0.0v 104.745n 0.0v 104.755n 0.0v 109.745n 0.0v 109.755n 0.0v 114.745n 0.0v 114.755n 0.0v 119.745n 0.0v 119.755n 0.0v 124.745n 0.0v 124.755n 0.95v 129.745n 0.95v 129.755n 0.95v 134.745n 0.95v 134.755n 0.95v 139.745n 0.95v 139.755n 0.95v 144.745n 0.95v 144.755n 0.95v 149.745n 0.95v 149.755n 0.95v 154.745n 0.95v 154.755n 0.95v 159.745n 0.95v 159.755n 0.95v 164.745n 0.95v 164.755n 0.95v 169.745n 0.95v 169.755n 0.95v 174.745n 0.95v 174.755n 0.95v 179.745n 0.95v 179.755n 0.95v 184.745n 0.95v 184.755n 0.95v 189.745n 0.95v 189.755n 0.95v 194.745n 0.95v 194.755n 0.95v 199.745n 0.95v 199.755n 0.95v 204.745n 0.95v 204.755n 0.95v 209.745n 0.95v 209.755n 0.95v 214.745n 0.95v 214.755n 0.0v 219.745n 0.0v 219.755n 0.0v 224.745n 0.0v 224.755n 0.0v 229.745n 0.0v 229.755n 0.0v 234.745n 0.0v 234.755n 0.0v 239.745n 0.0v 239.755n 0.0v 244.745n 0.0v 244.755n 0.0v 249.745n 0.0v 249.755n 0.0v 254.745n 0.0v 254.755n 0.0v 259.745n 0.0v 259.755n 0.95v 264.745n 0.95v 264.755n 0.95v 269.745n 0.95v 269.755n 0.95v 274.745n 0.95v 274.755n 0.95v 279.745n 0.95v 279.755n 0.95v 284.745n 0.95v 284.755n 0.95v 289.745n 0.95v 289.755n 0.95v 294.745n 0.95v 294.755n 0.95v 299.745n 0.95v 299.755n 0.95v 304.745n 0.95v 304.755n 0.95v 309.745n 0.95v 309.755n 0.95v 314.745n 0.95v 314.755n 0.95v 319.745n 0.95v 319.755n 0.95v 324.745n 0.95v 324.755n 0.95v 329.745n 0.95v 329.755n 0.95v 334.745n 0.95v 334.755n 0.95v 339.745n 0.95v 339.755n 0.95v 344.745n 0.95v 344.755n 0.95v 349.745n 0.95v 349.755n 0.95v 354.745n 0.95v 354.755n 0.0v 359.745n 0.0v 359.755n 0.0v 364.745n 0.0v 364.755n 0.0v 369.745n 0.0v 369.755n 0.0v 374.745n 0.0v 374.755n 0.0v 379.745n 0.0v 379.755n 0.0v 384.745n 0.0v 384.755n 0.0v 389.745n 0.0v 389.755n 0.0v 394.745n 0.0v 394.755n 0.0v 399.745n 0.0v 399.755n 0.0v 404.745n 0.0v 404.755n 0.0v 409.745n 0.0v 409.755n 0.0v 414.745n 0.0v 414.755n 0.0v 419.745n 0.0v 419.755n 0.0v 424.745n 0.0v 424.755n 0.0v 429.745n 0.0v 429.755n 0.95v 434.745n 0.95v 434.755n 0.95v 439.745n 0.95v 439.755n 0.95v 444.745n 0.95v 444.755n 0.95v 449.745n 0.95v 449.755n 0.95v 454.745n 0.95v 454.755n 0.95v 459.745n 0.95v 459.755n 0.95v 464.745n 0.95v 464.755n 0.95v 469.745n 0.95v 469.755n 0.0v 474.745n 0.0v 474.755n 0.0v 479.745n 0.0v 479.755n 0.0v 484.745n 0.0v 484.755n 0.95v 489.745n 0.95v 489.755n 0.95v 494.745n 0.95v 494.755n 0.95v 499.745n 0.95v 499.755n 0.95v 504.745n 0.95v 504.755n 0.95v 509.745n 0.95v 509.755n 0.95v 514.745n 0.95v 514.755n 0.95v 519.745n 0.95v 519.755n 0.95v 524.745n 0.95v 524.755n 0.95v 529.745n 0.95v 529.755n 0.95v 534.745n 0.95v 534.755n 0.95v 539.745n 0.95v 539.755n 0.95v 544.745n 0.95v 544.755n 0.95v 549.745n 0.95v 549.755n 0.95v 554.745n 0.95v 554.755n 0.95v 559.745n 0.95v 559.755n 0.95v 564.745n 0.95v 564.755n 0.95v 569.745n 0.95v 569.755n 0.95v 574.745n 0.95v 574.755n 0.95v 579.745n 0.95v 579.755n 0.0v 584.745n 0.0v 584.755n 0.0v 589.745n 0.0v 589.755n 0.0v 594.745n 0.0v 594.755n 0.0v 599.745n 0.0v 599.755n 0.95v 604.745n 0.95v 604.755n 0.95v 609.745n 0.95v 609.755n 0.0v 614.745n 0.0v 614.755n 0.95v 619.745n 0.95v 619.755n 0.0v 624.745n 0.0v 624.755n 0.0v 629.745n 0.0v 629.755n 0.0v 634.745n 0.0v 634.755n 0.0v 639.745n 0.0v 639.755n 0.0v 644.745n 0.0v 644.755n 0.0v 649.745n 0.0v 649.755n 0.0v 654.745n 0.0v 654.755n 0.0v 659.745n 0.0v 659.755n 0.95v 664.745n 0.95v 664.755n 0.95v 669.745n 0.95v 669.755n 0.95v 674.745n 0.95v 674.755n 0.0v 679.745n 0.0v 679.755n 0.0v 684.745n 0.0v 684.755n 0.95v 689.745n 0.95v 689.755n 0.95v 694.745n 0.95v 694.755n 0.95v 699.745n 0.95v 699.755n 0.95v 704.745n 0.95v 704.755n 0.0v 709.745n 0.0v 709.755n 0.0v 714.745n 0.0v 714.755n 0.0v 719.745n 0.0v 719.755n 0.0v 724.745n 0.0v 724.755n 0.0v 729.745n 0.0v 729.755n 0.95v 734.745n 0.95v 734.755n 0.95v 739.745n 0.95v 739.755n 0.0v 744.745n 0.0v 744.755n 0.0v 749.745n 0.0v 749.755n 0.0v 754.745n 0.0v 754.755n 0.0v 759.745n 0.0v 759.755n 0.0v 764.745n 0.0v 764.755n 0.0v 769.745n 0.0v 769.755n 0.0v 774.745n 0.0v 774.755n 0.0v 779.745n 0.0v 779.755n 0.95v 784.745n 0.95v 784.755n 0.95v 789.745n 0.95v 789.755n 0.95v 794.745n 0.95v 794.755n 0.95v 799.745n 0.95v 799.755n 0.0v 804.745n 0.0v 804.755n 0.0v 809.745n 0.0v 809.755n 0.0v 814.745n 0.0v 814.755n 0.0v 819.745n 0.0v 819.755n 0.95v 824.745n 0.95v 824.755n 0.95v 829.745n 0.95v 829.755n 0.0v 834.745n 0.0v 834.755n 0.0v 839.745n 0.0v 839.755n 0.0v 844.745n 0.0v 844.755n 0.0v 849.745n 0.0v 849.755n 0.0v 854.745n 0.0v 854.755n 0.95v 859.745n 0.95v 859.755n 0.95v 864.745n 0.95v 864.755n 0.95v 869.745n 0.95v 869.755n 0.95v 874.745n 0.95v 874.755n 0.95v 879.745n 0.95v 879.755n 0.95v 884.745n 0.95v 884.755n 0.95v 889.745n 0.95v 889.755n 0.0v 894.745n 0.0v 894.755n 0.0v 899.745n 0.0v 899.755n 0.0v 904.745n 0.0v 904.755n 0.0v 909.745n 0.0v 909.755n 0.95v 914.745n 0.95v 914.755n 0.95v 919.745n 0.95v 919.755n 0.0v 924.745n 0.0v 924.755n 0.0v 929.745n 0.0v 929.755n 0.0v 934.745n 0.0v 934.755n 0.0v 939.745n 0.0v 939.755n 0.0v 944.745n 0.0v 944.755n 0.0v 949.745n 0.0v 949.755n 0.0v 954.745n 0.0v 954.755n 0.0v 959.745n 0.0v 959.755n 0.0v 964.745n 0.0v 964.755n 0.0v 969.745n 0.0v 969.755n 0.0v 974.745n 0.0v 974.755n 0.0v 979.745n 0.0v 979.755n 0.0v 984.745n 0.0v 984.755n 0.0v 989.745n 0.0v 989.755n 0.0v 994.745n 0.0v 994.755n 0.0v 999.745n 0.0v 999.755n 0.0v 1004.745n 0.0v 1004.755n 0.95v 1009.745n 0.95v 1009.755n 0.95v 1014.745n 0.95v 1014.755n 0.95v 1019.745n 0.95v 1019.755n 0.95v 1024.745n 0.95v 1024.755n 0.95v )
* (time, data): [(0, 0), (5, 1), (10, 1), (15, 0), (20, 0), (25, 0), (30, 1), (35, 1), (40, 1), (45, 0), (50, 0), (55, 0), (60, 0), (65, 0), (70, 0), (75, 0), (80, 0), (85, 0), (90, 0), (95, 0), (100, 0), (105, 0), (110, 0), (115, 0), (120, 0), (125, 1), (130, 1), (135, 1), (140, 1), (145, 1), (150, 1), (155, 1), (160, 1), (165, 1), (170, 1), (175, 1), (180, 1), (185, 0), (190, 0), (195, 0), (200, 0), (205, 0), (210, 0), (215, 1), (220, 1), (225, 1), (230, 1), (235, 1), (240, 1), (245, 0), (250, 0), (255, 0), (260, 1), (265, 0), (270, 0), (275, 0), (280, 0), (285, 0), (290, 0), (295, 0), (300, 0), (305, 0), (310, 0), (315, 0), (320, 0), (325, 0), (330, 0), (335, 0), (340, 0), (345, 0), (350, 0), (355, 0), (360, 0), (365, 0), (370, 0), (375, 0), (380, 0), (385, 0), (390, 1), (395, 1), (400, 1), (405, 0), (410, 0), (415, 0), (420, 0), (425, 0), (430, 0), (435, 0), (440, 0), (445, 0), (450, 0), (455, 0), (460, 0), (465, 0), (470, 1), (475, 1), (480, 1), (485, 0), (490, 0), (495, 0), (500, 0), (505, 0), (510, 0), (515, 0), (520, 0), (525, 0), (530, 0), (535, 0), (540, 0), (545, 0), (550, 0), (555, 0), (560, 0), (565, 0), (570, 0), (575, 0), (580, 0), (585, 0), (590, 1), (595, 1), (600, 1), (605, 1), (610, 0), (615, 0), (620, 1), (625, 1), (630, 1), (635, 1), (640, 1), (645, 1), (650, 1), (655, 1), (660, 1), (665, 1), (670, 1), (675, 0), (680, 0), (685, 0), (690, 0), (695, 0), (700, 0), (705, 0), (710, 0), (715, 0), (720, 0), (725, 0), (730, 0), (735, 0), (740, 0), (745, 0), (750, 0), (755, 0), (760, 0), (765, 0), (770, 0), (775, 0), (780, 0), (785, 0), (790, 0), (795, 0), (800, 0), (805, 0), (810, 0), (815, 0), (820, 0), (825, 0), (830, 1), (835, 1), (840, 1), (845, 1), (850, 1), (855, 0), (860, 0), (865, 0), (870, 0), (875, 0), (880, 1), (885, 1), (890, 0), (895, 0), (900, 0), (905, 0), (910, 1), (915, 1), (920, 0), (925, 0), (930, 0), (935, 0), (940, 0), (945, 0), (950, 0), (955, 0), (960, 0), (965, 0), (970, 0), (975, 0), (980, 0), (985, 0), (990, 0), (995, 0), (1000, 0), (1005, 1), (1010, 1), (1015, 1), (1020, 1), (1025, 1)]
Vdin0_8  din0_8  0 PWL (0n 0.0v 4.745n 0.0v 4.755n 0.95v 9.745n 0.95v 9.755n 0.95v 14.745n 0.95v 14.755n 0.0v 19.745n 0.0v 19.755n 0.0v 24.745n 0.0v 24.755n 0.0v 29.745n 0.0v 29.755n 0.95v 34.745n 0.95v 34.755n 0.95v 39.745n 0.95v 39.755n 0.95v 44.745n 0.95v 44.755n 0.0v 49.745n 0.0v 49.755n 0.0v 54.745n 0.0v 54.755n 0.0v 59.745n 0.0v 59.755n 0.0v 64.745n 0.0v 64.755n 0.0v 69.745n 0.0v 69.755n 0.0v 74.745n 0.0v 74.755n 0.0v 79.745n 0.0v 79.755n 0.0v 84.745n 0.0v 84.755n 0.0v 89.745n 0.0v 89.755n 0.0v 94.745n 0.0v 94.755n 0.0v 99.745n 0.0v 99.755n 0.0v 104.745n 0.0v 104.755n 0.0v 109.745n 0.0v 109.755n 0.0v 114.745n 0.0v 114.755n 0.0v 119.745n 0.0v 119.755n 0.0v 124.745n 0.0v 124.755n 0.95v 129.745n 0.95v 129.755n 0.95v 134.745n 0.95v 134.755n 0.95v 139.745n 0.95v 139.755n 0.95v 144.745n 0.95v 144.755n 0.95v 149.745n 0.95v 149.755n 0.95v 154.745n 0.95v 154.755n 0.95v 159.745n 0.95v 159.755n 0.95v 164.745n 0.95v 164.755n 0.95v 169.745n 0.95v 169.755n 0.95v 174.745n 0.95v 174.755n 0.95v 179.745n 0.95v 179.755n 0.95v 184.745n 0.95v 184.755n 0.0v 189.745n 0.0v 189.755n 0.0v 194.745n 0.0v 194.755n 0.0v 199.745n 0.0v 199.755n 0.0v 204.745n 0.0v 204.755n 0.0v 209.745n 0.0v 209.755n 0.0v 214.745n 0.0v 214.755n 0.95v 219.745n 0.95v 219.755n 0.95v 224.745n 0.95v 224.755n 0.95v 229.745n 0.95v 229.755n 0.95v 234.745n 0.95v 234.755n 0.95v 239.745n 0.95v 239.755n 0.95v 244.745n 0.95v 244.755n 0.0v 249.745n 0.0v 249.755n 0.0v 254.745n 0.0v 254.755n 0.0v 259.745n 0.0v 259.755n 0.95v 264.745n 0.95v 264.755n 0.0v 269.745n 0.0v 269.755n 0.0v 274.745n 0.0v 274.755n 0.0v 279.745n 0.0v 279.755n 0.0v 284.745n 0.0v 284.755n 0.0v 289.745n 0.0v 289.755n 0.0v 294.745n 0.0v 294.755n 0.0v 299.745n 0.0v 299.755n 0.0v 304.745n 0.0v 304.755n 0.0v 309.745n 0.0v 309.755n 0.0v 314.745n 0.0v 314.755n 0.0v 319.745n 0.0v 319.755n 0.0v 324.745n 0.0v 324.755n 0.0v 329.745n 0.0v 329.755n 0.0v 334.745n 0.0v 334.755n 0.0v 339.745n 0.0v 339.755n 0.0v 344.745n 0.0v 344.755n 0.0v 349.745n 0.0v 349.755n 0.0v 354.745n 0.0v 354.755n 0.0v 359.745n 0.0v 359.755n 0.0v 364.745n 0.0v 364.755n 0.0v 369.745n 0.0v 369.755n 0.0v 374.745n 0.0v 374.755n 0.0v 379.745n 0.0v 379.755n 0.0v 384.745n 0.0v 384.755n 0.0v 389.745n 0.0v 389.755n 0.95v 394.745n 0.95v 394.755n 0.95v 399.745n 0.95v 399.755n 0.95v 404.745n 0.95v 404.755n 0.0v 409.745n 0.0v 409.755n 0.0v 414.745n 0.0v 414.755n 0.0v 419.745n 0.0v 419.755n 0.0v 424.745n 0.0v 424.755n 0.0v 429.745n 0.0v 429.755n 0.0v 434.745n 0.0v 434.755n 0.0v 439.745n 0.0v 439.755n 0.0v 444.745n 0.0v 444.755n 0.0v 449.745n 0.0v 449.755n 0.0v 454.745n 0.0v 454.755n 0.0v 459.745n 0.0v 459.755n 0.0v 464.745n 0.0v 464.755n 0.0v 469.745n 0.0v 469.755n 0.95v 474.745n 0.95v 474.755n 0.95v 479.745n 0.95v 479.755n 0.95v 484.745n 0.95v 484.755n 0.0v 489.745n 0.0v 489.755n 0.0v 494.745n 0.0v 494.755n 0.0v 499.745n 0.0v 499.755n 0.0v 504.745n 0.0v 504.755n 0.0v 509.745n 0.0v 509.755n 0.0v 514.745n 0.0v 514.755n 0.0v 519.745n 0.0v 519.755n 0.0v 524.745n 0.0v 524.755n 0.0v 529.745n 0.0v 529.755n 0.0v 534.745n 0.0v 534.755n 0.0v 539.745n 0.0v 539.755n 0.0v 544.745n 0.0v 544.755n 0.0v 549.745n 0.0v 549.755n 0.0v 554.745n 0.0v 554.755n 0.0v 559.745n 0.0v 559.755n 0.0v 564.745n 0.0v 564.755n 0.0v 569.745n 0.0v 569.755n 0.0v 574.745n 0.0v 574.755n 0.0v 579.745n 0.0v 579.755n 0.0v 584.745n 0.0v 584.755n 0.0v 589.745n 0.0v 589.755n 0.95v 594.745n 0.95v 594.755n 0.95v 599.745n 0.95v 599.755n 0.95v 604.745n 0.95v 604.755n 0.95v 609.745n 0.95v 609.755n 0.0v 614.745n 0.0v 614.755n 0.0v 619.745n 0.0v 619.755n 0.95v 624.745n 0.95v 624.755n 0.95v 629.745n 0.95v 629.755n 0.95v 634.745n 0.95v 634.755n 0.95v 639.745n 0.95v 639.755n 0.95v 644.745n 0.95v 644.755n 0.95v 649.745n 0.95v 649.755n 0.95v 654.745n 0.95v 654.755n 0.95v 659.745n 0.95v 659.755n 0.95v 664.745n 0.95v 664.755n 0.95v 669.745n 0.95v 669.755n 0.95v 674.745n 0.95v 674.755n 0.0v 679.745n 0.0v 679.755n 0.0v 684.745n 0.0v 684.755n 0.0v 689.745n 0.0v 689.755n 0.0v 694.745n 0.0v 694.755n 0.0v 699.745n 0.0v 699.755n 0.0v 704.745n 0.0v 704.755n 0.0v 709.745n 0.0v 709.755n 0.0v 714.745n 0.0v 714.755n 0.0v 719.745n 0.0v 719.755n 0.0v 724.745n 0.0v 724.755n 0.0v 729.745n 0.0v 729.755n 0.0v 734.745n 0.0v 734.755n 0.0v 739.745n 0.0v 739.755n 0.0v 744.745n 0.0v 744.755n 0.0v 749.745n 0.0v 749.755n 0.0v 754.745n 0.0v 754.755n 0.0v 759.745n 0.0v 759.755n 0.0v 764.745n 0.0v 764.755n 0.0v 769.745n 0.0v 769.755n 0.0v 774.745n 0.0v 774.755n 0.0v 779.745n 0.0v 779.755n 0.0v 784.745n 0.0v 784.755n 0.0v 789.745n 0.0v 789.755n 0.0v 794.745n 0.0v 794.755n 0.0v 799.745n 0.0v 799.755n 0.0v 804.745n 0.0v 804.755n 0.0v 809.745n 0.0v 809.755n 0.0v 814.745n 0.0v 814.755n 0.0v 819.745n 0.0v 819.755n 0.0v 824.745n 0.0v 824.755n 0.0v 829.745n 0.0v 829.755n 0.95v 834.745n 0.95v 834.755n 0.95v 839.745n 0.95v 839.755n 0.95v 844.745n 0.95v 844.755n 0.95v 849.745n 0.95v 849.755n 0.95v 854.745n 0.95v 854.755n 0.0v 859.745n 0.0v 859.755n 0.0v 864.745n 0.0v 864.755n 0.0v 869.745n 0.0v 869.755n 0.0v 874.745n 0.0v 874.755n 0.0v 879.745n 0.0v 879.755n 0.95v 884.745n 0.95v 884.755n 0.95v 889.745n 0.95v 889.755n 0.0v 894.745n 0.0v 894.755n 0.0v 899.745n 0.0v 899.755n 0.0v 904.745n 0.0v 904.755n 0.0v 909.745n 0.0v 909.755n 0.95v 914.745n 0.95v 914.755n 0.95v 919.745n 0.95v 919.755n 0.0v 924.745n 0.0v 924.755n 0.0v 929.745n 0.0v 929.755n 0.0v 934.745n 0.0v 934.755n 0.0v 939.745n 0.0v 939.755n 0.0v 944.745n 0.0v 944.755n 0.0v 949.745n 0.0v 949.755n 0.0v 954.745n 0.0v 954.755n 0.0v 959.745n 0.0v 959.755n 0.0v 964.745n 0.0v 964.755n 0.0v 969.745n 0.0v 969.755n 0.0v 974.745n 0.0v 974.755n 0.0v 979.745n 0.0v 979.755n 0.0v 984.745n 0.0v 984.755n 0.0v 989.745n 0.0v 989.755n 0.0v 994.745n 0.0v 994.755n 0.0v 999.745n 0.0v 999.755n 0.0v 1004.745n 0.0v 1004.755n 0.95v 1009.745n 0.95v 1009.755n 0.95v 1014.745n 0.95v 1014.755n 0.95v 1019.745n 0.95v 1019.755n 0.95v 1024.745n 0.95v 1024.755n 0.95v )
* (time, data): [(0, 0), (5, 1), (10, 0), (15, 0), (20, 0), (25, 0), (30, 0), (35, 0), (40, 0), (45, 1), (50, 1), (55, 1), (60, 1), (65, 0), (70, 0), (75, 0), (80, 0), (85, 0), (90, 0), (95, 0), (100, 0), (105, 0), (110, 0), (115, 0), (120, 0), (125, 0), (130, 0), (135, 0), (140, 0), (145, 0), (150, 0), (155, 1), (160, 1), (165, 1), (170, 1), (175, 1), (180, 1), (185, 0), (190, 0), (195, 0), (200, 0), (205, 0), (210, 0), (215, 0), (220, 0), (225, 0), (230, 1), (235, 1), (240, 0), (245, 0), (250, 0), (255, 0), (260, 0), (265, 1), (270, 1), (275, 1), (280, 1), (285, 0), (290, 0), (295, 0), (300, 0), (305, 0), (310, 0), (315, 0), (320, 0), (325, 0), (330, 0), (335, 0), (340, 0), (345, 0), (350, 0), (355, 0), (360, 0), (365, 1), (370, 1), (375, 1), (380, 0), (385, 0), (390, 1), (395, 1), (400, 1), (405, 0), (410, 0), (415, 0), (420, 0), (425, 0), (430, 0), (435, 0), (440, 0), (445, 0), (450, 0), (455, 0), (460, 0), (465, 0), (470, 1), (475, 1), (480, 1), (485, 0), (490, 1), (495, 1), (500, 1), (505, 1), (510, 1), (515, 1), (520, 1), (525, 1), (530, 1), (535, 1), (540, 1), (545, 1), (550, 1), (555, 1), (560, 1), (565, 1), (570, 1), (575, 1), (580, 0), (585, 0), (590, 1), (595, 1), (600, 0), (605, 0), (610, 1), (615, 0), (620, 1), (625, 1), (630, 1), (635, 1), (640, 1), (645, 1), (650, 1), (655, 1), (660, 1), (665, 1), (670, 1), (675, 1), (680, 1), (685, 0), (690, 0), (695, 0), (700, 0), (705, 0), (710, 1), (715, 1), (720, 1), (725, 1), (730, 0), (735, 0), (740, 1), (745, 1), (750, 1), (755, 1), (760, 1), (765, 1), (770, 1), (775, 1), (780, 1), (785, 1), (790, 1), (795, 1), (800, 1), (805, 1), (810, 1), (815, 1), (820, 1), (825, 1), (830, 1), (835, 1), (840, 1), (845, 1), (850, 1), (855, 1), (860, 1), (865, 1), (870, 1), (875, 1), (880, 1), (885, 1), (890, 1), (895, 1), (900, 1), (905, 1), (910, 0), (915, 0), (920, 0), (925, 0), (930, 0), (935, 0), (940, 0), (945, 0), (950, 0), (955, 0), (960, 0), (965, 0), (970, 0), (975, 0), (980, 0), (985, 1), (990, 1), (995, 1), (1000, 1), (1005, 0), (1010, 0), (1015, 0), (1020, 0), (1025, 0)]
Vdin0_9  din0_9  0 PWL (0n 0.0v 4.745n 0.0v 4.755n 0.95v 9.745n 0.95v 9.755n 0.0v 14.745n 0.0v 14.755n 0.0v 19.745n 0.0v 19.755n 0.0v 24.745n 0.0v 24.755n 0.0v 29.745n 0.0v 29.755n 0.0v 34.745n 0.0v 34.755n 0.0v 39.745n 0.0v 39.755n 0.0v 44.745n 0.0v 44.755n 0.95v 49.745n 0.95v 49.755n 0.95v 54.745n 0.95v 54.755n 0.95v 59.745n 0.95v 59.755n 0.95v 64.745n 0.95v 64.755n 0.0v 69.745n 0.0v 69.755n 0.0v 74.745n 0.0v 74.755n 0.0v 79.745n 0.0v 79.755n 0.0v 84.745n 0.0v 84.755n 0.0v 89.745n 0.0v 89.755n 0.0v 94.745n 0.0v 94.755n 0.0v 99.745n 0.0v 99.755n 0.0v 104.745n 0.0v 104.755n 0.0v 109.745n 0.0v 109.755n 0.0v 114.745n 0.0v 114.755n 0.0v 119.745n 0.0v 119.755n 0.0v 124.745n 0.0v 124.755n 0.0v 129.745n 0.0v 129.755n 0.0v 134.745n 0.0v 134.755n 0.0v 139.745n 0.0v 139.755n 0.0v 144.745n 0.0v 144.755n 0.0v 149.745n 0.0v 149.755n 0.0v 154.745n 0.0v 154.755n 0.95v 159.745n 0.95v 159.755n 0.95v 164.745n 0.95v 164.755n 0.95v 169.745n 0.95v 169.755n 0.95v 174.745n 0.95v 174.755n 0.95v 179.745n 0.95v 179.755n 0.95v 184.745n 0.95v 184.755n 0.0v 189.745n 0.0v 189.755n 0.0v 194.745n 0.0v 194.755n 0.0v 199.745n 0.0v 199.755n 0.0v 204.745n 0.0v 204.755n 0.0v 209.745n 0.0v 209.755n 0.0v 214.745n 0.0v 214.755n 0.0v 219.745n 0.0v 219.755n 0.0v 224.745n 0.0v 224.755n 0.0v 229.745n 0.0v 229.755n 0.95v 234.745n 0.95v 234.755n 0.95v 239.745n 0.95v 239.755n 0.0v 244.745n 0.0v 244.755n 0.0v 249.745n 0.0v 249.755n 0.0v 254.745n 0.0v 254.755n 0.0v 259.745n 0.0v 259.755n 0.0v 264.745n 0.0v 264.755n 0.95v 269.745n 0.95v 269.755n 0.95v 274.745n 0.95v 274.755n 0.95v 279.745n 0.95v 279.755n 0.95v 284.745n 0.95v 284.755n 0.0v 289.745n 0.0v 289.755n 0.0v 294.745n 0.0v 294.755n 0.0v 299.745n 0.0v 299.755n 0.0v 304.745n 0.0v 304.755n 0.0v 309.745n 0.0v 309.755n 0.0v 314.745n 0.0v 314.755n 0.0v 319.745n 0.0v 319.755n 0.0v 324.745n 0.0v 324.755n 0.0v 329.745n 0.0v 329.755n 0.0v 334.745n 0.0v 334.755n 0.0v 339.745n 0.0v 339.755n 0.0v 344.745n 0.0v 344.755n 0.0v 349.745n 0.0v 349.755n 0.0v 354.745n 0.0v 354.755n 0.0v 359.745n 0.0v 359.755n 0.0v 364.745n 0.0v 364.755n 0.95v 369.745n 0.95v 369.755n 0.95v 374.745n 0.95v 374.755n 0.95v 379.745n 0.95v 379.755n 0.0v 384.745n 0.0v 384.755n 0.0v 389.745n 0.0v 389.755n 0.95v 394.745n 0.95v 394.755n 0.95v 399.745n 0.95v 399.755n 0.95v 404.745n 0.95v 404.755n 0.0v 409.745n 0.0v 409.755n 0.0v 414.745n 0.0v 414.755n 0.0v 419.745n 0.0v 419.755n 0.0v 424.745n 0.0v 424.755n 0.0v 429.745n 0.0v 429.755n 0.0v 434.745n 0.0v 434.755n 0.0v 439.745n 0.0v 439.755n 0.0v 444.745n 0.0v 444.755n 0.0v 449.745n 0.0v 449.755n 0.0v 454.745n 0.0v 454.755n 0.0v 459.745n 0.0v 459.755n 0.0v 464.745n 0.0v 464.755n 0.0v 469.745n 0.0v 469.755n 0.95v 474.745n 0.95v 474.755n 0.95v 479.745n 0.95v 479.755n 0.95v 484.745n 0.95v 484.755n 0.0v 489.745n 0.0v 489.755n 0.95v 494.745n 0.95v 494.755n 0.95v 499.745n 0.95v 499.755n 0.95v 504.745n 0.95v 504.755n 0.95v 509.745n 0.95v 509.755n 0.95v 514.745n 0.95v 514.755n 0.95v 519.745n 0.95v 519.755n 0.95v 524.745n 0.95v 524.755n 0.95v 529.745n 0.95v 529.755n 0.95v 534.745n 0.95v 534.755n 0.95v 539.745n 0.95v 539.755n 0.95v 544.745n 0.95v 544.755n 0.95v 549.745n 0.95v 549.755n 0.95v 554.745n 0.95v 554.755n 0.95v 559.745n 0.95v 559.755n 0.95v 564.745n 0.95v 564.755n 0.95v 569.745n 0.95v 569.755n 0.95v 574.745n 0.95v 574.755n 0.95v 579.745n 0.95v 579.755n 0.0v 584.745n 0.0v 584.755n 0.0v 589.745n 0.0v 589.755n 0.95v 594.745n 0.95v 594.755n 0.95v 599.745n 0.95v 599.755n 0.0v 604.745n 0.0v 604.755n 0.0v 609.745n 0.0v 609.755n 0.95v 614.745n 0.95v 614.755n 0.0v 619.745n 0.0v 619.755n 0.95v 624.745n 0.95v 624.755n 0.95v 629.745n 0.95v 629.755n 0.95v 634.745n 0.95v 634.755n 0.95v 639.745n 0.95v 639.755n 0.95v 644.745n 0.95v 644.755n 0.95v 649.745n 0.95v 649.755n 0.95v 654.745n 0.95v 654.755n 0.95v 659.745n 0.95v 659.755n 0.95v 664.745n 0.95v 664.755n 0.95v 669.745n 0.95v 669.755n 0.95v 674.745n 0.95v 674.755n 0.95v 679.745n 0.95v 679.755n 0.95v 684.745n 0.95v 684.755n 0.0v 689.745n 0.0v 689.755n 0.0v 694.745n 0.0v 694.755n 0.0v 699.745n 0.0v 699.755n 0.0v 704.745n 0.0v 704.755n 0.0v 709.745n 0.0v 709.755n 0.95v 714.745n 0.95v 714.755n 0.95v 719.745n 0.95v 719.755n 0.95v 724.745n 0.95v 724.755n 0.95v 729.745n 0.95v 729.755n 0.0v 734.745n 0.0v 734.755n 0.0v 739.745n 0.0v 739.755n 0.95v 744.745n 0.95v 744.755n 0.95v 749.745n 0.95v 749.755n 0.95v 754.745n 0.95v 754.755n 0.95v 759.745n 0.95v 759.755n 0.95v 764.745n 0.95v 764.755n 0.95v 769.745n 0.95v 769.755n 0.95v 774.745n 0.95v 774.755n 0.95v 779.745n 0.95v 779.755n 0.95v 784.745n 0.95v 784.755n 0.95v 789.745n 0.95v 789.755n 0.95v 794.745n 0.95v 794.755n 0.95v 799.745n 0.95v 799.755n 0.95v 804.745n 0.95v 804.755n 0.95v 809.745n 0.95v 809.755n 0.95v 814.745n 0.95v 814.755n 0.95v 819.745n 0.95v 819.755n 0.95v 824.745n 0.95v 824.755n 0.95v 829.745n 0.95v 829.755n 0.95v 834.745n 0.95v 834.755n 0.95v 839.745n 0.95v 839.755n 0.95v 844.745n 0.95v 844.755n 0.95v 849.745n 0.95v 849.755n 0.95v 854.745n 0.95v 854.755n 0.95v 859.745n 0.95v 859.755n 0.95v 864.745n 0.95v 864.755n 0.95v 869.745n 0.95v 869.755n 0.95v 874.745n 0.95v 874.755n 0.95v 879.745n 0.95v 879.755n 0.95v 884.745n 0.95v 884.755n 0.95v 889.745n 0.95v 889.755n 0.95v 894.745n 0.95v 894.755n 0.95v 899.745n 0.95v 899.755n 0.95v 904.745n 0.95v 904.755n 0.95v 909.745n 0.95v 909.755n 0.0v 914.745n 0.0v 914.755n 0.0v 919.745n 0.0v 919.755n 0.0v 924.745n 0.0v 924.755n 0.0v 929.745n 0.0v 929.755n 0.0v 934.745n 0.0v 934.755n 0.0v 939.745n 0.0v 939.755n 0.0v 944.745n 0.0v 944.755n 0.0v 949.745n 0.0v 949.755n 0.0v 954.745n 0.0v 954.755n 0.0v 959.745n 0.0v 959.755n 0.0v 964.745n 0.0v 964.755n 0.0v 969.745n 0.0v 969.755n 0.0v 974.745n 0.0v 974.755n 0.0v 979.745n 0.0v 979.755n 0.0v 984.745n 0.0v 984.755n 0.95v 989.745n 0.95v 989.755n 0.95v 994.745n 0.95v 994.755n 0.95v 999.745n 0.95v 999.755n 0.95v 1004.745n 0.95v 1004.755n 0.0v 1009.745n 0.0v 1009.755n 0.0v 1014.745n 0.0v 1014.755n 0.0v 1019.745n 0.0v 1019.755n 0.0v 1024.745n 0.0v 1024.755n 0.0v )
* (time, data): [(0, 0), (5, 1), (10, 1), (15, 1), (20, 1), (25, 1), (30, 0), (35, 0), (40, 0), (45, 0), (50, 0), (55, 0), (60, 0), (65, 0), (70, 0), (75, 0), (80, 0), (85, 0), (90, 0), (95, 0), (100, 0), (105, 0), (110, 0), (115, 0), (120, 0), (125, 0), (130, 0), (135, 0), (140, 0), (145, 0), (150, 0), (155, 1), (160, 1), (165, 1), (170, 1), (175, 1), (180, 1), (185, 0), (190, 0), (195, 0), (200, 0), (205, 0), (210, 0), (215, 0), (220, 1), (225, 1), (230, 0), (235, 0), (240, 0), (245, 1), (250, 1), (255, 1), (260, 0), (265, 1), (270, 1), (275, 1), (280, 1), (285, 0), (290, 0), (295, 0), (300, 0), (305, 0), (310, 0), (315, 0), (320, 0), (325, 0), (330, 0), (335, 0), (340, 0), (345, 0), (350, 0), (355, 1), (360, 1), (365, 0), (370, 0), (375, 0), (380, 0), (385, 0), (390, 0), (395, 0), (400, 0), (405, 0), (410, 0), (415, 0), (420, 0), (425, 0), (430, 0), (435, 0), (440, 0), (445, 0), (450, 0), (455, 0), (460, 0), (465, 0), (470, 1), (475, 1), (480, 1), (485, 0), (490, 0), (495, 0), (500, 0), (505, 0), (510, 0), (515, 0), (520, 0), (525, 0), (530, 0), (535, 0), (540, 0), (545, 0), (550, 0), (555, 0), (560, 0), (565, 0), (570, 0), (575, 0), (580, 0), (585, 0), (590, 1), (595, 1), (600, 1), (605, 1), (610, 0), (615, 1), (620, 1), (625, 1), (630, 1), (635, 1), (640, 1), (645, 1), (650, 1), (655, 1), (660, 1), (665, 1), (670, 1), (675, 0), (680, 0), (685, 0), (690, 0), (695, 0), (700, 0), (705, 0), (710, 1), (715, 1), (720, 1), (725, 1), (730, 0), (735, 1), (740, 1), (745, 1), (750, 1), (755, 1), (760, 1), (765, 1), (770, 1), (775, 1), (780, 1), (785, 1), (790, 1), (795, 1), (800, 0), (805, 0), (810, 0), (815, 0), (820, 1), (825, 1), (830, 0), (835, 0), (840, 0), (845, 0), (850, 0), (855, 0), (860, 0), (865, 0), (870, 0), (875, 0), (880, 1), (885, 1), (890, 0), (895, 0), (900, 0), (905, 0), (910, 1), (915, 1), (920, 1), (925, 1), (930, 1), (935, 1), (940, 1), (945, 0), (950, 0), (955, 0), (960, 0), (965, 0), (970, 0), (975, 0), (980, 0), (985, 1), (990, 1), (995, 1), (1000, 1), (1005, 0), (1010, 0), (1015, 0), (1020, 0), (1025, 0)]
Vdin0_10  din0_10  0 PWL (0n 0.0v 4.745n 0.0v 4.755n 0.95v 9.745n 0.95v 9.755n 0.95v 14.745n 0.95v 14.755n 0.95v 19.745n 0.95v 19.755n 0.95v 24.745n 0.95v 24.755n 0.95v 29.745n 0.95v 29.755n 0.0v 34.745n 0.0v 34.755n 0.0v 39.745n 0.0v 39.755n 0.0v 44.745n 0.0v 44.755n 0.0v 49.745n 0.0v 49.755n 0.0v 54.745n 0.0v 54.755n 0.0v 59.745n 0.0v 59.755n 0.0v 64.745n 0.0v 64.755n 0.0v 69.745n 0.0v 69.755n 0.0v 74.745n 0.0v 74.755n 0.0v 79.745n 0.0v 79.755n 0.0v 84.745n 0.0v 84.755n 0.0v 89.745n 0.0v 89.755n 0.0v 94.745n 0.0v 94.755n 0.0v 99.745n 0.0v 99.755n 0.0v 104.745n 0.0v 104.755n 0.0v 109.745n 0.0v 109.755n 0.0v 114.745n 0.0v 114.755n 0.0v 119.745n 0.0v 119.755n 0.0v 124.745n 0.0v 124.755n 0.0v 129.745n 0.0v 129.755n 0.0v 134.745n 0.0v 134.755n 0.0v 139.745n 0.0v 139.755n 0.0v 144.745n 0.0v 144.755n 0.0v 149.745n 0.0v 149.755n 0.0v 154.745n 0.0v 154.755n 0.95v 159.745n 0.95v 159.755n 0.95v 164.745n 0.95v 164.755n 0.95v 169.745n 0.95v 169.755n 0.95v 174.745n 0.95v 174.755n 0.95v 179.745n 0.95v 179.755n 0.95v 184.745n 0.95v 184.755n 0.0v 189.745n 0.0v 189.755n 0.0v 194.745n 0.0v 194.755n 0.0v 199.745n 0.0v 199.755n 0.0v 204.745n 0.0v 204.755n 0.0v 209.745n 0.0v 209.755n 0.0v 214.745n 0.0v 214.755n 0.0v 219.745n 0.0v 219.755n 0.95v 224.745n 0.95v 224.755n 0.95v 229.745n 0.95v 229.755n 0.0v 234.745n 0.0v 234.755n 0.0v 239.745n 0.0v 239.755n 0.0v 244.745n 0.0v 244.755n 0.95v 249.745n 0.95v 249.755n 0.95v 254.745n 0.95v 254.755n 0.95v 259.745n 0.95v 259.755n 0.0v 264.745n 0.0v 264.755n 0.95v 269.745n 0.95v 269.755n 0.95v 274.745n 0.95v 274.755n 0.95v 279.745n 0.95v 279.755n 0.95v 284.745n 0.95v 284.755n 0.0v 289.745n 0.0v 289.755n 0.0v 294.745n 0.0v 294.755n 0.0v 299.745n 0.0v 299.755n 0.0v 304.745n 0.0v 304.755n 0.0v 309.745n 0.0v 309.755n 0.0v 314.745n 0.0v 314.755n 0.0v 319.745n 0.0v 319.755n 0.0v 324.745n 0.0v 324.755n 0.0v 329.745n 0.0v 329.755n 0.0v 334.745n 0.0v 334.755n 0.0v 339.745n 0.0v 339.755n 0.0v 344.745n 0.0v 344.755n 0.0v 349.745n 0.0v 349.755n 0.0v 354.745n 0.0v 354.755n 0.95v 359.745n 0.95v 359.755n 0.95v 364.745n 0.95v 364.755n 0.0v 369.745n 0.0v 369.755n 0.0v 374.745n 0.0v 374.755n 0.0v 379.745n 0.0v 379.755n 0.0v 384.745n 0.0v 384.755n 0.0v 389.745n 0.0v 389.755n 0.0v 394.745n 0.0v 394.755n 0.0v 399.745n 0.0v 399.755n 0.0v 404.745n 0.0v 404.755n 0.0v 409.745n 0.0v 409.755n 0.0v 414.745n 0.0v 414.755n 0.0v 419.745n 0.0v 419.755n 0.0v 424.745n 0.0v 424.755n 0.0v 429.745n 0.0v 429.755n 0.0v 434.745n 0.0v 434.755n 0.0v 439.745n 0.0v 439.755n 0.0v 444.745n 0.0v 444.755n 0.0v 449.745n 0.0v 449.755n 0.0v 454.745n 0.0v 454.755n 0.0v 459.745n 0.0v 459.755n 0.0v 464.745n 0.0v 464.755n 0.0v 469.745n 0.0v 469.755n 0.95v 474.745n 0.95v 474.755n 0.95v 479.745n 0.95v 479.755n 0.95v 484.745n 0.95v 484.755n 0.0v 489.745n 0.0v 489.755n 0.0v 494.745n 0.0v 494.755n 0.0v 499.745n 0.0v 499.755n 0.0v 504.745n 0.0v 504.755n 0.0v 509.745n 0.0v 509.755n 0.0v 514.745n 0.0v 514.755n 0.0v 519.745n 0.0v 519.755n 0.0v 524.745n 0.0v 524.755n 0.0v 529.745n 0.0v 529.755n 0.0v 534.745n 0.0v 534.755n 0.0v 539.745n 0.0v 539.755n 0.0v 544.745n 0.0v 544.755n 0.0v 549.745n 0.0v 549.755n 0.0v 554.745n 0.0v 554.755n 0.0v 559.745n 0.0v 559.755n 0.0v 564.745n 0.0v 564.755n 0.0v 569.745n 0.0v 569.755n 0.0v 574.745n 0.0v 574.755n 0.0v 579.745n 0.0v 579.755n 0.0v 584.745n 0.0v 584.755n 0.0v 589.745n 0.0v 589.755n 0.95v 594.745n 0.95v 594.755n 0.95v 599.745n 0.95v 599.755n 0.95v 604.745n 0.95v 604.755n 0.95v 609.745n 0.95v 609.755n 0.0v 614.745n 0.0v 614.755n 0.95v 619.745n 0.95v 619.755n 0.95v 624.745n 0.95v 624.755n 0.95v 629.745n 0.95v 629.755n 0.95v 634.745n 0.95v 634.755n 0.95v 639.745n 0.95v 639.755n 0.95v 644.745n 0.95v 644.755n 0.95v 649.745n 0.95v 649.755n 0.95v 654.745n 0.95v 654.755n 0.95v 659.745n 0.95v 659.755n 0.95v 664.745n 0.95v 664.755n 0.95v 669.745n 0.95v 669.755n 0.95v 674.745n 0.95v 674.755n 0.0v 679.745n 0.0v 679.755n 0.0v 684.745n 0.0v 684.755n 0.0v 689.745n 0.0v 689.755n 0.0v 694.745n 0.0v 694.755n 0.0v 699.745n 0.0v 699.755n 0.0v 704.745n 0.0v 704.755n 0.0v 709.745n 0.0v 709.755n 0.95v 714.745n 0.95v 714.755n 0.95v 719.745n 0.95v 719.755n 0.95v 724.745n 0.95v 724.755n 0.95v 729.745n 0.95v 729.755n 0.0v 734.745n 0.0v 734.755n 0.95v 739.745n 0.95v 739.755n 0.95v 744.745n 0.95v 744.755n 0.95v 749.745n 0.95v 749.755n 0.95v 754.745n 0.95v 754.755n 0.95v 759.745n 0.95v 759.755n 0.95v 764.745n 0.95v 764.755n 0.95v 769.745n 0.95v 769.755n 0.95v 774.745n 0.95v 774.755n 0.95v 779.745n 0.95v 779.755n 0.95v 784.745n 0.95v 784.755n 0.95v 789.745n 0.95v 789.755n 0.95v 794.745n 0.95v 794.755n 0.95v 799.745n 0.95v 799.755n 0.0v 804.745n 0.0v 804.755n 0.0v 809.745n 0.0v 809.755n 0.0v 814.745n 0.0v 814.755n 0.0v 819.745n 0.0v 819.755n 0.95v 824.745n 0.95v 824.755n 0.95v 829.745n 0.95v 829.755n 0.0v 834.745n 0.0v 834.755n 0.0v 839.745n 0.0v 839.755n 0.0v 844.745n 0.0v 844.755n 0.0v 849.745n 0.0v 849.755n 0.0v 854.745n 0.0v 854.755n 0.0v 859.745n 0.0v 859.755n 0.0v 864.745n 0.0v 864.755n 0.0v 869.745n 0.0v 869.755n 0.0v 874.745n 0.0v 874.755n 0.0v 879.745n 0.0v 879.755n 0.95v 884.745n 0.95v 884.755n 0.95v 889.745n 0.95v 889.755n 0.0v 894.745n 0.0v 894.755n 0.0v 899.745n 0.0v 899.755n 0.0v 904.745n 0.0v 904.755n 0.0v 909.745n 0.0v 909.755n 0.95v 914.745n 0.95v 914.755n 0.95v 919.745n 0.95v 919.755n 0.95v 924.745n 0.95v 924.755n 0.95v 929.745n 0.95v 929.755n 0.95v 934.745n 0.95v 934.755n 0.95v 939.745n 0.95v 939.755n 0.95v 944.745n 0.95v 944.755n 0.0v 949.745n 0.0v 949.755n 0.0v 954.745n 0.0v 954.755n 0.0v 959.745n 0.0v 959.755n 0.0v 964.745n 0.0v 964.755n 0.0v 969.745n 0.0v 969.755n 0.0v 974.745n 0.0v 974.755n 0.0v 979.745n 0.0v 979.755n 0.0v 984.745n 0.0v 984.755n 0.95v 989.745n 0.95v 989.755n 0.95v 994.745n 0.95v 994.755n 0.95v 999.745n 0.95v 999.755n 0.95v 1004.745n 0.95v 1004.755n 0.0v 1009.745n 0.0v 1009.755n 0.0v 1014.745n 0.0v 1014.755n 0.0v 1019.745n 0.0v 1019.755n 0.0v 1024.745n 0.0v 1024.755n 0.0v )
* (time, data): [(0, 0), (5, 0), (10, 0), (15, 0), (20, 0), (25, 0), (30, 0), (35, 0), (40, 0), (45, 1), (50, 1), (55, 1), (60, 1), (65, 0), (70, 0), (75, 0), (80, 0), (85, 0), (90, 0), (95, 0), (100, 0), (105, 0), (110, 0), (115, 0), (120, 0), (125, 1), (130, 1), (135, 1), (140, 1), (145, 1), (150, 1), (155, 1), (160, 1), (165, 1), (170, 1), (175, 1), (180, 1), (185, 1), (190, 1), (195, 1), (200, 1), (205, 1), (210, 1), (215, 0), (220, 1), (225, 1), (230, 0), (235, 0), (240, 0), (245, 1), (250, 1), (255, 1), (260, 0), (265, 0), (270, 0), (275, 0), (280, 0), (285, 1), (290, 1), (295, 1), (300, 1), (305, 1), (310, 1), (315, 1), (320, 1), (325, 1), (330, 1), (335, 1), (340, 1), (345, 1), (350, 1), (355, 0), (360, 0), (365, 0), (370, 0), (375, 0), (380, 1), (385, 1), (390, 0), (395, 0), (400, 0), (405, 1), (410, 1), (415, 1), (420, 1), (425, 1), (430, 1), (435, 1), (440, 1), (445, 1), (450, 1), (455, 1), (460, 1), (465, 1), (470, 0), (475, 0), (480, 0), (485, 1), (490, 1), (495, 1), (500, 1), (505, 1), (510, 1), (515, 1), (520, 1), (525, 1), (530, 1), (535, 1), (540, 1), (545, 1), (550, 1), (555, 1), (560, 1), (565, 1), (570, 1), (575, 1), (580, 0), (585, 0), (590, 0), (595, 0), (600, 1), (605, 1), (610, 1), (615, 1), (620, 0), (625, 0), (630, 0), (635, 0), (640, 0), (645, 0), (650, 0), (655, 0), (660, 1), (665, 1), (670, 1), (675, 1), (680, 1), (685, 0), (690, 0), (695, 0), (700, 0), (705, 0), (710, 1), (715, 1), (720, 1), (725, 1), (730, 1), (735, 1), (740, 0), (745, 0), (750, 0), (755, 0), (760, 0), (765, 0), (770, 0), (775, 0), (780, 0), (785, 0), (790, 0), (795, 0), (800, 0), (805, 0), (810, 0), (815, 0), (820, 1), (825, 1), (830, 1), (835, 1), (840, 1), (845, 1), (850, 1), (855, 0), (860, 0), (865, 0), (870, 0), (875, 0), (880, 0), (885, 0), (890, 1), (895, 1), (900, 1), (905, 1), (910, 1), (915, 1), (920, 1), (925, 1), (930, 1), (935, 1), (940, 1), (945, 0), (950, 1), (955, 1), (960, 0), (965, 0), (970, 0), (975, 0), (980, 0), (985, 1), (990, 1), (995, 1), (1000, 1), (1005, 0), (1010, 0), (1015, 0), (1020, 0), (1025, 0)]
Vdin0_11  din0_11  0 PWL (0n 0.0v 4.745n 0.0v 4.755n 0.0v 9.745n 0.0v 9.755n 0.0v 14.745n 0.0v 14.755n 0.0v 19.745n 0.0v 19.755n 0.0v 24.745n 0.0v 24.755n 0.0v 29.745n 0.0v 29.755n 0.0v 34.745n 0.0v 34.755n 0.0v 39.745n 0.0v 39.755n 0.0v 44.745n 0.0v 44.755n 0.95v 49.745n 0.95v 49.755n 0.95v 54.745n 0.95v 54.755n 0.95v 59.745n 0.95v 59.755n 0.95v 64.745n 0.95v 64.755n 0.0v 69.745n 0.0v 69.755n 0.0v 74.745n 0.0v 74.755n 0.0v 79.745n 0.0v 79.755n 0.0v 84.745n 0.0v 84.755n 0.0v 89.745n 0.0v 89.755n 0.0v 94.745n 0.0v 94.755n 0.0v 99.745n 0.0v 99.755n 0.0v 104.745n 0.0v 104.755n 0.0v 109.745n 0.0v 109.755n 0.0v 114.745n 0.0v 114.755n 0.0v 119.745n 0.0v 119.755n 0.0v 124.745n 0.0v 124.755n 0.95v 129.745n 0.95v 129.755n 0.95v 134.745n 0.95v 134.755n 0.95v 139.745n 0.95v 139.755n 0.95v 144.745n 0.95v 144.755n 0.95v 149.745n 0.95v 149.755n 0.95v 154.745n 0.95v 154.755n 0.95v 159.745n 0.95v 159.755n 0.95v 164.745n 0.95v 164.755n 0.95v 169.745n 0.95v 169.755n 0.95v 174.745n 0.95v 174.755n 0.95v 179.745n 0.95v 179.755n 0.95v 184.745n 0.95v 184.755n 0.95v 189.745n 0.95v 189.755n 0.95v 194.745n 0.95v 194.755n 0.95v 199.745n 0.95v 199.755n 0.95v 204.745n 0.95v 204.755n 0.95v 209.745n 0.95v 209.755n 0.95v 214.745n 0.95v 214.755n 0.0v 219.745n 0.0v 219.755n 0.95v 224.745n 0.95v 224.755n 0.95v 229.745n 0.95v 229.755n 0.0v 234.745n 0.0v 234.755n 0.0v 239.745n 0.0v 239.755n 0.0v 244.745n 0.0v 244.755n 0.95v 249.745n 0.95v 249.755n 0.95v 254.745n 0.95v 254.755n 0.95v 259.745n 0.95v 259.755n 0.0v 264.745n 0.0v 264.755n 0.0v 269.745n 0.0v 269.755n 0.0v 274.745n 0.0v 274.755n 0.0v 279.745n 0.0v 279.755n 0.0v 284.745n 0.0v 284.755n 0.95v 289.745n 0.95v 289.755n 0.95v 294.745n 0.95v 294.755n 0.95v 299.745n 0.95v 299.755n 0.95v 304.745n 0.95v 304.755n 0.95v 309.745n 0.95v 309.755n 0.95v 314.745n 0.95v 314.755n 0.95v 319.745n 0.95v 319.755n 0.95v 324.745n 0.95v 324.755n 0.95v 329.745n 0.95v 329.755n 0.95v 334.745n 0.95v 334.755n 0.95v 339.745n 0.95v 339.755n 0.95v 344.745n 0.95v 344.755n 0.95v 349.745n 0.95v 349.755n 0.95v 354.745n 0.95v 354.755n 0.0v 359.745n 0.0v 359.755n 0.0v 364.745n 0.0v 364.755n 0.0v 369.745n 0.0v 369.755n 0.0v 374.745n 0.0v 374.755n 0.0v 379.745n 0.0v 379.755n 0.95v 384.745n 0.95v 384.755n 0.95v 389.745n 0.95v 389.755n 0.0v 394.745n 0.0v 394.755n 0.0v 399.745n 0.0v 399.755n 0.0v 404.745n 0.0v 404.755n 0.95v 409.745n 0.95v 409.755n 0.95v 414.745n 0.95v 414.755n 0.95v 419.745n 0.95v 419.755n 0.95v 424.745n 0.95v 424.755n 0.95v 429.745n 0.95v 429.755n 0.95v 434.745n 0.95v 434.755n 0.95v 439.745n 0.95v 439.755n 0.95v 444.745n 0.95v 444.755n 0.95v 449.745n 0.95v 449.755n 0.95v 454.745n 0.95v 454.755n 0.95v 459.745n 0.95v 459.755n 0.95v 464.745n 0.95v 464.755n 0.95v 469.745n 0.95v 469.755n 0.0v 474.745n 0.0v 474.755n 0.0v 479.745n 0.0v 479.755n 0.0v 484.745n 0.0v 484.755n 0.95v 489.745n 0.95v 489.755n 0.95v 494.745n 0.95v 494.755n 0.95v 499.745n 0.95v 499.755n 0.95v 504.745n 0.95v 504.755n 0.95v 509.745n 0.95v 509.755n 0.95v 514.745n 0.95v 514.755n 0.95v 519.745n 0.95v 519.755n 0.95v 524.745n 0.95v 524.755n 0.95v 529.745n 0.95v 529.755n 0.95v 534.745n 0.95v 534.755n 0.95v 539.745n 0.95v 539.755n 0.95v 544.745n 0.95v 544.755n 0.95v 549.745n 0.95v 549.755n 0.95v 554.745n 0.95v 554.755n 0.95v 559.745n 0.95v 559.755n 0.95v 564.745n 0.95v 564.755n 0.95v 569.745n 0.95v 569.755n 0.95v 574.745n 0.95v 574.755n 0.95v 579.745n 0.95v 579.755n 0.0v 584.745n 0.0v 584.755n 0.0v 589.745n 0.0v 589.755n 0.0v 594.745n 0.0v 594.755n 0.0v 599.745n 0.0v 599.755n 0.95v 604.745n 0.95v 604.755n 0.95v 609.745n 0.95v 609.755n 0.95v 614.745n 0.95v 614.755n 0.95v 619.745n 0.95v 619.755n 0.0v 624.745n 0.0v 624.755n 0.0v 629.745n 0.0v 629.755n 0.0v 634.745n 0.0v 634.755n 0.0v 639.745n 0.0v 639.755n 0.0v 644.745n 0.0v 644.755n 0.0v 649.745n 0.0v 649.755n 0.0v 654.745n 0.0v 654.755n 0.0v 659.745n 0.0v 659.755n 0.95v 664.745n 0.95v 664.755n 0.95v 669.745n 0.95v 669.755n 0.95v 674.745n 0.95v 674.755n 0.95v 679.745n 0.95v 679.755n 0.95v 684.745n 0.95v 684.755n 0.0v 689.745n 0.0v 689.755n 0.0v 694.745n 0.0v 694.755n 0.0v 699.745n 0.0v 699.755n 0.0v 704.745n 0.0v 704.755n 0.0v 709.745n 0.0v 709.755n 0.95v 714.745n 0.95v 714.755n 0.95v 719.745n 0.95v 719.755n 0.95v 724.745n 0.95v 724.755n 0.95v 729.745n 0.95v 729.755n 0.95v 734.745n 0.95v 734.755n 0.95v 739.745n 0.95v 739.755n 0.0v 744.745n 0.0v 744.755n 0.0v 749.745n 0.0v 749.755n 0.0v 754.745n 0.0v 754.755n 0.0v 759.745n 0.0v 759.755n 0.0v 764.745n 0.0v 764.755n 0.0v 769.745n 0.0v 769.755n 0.0v 774.745n 0.0v 774.755n 0.0v 779.745n 0.0v 779.755n 0.0v 784.745n 0.0v 784.755n 0.0v 789.745n 0.0v 789.755n 0.0v 794.745n 0.0v 794.755n 0.0v 799.745n 0.0v 799.755n 0.0v 804.745n 0.0v 804.755n 0.0v 809.745n 0.0v 809.755n 0.0v 814.745n 0.0v 814.755n 0.0v 819.745n 0.0v 819.755n 0.95v 824.745n 0.95v 824.755n 0.95v 829.745n 0.95v 829.755n 0.95v 834.745n 0.95v 834.755n 0.95v 839.745n 0.95v 839.755n 0.95v 844.745n 0.95v 844.755n 0.95v 849.745n 0.95v 849.755n 0.95v 854.745n 0.95v 854.755n 0.0v 859.745n 0.0v 859.755n 0.0v 864.745n 0.0v 864.755n 0.0v 869.745n 0.0v 869.755n 0.0v 874.745n 0.0v 874.755n 0.0v 879.745n 0.0v 879.755n 0.0v 884.745n 0.0v 884.755n 0.0v 889.745n 0.0v 889.755n 0.95v 894.745n 0.95v 894.755n 0.95v 899.745n 0.95v 899.755n 0.95v 904.745n 0.95v 904.755n 0.95v 909.745n 0.95v 909.755n 0.95v 914.745n 0.95v 914.755n 0.95v 919.745n 0.95v 919.755n 0.95v 924.745n 0.95v 924.755n 0.95v 929.745n 0.95v 929.755n 0.95v 934.745n 0.95v 934.755n 0.95v 939.745n 0.95v 939.755n 0.95v 944.745n 0.95v 944.755n 0.0v 949.745n 0.0v 949.755n 0.95v 954.745n 0.95v 954.755n 0.95v 959.745n 0.95v 959.755n 0.0v 964.745n 0.0v 964.755n 0.0v 969.745n 0.0v 969.755n 0.0v 974.745n 0.0v 974.755n 0.0v 979.745n 0.0v 979.755n 0.0v 984.745n 0.0v 984.755n 0.95v 989.745n 0.95v 989.755n 0.95v 994.745n 0.95v 994.755n 0.95v 999.745n 0.95v 999.755n 0.95v 1004.745n 0.95v 1004.755n 0.0v 1009.745n 0.0v 1009.755n 0.0v 1014.745n 0.0v 1014.755n 0.0v 1019.745n 0.0v 1019.755n 0.0v 1024.745n 0.0v 1024.755n 0.0v )
* (time, data): [(0, 0), (5, 0), (10, 0), (15, 0), (20, 0), (25, 0), (30, 1), (35, 1), (40, 1), (45, 1), (50, 1), (55, 1), (60, 1), (65, 0), (70, 0), (75, 0), (80, 0), (85, 0), (90, 0), (95, 0), (100, 0), (105, 0), (110, 0), (115, 0), (120, 0), (125, 0), (130, 0), (135, 0), (140, 0), (145, 0), (150, 0), (155, 1), (160, 1), (165, 1), (170, 1), (175, 1), (180, 1), (185, 1), (190, 1), (195, 1), (200, 1), (205, 1), (210, 1), (215, 1), (220, 0), (225, 0), (230, 0), (235, 0), (240, 1), (245, 0), (250, 0), (255, 0), (260, 0), (265, 0), (270, 0), (275, 0), (280, 0), (285, 1), (290, 1), (295, 1), (300, 1), (305, 1), (310, 1), (315, 1), (320, 1), (325, 1), (330, 1), (335, 1), (340, 1), (345, 1), (350, 1), (355, 1), (360, 1), (365, 0), (370, 0), (375, 0), (380, 0), (385, 0), (390, 1), (395, 1), (400, 1), (405, 1), (410, 1), (415, 1), (420, 1), (425, 1), (430, 0), (435, 0), (440, 0), (445, 0), (450, 0), (455, 0), (460, 0), (465, 0), (470, 0), (475, 0), (480, 0), (485, 1), (490, 0), (495, 0), (500, 0), (505, 0), (510, 0), (515, 0), (520, 0), (525, 0), (530, 0), (535, 0), (540, 0), (545, 0), (550, 0), (555, 0), (560, 0), (565, 0), (570, 0), (575, 0), (580, 0), (585, 0), (590, 0), (595, 0), (600, 0), (605, 0), (610, 1), (615, 1), (620, 1), (625, 1), (630, 1), (635, 1), (640, 1), (645, 1), (650, 1), (655, 1), (660, 0), (665, 0), (670, 0), (675, 0), (680, 0), (685, 1), (690, 1), (695, 1), (700, 1), (705, 1), (710, 0), (715, 0), (720, 0), (725, 0), (730, 1), (735, 1), (740, 1), (745, 1), (750, 1), (755, 1), (760, 1), (765, 1), (770, 1), (775, 1), (780, 1), (785, 1), (790, 1), (795, 1), (800, 1), (805, 1), (810, 1), (815, 1), (820, 0), (825, 0), (830, 1), (835, 1), (840, 1), (845, 1), (850, 1), (855, 0), (860, 0), (865, 0), (870, 0), (875, 0), (880, 0), (885, 0), (890, 0), (895, 0), (900, 0), (905, 0), (910, 0), (915, 0), (920, 1), (925, 1), (930, 1), (935, 1), (940, 1), (945, 0), (950, 1), (955, 1), (960, 1), (965, 1), (970, 1), (975, 1), (980, 1), (985, 1), (990, 1), (995, 1), (1000, 1), (1005, 0), (1010, 0), (1015, 0), (1020, 0), (1025, 0)]
Vdin0_12  din0_12  0 PWL (0n 0.0v 4.745n 0.0v 4.755n 0.0v 9.745n 0.0v 9.755n 0.0v 14.745n 0.0v 14.755n 0.0v 19.745n 0.0v 19.755n 0.0v 24.745n 0.0v 24.755n 0.0v 29.745n 0.0v 29.755n 0.95v 34.745n 0.95v 34.755n 0.95v 39.745n 0.95v 39.755n 0.95v 44.745n 0.95v 44.755n 0.95v 49.745n 0.95v 49.755n 0.95v 54.745n 0.95v 54.755n 0.95v 59.745n 0.95v 59.755n 0.95v 64.745n 0.95v 64.755n 0.0v 69.745n 0.0v 69.755n 0.0v 74.745n 0.0v 74.755n 0.0v 79.745n 0.0v 79.755n 0.0v 84.745n 0.0v 84.755n 0.0v 89.745n 0.0v 89.755n 0.0v 94.745n 0.0v 94.755n 0.0v 99.745n 0.0v 99.755n 0.0v 104.745n 0.0v 104.755n 0.0v 109.745n 0.0v 109.755n 0.0v 114.745n 0.0v 114.755n 0.0v 119.745n 0.0v 119.755n 0.0v 124.745n 0.0v 124.755n 0.0v 129.745n 0.0v 129.755n 0.0v 134.745n 0.0v 134.755n 0.0v 139.745n 0.0v 139.755n 0.0v 144.745n 0.0v 144.755n 0.0v 149.745n 0.0v 149.755n 0.0v 154.745n 0.0v 154.755n 0.95v 159.745n 0.95v 159.755n 0.95v 164.745n 0.95v 164.755n 0.95v 169.745n 0.95v 169.755n 0.95v 174.745n 0.95v 174.755n 0.95v 179.745n 0.95v 179.755n 0.95v 184.745n 0.95v 184.755n 0.95v 189.745n 0.95v 189.755n 0.95v 194.745n 0.95v 194.755n 0.95v 199.745n 0.95v 199.755n 0.95v 204.745n 0.95v 204.755n 0.95v 209.745n 0.95v 209.755n 0.95v 214.745n 0.95v 214.755n 0.95v 219.745n 0.95v 219.755n 0.0v 224.745n 0.0v 224.755n 0.0v 229.745n 0.0v 229.755n 0.0v 234.745n 0.0v 234.755n 0.0v 239.745n 0.0v 239.755n 0.95v 244.745n 0.95v 244.755n 0.0v 249.745n 0.0v 249.755n 0.0v 254.745n 0.0v 254.755n 0.0v 259.745n 0.0v 259.755n 0.0v 264.745n 0.0v 264.755n 0.0v 269.745n 0.0v 269.755n 0.0v 274.745n 0.0v 274.755n 0.0v 279.745n 0.0v 279.755n 0.0v 284.745n 0.0v 284.755n 0.95v 289.745n 0.95v 289.755n 0.95v 294.745n 0.95v 294.755n 0.95v 299.745n 0.95v 299.755n 0.95v 304.745n 0.95v 304.755n 0.95v 309.745n 0.95v 309.755n 0.95v 314.745n 0.95v 314.755n 0.95v 319.745n 0.95v 319.755n 0.95v 324.745n 0.95v 324.755n 0.95v 329.745n 0.95v 329.755n 0.95v 334.745n 0.95v 334.755n 0.95v 339.745n 0.95v 339.755n 0.95v 344.745n 0.95v 344.755n 0.95v 349.745n 0.95v 349.755n 0.95v 354.745n 0.95v 354.755n 0.95v 359.745n 0.95v 359.755n 0.95v 364.745n 0.95v 364.755n 0.0v 369.745n 0.0v 369.755n 0.0v 374.745n 0.0v 374.755n 0.0v 379.745n 0.0v 379.755n 0.0v 384.745n 0.0v 384.755n 0.0v 389.745n 0.0v 389.755n 0.95v 394.745n 0.95v 394.755n 0.95v 399.745n 0.95v 399.755n 0.95v 404.745n 0.95v 404.755n 0.95v 409.745n 0.95v 409.755n 0.95v 414.745n 0.95v 414.755n 0.95v 419.745n 0.95v 419.755n 0.95v 424.745n 0.95v 424.755n 0.95v 429.745n 0.95v 429.755n 0.0v 434.745n 0.0v 434.755n 0.0v 439.745n 0.0v 439.755n 0.0v 444.745n 0.0v 444.755n 0.0v 449.745n 0.0v 449.755n 0.0v 454.745n 0.0v 454.755n 0.0v 459.745n 0.0v 459.755n 0.0v 464.745n 0.0v 464.755n 0.0v 469.745n 0.0v 469.755n 0.0v 474.745n 0.0v 474.755n 0.0v 479.745n 0.0v 479.755n 0.0v 484.745n 0.0v 484.755n 0.95v 489.745n 0.95v 489.755n 0.0v 494.745n 0.0v 494.755n 0.0v 499.745n 0.0v 499.755n 0.0v 504.745n 0.0v 504.755n 0.0v 509.745n 0.0v 509.755n 0.0v 514.745n 0.0v 514.755n 0.0v 519.745n 0.0v 519.755n 0.0v 524.745n 0.0v 524.755n 0.0v 529.745n 0.0v 529.755n 0.0v 534.745n 0.0v 534.755n 0.0v 539.745n 0.0v 539.755n 0.0v 544.745n 0.0v 544.755n 0.0v 549.745n 0.0v 549.755n 0.0v 554.745n 0.0v 554.755n 0.0v 559.745n 0.0v 559.755n 0.0v 564.745n 0.0v 564.755n 0.0v 569.745n 0.0v 569.755n 0.0v 574.745n 0.0v 574.755n 0.0v 579.745n 0.0v 579.755n 0.0v 584.745n 0.0v 584.755n 0.0v 589.745n 0.0v 589.755n 0.0v 594.745n 0.0v 594.755n 0.0v 599.745n 0.0v 599.755n 0.0v 604.745n 0.0v 604.755n 0.0v 609.745n 0.0v 609.755n 0.95v 614.745n 0.95v 614.755n 0.95v 619.745n 0.95v 619.755n 0.95v 624.745n 0.95v 624.755n 0.95v 629.745n 0.95v 629.755n 0.95v 634.745n 0.95v 634.755n 0.95v 639.745n 0.95v 639.755n 0.95v 644.745n 0.95v 644.755n 0.95v 649.745n 0.95v 649.755n 0.95v 654.745n 0.95v 654.755n 0.95v 659.745n 0.95v 659.755n 0.0v 664.745n 0.0v 664.755n 0.0v 669.745n 0.0v 669.755n 0.0v 674.745n 0.0v 674.755n 0.0v 679.745n 0.0v 679.755n 0.0v 684.745n 0.0v 684.755n 0.95v 689.745n 0.95v 689.755n 0.95v 694.745n 0.95v 694.755n 0.95v 699.745n 0.95v 699.755n 0.95v 704.745n 0.95v 704.755n 0.95v 709.745n 0.95v 709.755n 0.0v 714.745n 0.0v 714.755n 0.0v 719.745n 0.0v 719.755n 0.0v 724.745n 0.0v 724.755n 0.0v 729.745n 0.0v 729.755n 0.95v 734.745n 0.95v 734.755n 0.95v 739.745n 0.95v 739.755n 0.95v 744.745n 0.95v 744.755n 0.95v 749.745n 0.95v 749.755n 0.95v 754.745n 0.95v 754.755n 0.95v 759.745n 0.95v 759.755n 0.95v 764.745n 0.95v 764.755n 0.95v 769.745n 0.95v 769.755n 0.95v 774.745n 0.95v 774.755n 0.95v 779.745n 0.95v 779.755n 0.95v 784.745n 0.95v 784.755n 0.95v 789.745n 0.95v 789.755n 0.95v 794.745n 0.95v 794.755n 0.95v 799.745n 0.95v 799.755n 0.95v 804.745n 0.95v 804.755n 0.95v 809.745n 0.95v 809.755n 0.95v 814.745n 0.95v 814.755n 0.95v 819.745n 0.95v 819.755n 0.0v 824.745n 0.0v 824.755n 0.0v 829.745n 0.0v 829.755n 0.95v 834.745n 0.95v 834.755n 0.95v 839.745n 0.95v 839.755n 0.95v 844.745n 0.95v 844.755n 0.95v 849.745n 0.95v 849.755n 0.95v 854.745n 0.95v 854.755n 0.0v 859.745n 0.0v 859.755n 0.0v 864.745n 0.0v 864.755n 0.0v 869.745n 0.0v 869.755n 0.0v 874.745n 0.0v 874.755n 0.0v 879.745n 0.0v 879.755n 0.0v 884.745n 0.0v 884.755n 0.0v 889.745n 0.0v 889.755n 0.0v 894.745n 0.0v 894.755n 0.0v 899.745n 0.0v 899.755n 0.0v 904.745n 0.0v 904.755n 0.0v 909.745n 0.0v 909.755n 0.0v 914.745n 0.0v 914.755n 0.0v 919.745n 0.0v 919.755n 0.95v 924.745n 0.95v 924.755n 0.95v 929.745n 0.95v 929.755n 0.95v 934.745n 0.95v 934.755n 0.95v 939.745n 0.95v 939.755n 0.95v 944.745n 0.95v 944.755n 0.0v 949.745n 0.0v 949.755n 0.95v 954.745n 0.95v 954.755n 0.95v 959.745n 0.95v 959.755n 0.95v 964.745n 0.95v 964.755n 0.95v 969.745n 0.95v 969.755n 0.95v 974.745n 0.95v 974.755n 0.95v 979.745n 0.95v 979.755n 0.95v 984.745n 0.95v 984.755n 0.95v 989.745n 0.95v 989.755n 0.95v 994.745n 0.95v 994.755n 0.95v 999.745n 0.95v 999.755n 0.95v 1004.745n 0.95v 1004.755n 0.0v 1009.745n 0.0v 1009.755n 0.0v 1014.745n 0.0v 1014.755n 0.0v 1019.745n 0.0v 1019.755n 0.0v 1024.745n 0.0v 1024.755n 0.0v )
* (time, data): [(0, 0), (5, 1), (10, 1), (15, 0), (20, 0), (25, 0), (30, 0), (35, 0), (40, 0), (45, 1), (50, 1), (55, 1), (60, 1), (65, 1), (70, 1), (75, 1), (80, 1), (85, 1), (90, 1), (95, 1), (100, 1), (105, 1), (110, 1), (115, 1), (120, 1), (125, 0), (130, 0), (135, 0), (140, 0), (145, 0), (150, 0), (155, 0), (160, 0), (165, 0), (170, 0), (175, 0), (180, 0), (185, 0), (190, 0), (195, 0), (200, 0), (205, 0), (210, 0), (215, 0), (220, 1), (225, 1), (230, 1), (235, 1), (240, 0), (245, 1), (250, 1), (255, 1), (260, 0), (265, 1), (270, 1), (275, 1), (280, 1), (285, 1), (290, 1), (295, 1), (300, 1), (305, 1), (310, 1), (315, 1), (320, 1), (325, 1), (330, 1), (335, 1), (340, 1), (345, 1), (350, 1), (355, 0), (360, 0), (365, 0), (370, 0), (375, 0), (380, 1), (385, 1), (390, 1), (395, 1), (400, 1), (405, 1), (410, 1), (415, 1), (420, 1), (425, 1), (430, 0), (435, 0), (440, 0), (445, 0), (450, 0), (455, 0), (460, 0), (465, 0), (470, 1), (475, 1), (480, 1), (485, 0), (490, 1), (495, 1), (500, 1), (505, 1), (510, 1), (515, 1), (520, 1), (525, 1), (530, 1), (535, 1), (540, 1), (545, 1), (550, 1), (555, 1), (560, 1), (565, 1), (570, 1), (575, 1), (580, 0), (585, 0), (590, 1), (595, 1), (600, 1), (605, 1), (610, 1), (615, 0), (620, 1), (625, 1), (630, 1), (635, 1), (640, 1), (645, 1), (650, 1), (655, 1), (660, 0), (665, 0), (670, 0), (675, 0), (680, 0), (685, 1), (690, 1), (695, 1), (700, 1), (705, 1), (710, 1), (715, 1), (720, 1), (725, 1), (730, 1), (735, 1), (740, 1), (745, 1), (750, 1), (755, 1), (760, 1), (765, 1), (770, 1), (775, 1), (780, 0), (785, 0), (790, 0), (795, 0), (800, 1), (805, 1), (810, 1), (815, 1), (820, 1), (825, 1), (830, 0), (835, 0), (840, 0), (845, 0), (850, 0), (855, 1), (860, 1), (865, 1), (870, 1), (875, 1), (880, 1), (885, 1), (890, 0), (895, 0), (900, 0), (905, 0), (910, 1), (915, 1), (920, 1), (925, 1), (930, 1), (935, 1), (940, 1), (945, 0), (950, 0), (955, 0), (960, 1), (965, 1), (970, 1), (975, 1), (980, 1), (985, 1), (990, 1), (995, 1), (1000, 1), (1005, 1), (1010, 1), (1015, 1), (1020, 1), (1025, 1)]
Vdin0_13  din0_13  0 PWL (0n 0.0v 4.745n 0.0v 4.755n 0.95v 9.745n 0.95v 9.755n 0.95v 14.745n 0.95v 14.755n 0.0v 19.745n 0.0v 19.755n 0.0v 24.745n 0.0v 24.755n 0.0v 29.745n 0.0v 29.755n 0.0v 34.745n 0.0v 34.755n 0.0v 39.745n 0.0v 39.755n 0.0v 44.745n 0.0v 44.755n 0.95v 49.745n 0.95v 49.755n 0.95v 54.745n 0.95v 54.755n 0.95v 59.745n 0.95v 59.755n 0.95v 64.745n 0.95v 64.755n 0.95v 69.745n 0.95v 69.755n 0.95v 74.745n 0.95v 74.755n 0.95v 79.745n 0.95v 79.755n 0.95v 84.745n 0.95v 84.755n 0.95v 89.745n 0.95v 89.755n 0.95v 94.745n 0.95v 94.755n 0.95v 99.745n 0.95v 99.755n 0.95v 104.745n 0.95v 104.755n 0.95v 109.745n 0.95v 109.755n 0.95v 114.745n 0.95v 114.755n 0.95v 119.745n 0.95v 119.755n 0.95v 124.745n 0.95v 124.755n 0.0v 129.745n 0.0v 129.755n 0.0v 134.745n 0.0v 134.755n 0.0v 139.745n 0.0v 139.755n 0.0v 144.745n 0.0v 144.755n 0.0v 149.745n 0.0v 149.755n 0.0v 154.745n 0.0v 154.755n 0.0v 159.745n 0.0v 159.755n 0.0v 164.745n 0.0v 164.755n 0.0v 169.745n 0.0v 169.755n 0.0v 174.745n 0.0v 174.755n 0.0v 179.745n 0.0v 179.755n 0.0v 184.745n 0.0v 184.755n 0.0v 189.745n 0.0v 189.755n 0.0v 194.745n 0.0v 194.755n 0.0v 199.745n 0.0v 199.755n 0.0v 204.745n 0.0v 204.755n 0.0v 209.745n 0.0v 209.755n 0.0v 214.745n 0.0v 214.755n 0.0v 219.745n 0.0v 219.755n 0.95v 224.745n 0.95v 224.755n 0.95v 229.745n 0.95v 229.755n 0.95v 234.745n 0.95v 234.755n 0.95v 239.745n 0.95v 239.755n 0.0v 244.745n 0.0v 244.755n 0.95v 249.745n 0.95v 249.755n 0.95v 254.745n 0.95v 254.755n 0.95v 259.745n 0.95v 259.755n 0.0v 264.745n 0.0v 264.755n 0.95v 269.745n 0.95v 269.755n 0.95v 274.745n 0.95v 274.755n 0.95v 279.745n 0.95v 279.755n 0.95v 284.745n 0.95v 284.755n 0.95v 289.745n 0.95v 289.755n 0.95v 294.745n 0.95v 294.755n 0.95v 299.745n 0.95v 299.755n 0.95v 304.745n 0.95v 304.755n 0.95v 309.745n 0.95v 309.755n 0.95v 314.745n 0.95v 314.755n 0.95v 319.745n 0.95v 319.755n 0.95v 324.745n 0.95v 324.755n 0.95v 329.745n 0.95v 329.755n 0.95v 334.745n 0.95v 334.755n 0.95v 339.745n 0.95v 339.755n 0.95v 344.745n 0.95v 344.755n 0.95v 349.745n 0.95v 349.755n 0.95v 354.745n 0.95v 354.755n 0.0v 359.745n 0.0v 359.755n 0.0v 364.745n 0.0v 364.755n 0.0v 369.745n 0.0v 369.755n 0.0v 374.745n 0.0v 374.755n 0.0v 379.745n 0.0v 379.755n 0.95v 384.745n 0.95v 384.755n 0.95v 389.745n 0.95v 389.755n 0.95v 394.745n 0.95v 394.755n 0.95v 399.745n 0.95v 399.755n 0.95v 404.745n 0.95v 404.755n 0.95v 409.745n 0.95v 409.755n 0.95v 414.745n 0.95v 414.755n 0.95v 419.745n 0.95v 419.755n 0.95v 424.745n 0.95v 424.755n 0.95v 429.745n 0.95v 429.755n 0.0v 434.745n 0.0v 434.755n 0.0v 439.745n 0.0v 439.755n 0.0v 444.745n 0.0v 444.755n 0.0v 449.745n 0.0v 449.755n 0.0v 454.745n 0.0v 454.755n 0.0v 459.745n 0.0v 459.755n 0.0v 464.745n 0.0v 464.755n 0.0v 469.745n 0.0v 469.755n 0.95v 474.745n 0.95v 474.755n 0.95v 479.745n 0.95v 479.755n 0.95v 484.745n 0.95v 484.755n 0.0v 489.745n 0.0v 489.755n 0.95v 494.745n 0.95v 494.755n 0.95v 499.745n 0.95v 499.755n 0.95v 504.745n 0.95v 504.755n 0.95v 509.745n 0.95v 509.755n 0.95v 514.745n 0.95v 514.755n 0.95v 519.745n 0.95v 519.755n 0.95v 524.745n 0.95v 524.755n 0.95v 529.745n 0.95v 529.755n 0.95v 534.745n 0.95v 534.755n 0.95v 539.745n 0.95v 539.755n 0.95v 544.745n 0.95v 544.755n 0.95v 549.745n 0.95v 549.755n 0.95v 554.745n 0.95v 554.755n 0.95v 559.745n 0.95v 559.755n 0.95v 564.745n 0.95v 564.755n 0.95v 569.745n 0.95v 569.755n 0.95v 574.745n 0.95v 574.755n 0.95v 579.745n 0.95v 579.755n 0.0v 584.745n 0.0v 584.755n 0.0v 589.745n 0.0v 589.755n 0.95v 594.745n 0.95v 594.755n 0.95v 599.745n 0.95v 599.755n 0.95v 604.745n 0.95v 604.755n 0.95v 609.745n 0.95v 609.755n 0.95v 614.745n 0.95v 614.755n 0.0v 619.745n 0.0v 619.755n 0.95v 624.745n 0.95v 624.755n 0.95v 629.745n 0.95v 629.755n 0.95v 634.745n 0.95v 634.755n 0.95v 639.745n 0.95v 639.755n 0.95v 644.745n 0.95v 644.755n 0.95v 649.745n 0.95v 649.755n 0.95v 654.745n 0.95v 654.755n 0.95v 659.745n 0.95v 659.755n 0.0v 664.745n 0.0v 664.755n 0.0v 669.745n 0.0v 669.755n 0.0v 674.745n 0.0v 674.755n 0.0v 679.745n 0.0v 679.755n 0.0v 684.745n 0.0v 684.755n 0.95v 689.745n 0.95v 689.755n 0.95v 694.745n 0.95v 694.755n 0.95v 699.745n 0.95v 699.755n 0.95v 704.745n 0.95v 704.755n 0.95v 709.745n 0.95v 709.755n 0.95v 714.745n 0.95v 714.755n 0.95v 719.745n 0.95v 719.755n 0.95v 724.745n 0.95v 724.755n 0.95v 729.745n 0.95v 729.755n 0.95v 734.745n 0.95v 734.755n 0.95v 739.745n 0.95v 739.755n 0.95v 744.745n 0.95v 744.755n 0.95v 749.745n 0.95v 749.755n 0.95v 754.745n 0.95v 754.755n 0.95v 759.745n 0.95v 759.755n 0.95v 764.745n 0.95v 764.755n 0.95v 769.745n 0.95v 769.755n 0.95v 774.745n 0.95v 774.755n 0.95v 779.745n 0.95v 779.755n 0.0v 784.745n 0.0v 784.755n 0.0v 789.745n 0.0v 789.755n 0.0v 794.745n 0.0v 794.755n 0.0v 799.745n 0.0v 799.755n 0.95v 804.745n 0.95v 804.755n 0.95v 809.745n 0.95v 809.755n 0.95v 814.745n 0.95v 814.755n 0.95v 819.745n 0.95v 819.755n 0.95v 824.745n 0.95v 824.755n 0.95v 829.745n 0.95v 829.755n 0.0v 834.745n 0.0v 834.755n 0.0v 839.745n 0.0v 839.755n 0.0v 844.745n 0.0v 844.755n 0.0v 849.745n 0.0v 849.755n 0.0v 854.745n 0.0v 854.755n 0.95v 859.745n 0.95v 859.755n 0.95v 864.745n 0.95v 864.755n 0.95v 869.745n 0.95v 869.755n 0.95v 874.745n 0.95v 874.755n 0.95v 879.745n 0.95v 879.755n 0.95v 884.745n 0.95v 884.755n 0.95v 889.745n 0.95v 889.755n 0.0v 894.745n 0.0v 894.755n 0.0v 899.745n 0.0v 899.755n 0.0v 904.745n 0.0v 904.755n 0.0v 909.745n 0.0v 909.755n 0.95v 914.745n 0.95v 914.755n 0.95v 919.745n 0.95v 919.755n 0.95v 924.745n 0.95v 924.755n 0.95v 929.745n 0.95v 929.755n 0.95v 934.745n 0.95v 934.755n 0.95v 939.745n 0.95v 939.755n 0.95v 944.745n 0.95v 944.755n 0.0v 949.745n 0.0v 949.755n 0.0v 954.745n 0.0v 954.755n 0.0v 959.745n 0.0v 959.755n 0.95v 964.745n 0.95v 964.755n 0.95v 969.745n 0.95v 969.755n 0.95v 974.745n 0.95v 974.755n 0.95v 979.745n 0.95v 979.755n 0.95v 984.745n 0.95v 984.755n 0.95v 989.745n 0.95v 989.755n 0.95v 994.745n 0.95v 994.755n 0.95v 999.745n 0.95v 999.755n 0.95v 1004.745n 0.95v 1004.755n 0.95v 1009.745n 0.95v 1009.755n 0.95v 1014.745n 0.95v 1014.755n 0.95v 1019.745n 0.95v 1019.755n 0.95v 1024.745n 0.95v 1024.755n 0.95v )
* (time, data): [(0, 0), (5, 0), (10, 1), (15, 0), (20, 0), (25, 0), (30, 1), (35, 1), (40, 1), (45, 0), (50, 0), (55, 0), (60, 0), (65, 0), (70, 0), (75, 0), (80, 0), (85, 0), (90, 0), (95, 0), (100, 0), (105, 0), (110, 0), (115, 0), (120, 0), (125, 0), (130, 0), (135, 0), (140, 0), (145, 0), (150, 0), (155, 0), (160, 0), (165, 0), (170, 0), (175, 0), (180, 0), (185, 1), (190, 1), (195, 1), (200, 1), (205, 1), (210, 1), (215, 1), (220, 0), (225, 0), (230, 0), (235, 0), (240, 0), (245, 0), (250, 0), (255, 0), (260, 1), (265, 0), (270, 0), (275, 0), (280, 0), (285, 0), (290, 0), (295, 0), (300, 0), (305, 0), (310, 0), (315, 0), (320, 0), (325, 0), (330, 0), (335, 0), (340, 0), (345, 0), (350, 0), (355, 1), (360, 1), (365, 1), (370, 1), (375, 1), (380, 0), (385, 0), (390, 0), (395, 0), (400, 0), (405, 0), (410, 0), (415, 0), (420, 0), (425, 0), (430, 0), (435, 0), (440, 0), (445, 0), (450, 0), (455, 0), (460, 0), (465, 0), (470, 1), (475, 1), (480, 1), (485, 0), (490, 0), (495, 0), (500, 0), (505, 0), (510, 0), (515, 0), (520, 0), (525, 0), (530, 0), (535, 0), (540, 0), (545, 0), (550, 0), (555, 0), (560, 0), (565, 0), (570, 0), (575, 0), (580, 1), (585, 1), (590, 0), (595, 0), (600, 0), (605, 0), (610, 1), (615, 0), (620, 1), (625, 1), (630, 1), (635, 1), (640, 1), (645, 1), (650, 1), (655, 1), (660, 1), (665, 1), (670, 1), (675, 0), (680, 0), (685, 1), (690, 1), (695, 1), (700, 1), (705, 1), (710, 0), (715, 0), (720, 0), (725, 0), (730, 1), (735, 1), (740, 0), (745, 0), (750, 0), (755, 0), (760, 0), (765, 0), (770, 0), (775, 0), (780, 1), (785, 1), (790, 1), (795, 1), (800, 0), (805, 0), (810, 0), (815, 0), (820, 0), (825, 0), (830, 0), (835, 0), (840, 0), (845, 0), (850, 0), (855, 1), (860, 1), (865, 1), (870, 1), (875, 1), (880, 1), (885, 1), (890, 0), (895, 0), (900, 0), (905, 0), (910, 0), (915, 0), (920, 1), (925, 1), (930, 1), (935, 1), (940, 1), (945, 0), (950, 1), (955, 1), (960, 0), (965, 0), (970, 0), (975, 0), (980, 0), (985, 0), (990, 0), (995, 0), (1000, 0), (1005, 0), (1010, 0), (1015, 0), (1020, 0), (1025, 0)]
Vdin0_14  din0_14  0 PWL (0n 0.0v 4.745n 0.0v 4.755n 0.0v 9.745n 0.0v 9.755n 0.95v 14.745n 0.95v 14.755n 0.0v 19.745n 0.0v 19.755n 0.0v 24.745n 0.0v 24.755n 0.0v 29.745n 0.0v 29.755n 0.95v 34.745n 0.95v 34.755n 0.95v 39.745n 0.95v 39.755n 0.95v 44.745n 0.95v 44.755n 0.0v 49.745n 0.0v 49.755n 0.0v 54.745n 0.0v 54.755n 0.0v 59.745n 0.0v 59.755n 0.0v 64.745n 0.0v 64.755n 0.0v 69.745n 0.0v 69.755n 0.0v 74.745n 0.0v 74.755n 0.0v 79.745n 0.0v 79.755n 0.0v 84.745n 0.0v 84.755n 0.0v 89.745n 0.0v 89.755n 0.0v 94.745n 0.0v 94.755n 0.0v 99.745n 0.0v 99.755n 0.0v 104.745n 0.0v 104.755n 0.0v 109.745n 0.0v 109.755n 0.0v 114.745n 0.0v 114.755n 0.0v 119.745n 0.0v 119.755n 0.0v 124.745n 0.0v 124.755n 0.0v 129.745n 0.0v 129.755n 0.0v 134.745n 0.0v 134.755n 0.0v 139.745n 0.0v 139.755n 0.0v 144.745n 0.0v 144.755n 0.0v 149.745n 0.0v 149.755n 0.0v 154.745n 0.0v 154.755n 0.0v 159.745n 0.0v 159.755n 0.0v 164.745n 0.0v 164.755n 0.0v 169.745n 0.0v 169.755n 0.0v 174.745n 0.0v 174.755n 0.0v 179.745n 0.0v 179.755n 0.0v 184.745n 0.0v 184.755n 0.95v 189.745n 0.95v 189.755n 0.95v 194.745n 0.95v 194.755n 0.95v 199.745n 0.95v 199.755n 0.95v 204.745n 0.95v 204.755n 0.95v 209.745n 0.95v 209.755n 0.95v 214.745n 0.95v 214.755n 0.95v 219.745n 0.95v 219.755n 0.0v 224.745n 0.0v 224.755n 0.0v 229.745n 0.0v 229.755n 0.0v 234.745n 0.0v 234.755n 0.0v 239.745n 0.0v 239.755n 0.0v 244.745n 0.0v 244.755n 0.0v 249.745n 0.0v 249.755n 0.0v 254.745n 0.0v 254.755n 0.0v 259.745n 0.0v 259.755n 0.95v 264.745n 0.95v 264.755n 0.0v 269.745n 0.0v 269.755n 0.0v 274.745n 0.0v 274.755n 0.0v 279.745n 0.0v 279.755n 0.0v 284.745n 0.0v 284.755n 0.0v 289.745n 0.0v 289.755n 0.0v 294.745n 0.0v 294.755n 0.0v 299.745n 0.0v 299.755n 0.0v 304.745n 0.0v 304.755n 0.0v 309.745n 0.0v 309.755n 0.0v 314.745n 0.0v 314.755n 0.0v 319.745n 0.0v 319.755n 0.0v 324.745n 0.0v 324.755n 0.0v 329.745n 0.0v 329.755n 0.0v 334.745n 0.0v 334.755n 0.0v 339.745n 0.0v 339.755n 0.0v 344.745n 0.0v 344.755n 0.0v 349.745n 0.0v 349.755n 0.0v 354.745n 0.0v 354.755n 0.95v 359.745n 0.95v 359.755n 0.95v 364.745n 0.95v 364.755n 0.95v 369.745n 0.95v 369.755n 0.95v 374.745n 0.95v 374.755n 0.95v 379.745n 0.95v 379.755n 0.0v 384.745n 0.0v 384.755n 0.0v 389.745n 0.0v 389.755n 0.0v 394.745n 0.0v 394.755n 0.0v 399.745n 0.0v 399.755n 0.0v 404.745n 0.0v 404.755n 0.0v 409.745n 0.0v 409.755n 0.0v 414.745n 0.0v 414.755n 0.0v 419.745n 0.0v 419.755n 0.0v 424.745n 0.0v 424.755n 0.0v 429.745n 0.0v 429.755n 0.0v 434.745n 0.0v 434.755n 0.0v 439.745n 0.0v 439.755n 0.0v 444.745n 0.0v 444.755n 0.0v 449.745n 0.0v 449.755n 0.0v 454.745n 0.0v 454.755n 0.0v 459.745n 0.0v 459.755n 0.0v 464.745n 0.0v 464.755n 0.0v 469.745n 0.0v 469.755n 0.95v 474.745n 0.95v 474.755n 0.95v 479.745n 0.95v 479.755n 0.95v 484.745n 0.95v 484.755n 0.0v 489.745n 0.0v 489.755n 0.0v 494.745n 0.0v 494.755n 0.0v 499.745n 0.0v 499.755n 0.0v 504.745n 0.0v 504.755n 0.0v 509.745n 0.0v 509.755n 0.0v 514.745n 0.0v 514.755n 0.0v 519.745n 0.0v 519.755n 0.0v 524.745n 0.0v 524.755n 0.0v 529.745n 0.0v 529.755n 0.0v 534.745n 0.0v 534.755n 0.0v 539.745n 0.0v 539.755n 0.0v 544.745n 0.0v 544.755n 0.0v 549.745n 0.0v 549.755n 0.0v 554.745n 0.0v 554.755n 0.0v 559.745n 0.0v 559.755n 0.0v 564.745n 0.0v 564.755n 0.0v 569.745n 0.0v 569.755n 0.0v 574.745n 0.0v 574.755n 0.0v 579.745n 0.0v 579.755n 0.95v 584.745n 0.95v 584.755n 0.95v 589.745n 0.95v 589.755n 0.0v 594.745n 0.0v 594.755n 0.0v 599.745n 0.0v 599.755n 0.0v 604.745n 0.0v 604.755n 0.0v 609.745n 0.0v 609.755n 0.95v 614.745n 0.95v 614.755n 0.0v 619.745n 0.0v 619.755n 0.95v 624.745n 0.95v 624.755n 0.95v 629.745n 0.95v 629.755n 0.95v 634.745n 0.95v 634.755n 0.95v 639.745n 0.95v 639.755n 0.95v 644.745n 0.95v 644.755n 0.95v 649.745n 0.95v 649.755n 0.95v 654.745n 0.95v 654.755n 0.95v 659.745n 0.95v 659.755n 0.95v 664.745n 0.95v 664.755n 0.95v 669.745n 0.95v 669.755n 0.95v 674.745n 0.95v 674.755n 0.0v 679.745n 0.0v 679.755n 0.0v 684.745n 0.0v 684.755n 0.95v 689.745n 0.95v 689.755n 0.95v 694.745n 0.95v 694.755n 0.95v 699.745n 0.95v 699.755n 0.95v 704.745n 0.95v 704.755n 0.95v 709.745n 0.95v 709.755n 0.0v 714.745n 0.0v 714.755n 0.0v 719.745n 0.0v 719.755n 0.0v 724.745n 0.0v 724.755n 0.0v 729.745n 0.0v 729.755n 0.95v 734.745n 0.95v 734.755n 0.95v 739.745n 0.95v 739.755n 0.0v 744.745n 0.0v 744.755n 0.0v 749.745n 0.0v 749.755n 0.0v 754.745n 0.0v 754.755n 0.0v 759.745n 0.0v 759.755n 0.0v 764.745n 0.0v 764.755n 0.0v 769.745n 0.0v 769.755n 0.0v 774.745n 0.0v 774.755n 0.0v 779.745n 0.0v 779.755n 0.95v 784.745n 0.95v 784.755n 0.95v 789.745n 0.95v 789.755n 0.95v 794.745n 0.95v 794.755n 0.95v 799.745n 0.95v 799.755n 0.0v 804.745n 0.0v 804.755n 0.0v 809.745n 0.0v 809.755n 0.0v 814.745n 0.0v 814.755n 0.0v 819.745n 0.0v 819.755n 0.0v 824.745n 0.0v 824.755n 0.0v 829.745n 0.0v 829.755n 0.0v 834.745n 0.0v 834.755n 0.0v 839.745n 0.0v 839.755n 0.0v 844.745n 0.0v 844.755n 0.0v 849.745n 0.0v 849.755n 0.0v 854.745n 0.0v 854.755n 0.95v 859.745n 0.95v 859.755n 0.95v 864.745n 0.95v 864.755n 0.95v 869.745n 0.95v 869.755n 0.95v 874.745n 0.95v 874.755n 0.95v 879.745n 0.95v 879.755n 0.95v 884.745n 0.95v 884.755n 0.95v 889.745n 0.95v 889.755n 0.0v 894.745n 0.0v 894.755n 0.0v 899.745n 0.0v 899.755n 0.0v 904.745n 0.0v 904.755n 0.0v 909.745n 0.0v 909.755n 0.0v 914.745n 0.0v 914.755n 0.0v 919.745n 0.0v 919.755n 0.95v 924.745n 0.95v 924.755n 0.95v 929.745n 0.95v 929.755n 0.95v 934.745n 0.95v 934.755n 0.95v 939.745n 0.95v 939.755n 0.95v 944.745n 0.95v 944.755n 0.0v 949.745n 0.0v 949.755n 0.95v 954.745n 0.95v 954.755n 0.95v 959.745n 0.95v 959.755n 0.0v 964.745n 0.0v 964.755n 0.0v 969.745n 0.0v 969.755n 0.0v 974.745n 0.0v 974.755n 0.0v 979.745n 0.0v 979.755n 0.0v 984.745n 0.0v 984.755n 0.0v 989.745n 0.0v 989.755n 0.0v 994.745n 0.0v 994.755n 0.0v 999.745n 0.0v 999.755n 0.0v 1004.745n 0.0v 1004.755n 0.0v 1009.745n 0.0v 1009.755n 0.0v 1014.745n 0.0v 1014.755n 0.0v 1019.745n 0.0v 1019.755n 0.0v 1024.745n 0.0v 1024.755n 0.0v )
* (time, data): [(0, 0), (5, 0), (10, 0), (15, 0), (20, 0), (25, 0), (30, 0), (35, 0), (40, 0), (45, 0), (50, 0), (55, 0), (60, 0), (65, 1), (70, 1), (75, 1), (80, 1), (85, 1), (90, 1), (95, 1), (100, 1), (105, 1), (110, 1), (115, 1), (120, 1), (125, 0), (130, 0), (135, 0), (140, 0), (145, 0), (150, 0), (155, 0), (160, 0), (165, 0), (170, 0), (175, 0), (180, 0), (185, 0), (190, 0), (195, 0), (200, 0), (205, 0), (210, 0), (215, 1), (220, 1), (225, 1), (230, 1), (235, 1), (240, 1), (245, 0), (250, 0), (255, 0), (260, 1), (265, 0), (270, 0), (275, 0), (280, 0), (285, 0), (290, 0), (295, 0), (300, 0), (305, 0), (310, 0), (315, 0), (320, 0), (325, 0), (330, 0), (335, 0), (340, 0), (345, 0), (350, 0), (355, 1), (360, 1), (365, 0), (370, 0), (375, 0), (380, 0), (385, 0), (390, 0), (395, 0), (400, 0), (405, 1), (410, 1), (415, 1), (420, 1), (425, 1), (430, 1), (435, 1), (440, 1), (445, 1), (450, 1), (455, 1), (460, 1), (465, 1), (470, 0), (475, 0), (480, 0), (485, 0), (490, 1), (495, 1), (500, 1), (505, 1), (510, 1), (515, 1), (520, 1), (525, 1), (530, 1), (535, 1), (540, 1), (545, 1), (550, 1), (555, 1), (560, 1), (565, 1), (570, 1), (575, 1), (580, 1), (585, 1), (590, 1), (595, 1), (600, 1), (605, 1), (610, 0), (615, 1), (620, 0), (625, 0), (630, 0), (635, 0), (640, 0), (645, 0), (650, 0), (655, 0), (660, 0), (665, 0), (670, 0), (675, 1), (680, 1), (685, 1), (690, 1), (695, 1), (700, 1), (705, 1), (710, 1), (715, 1), (720, 1), (725, 1), (730, 0), (735, 1), (740, 0), (745, 0), (750, 0), (755, 0), (760, 0), (765, 0), (770, 0), (775, 0), (780, 1), (785, 1), (790, 1), (795, 1), (800, 1), (805, 1), (810, 1), (815, 1), (820, 0), (825, 0), (830, 1), (835, 1), (840, 1), (845, 1), (850, 1), (855, 1), (860, 1), (865, 1), (870, 1), (875, 1), (880, 1), (885, 1), (890, 0), (895, 0), (900, 0), (905, 0), (910, 0), (915, 0), (920, 1), (925, 1), (930, 1), (935, 1), (940, 1), (945, 0), (950, 0), (955, 0), (960, 0), (965, 0), (970, 0), (975, 0), (980, 0), (985, 0), (990, 0), (995, 0), (1000, 0), (1005, 0), (1010, 0), (1015, 0), (1020, 0), (1025, 0)]
Vdin0_15  din0_15  0 PWL (0n 0.0v 4.745n 0.0v 4.755n 0.0v 9.745n 0.0v 9.755n 0.0v 14.745n 0.0v 14.755n 0.0v 19.745n 0.0v 19.755n 0.0v 24.745n 0.0v 24.755n 0.0v 29.745n 0.0v 29.755n 0.0v 34.745n 0.0v 34.755n 0.0v 39.745n 0.0v 39.755n 0.0v 44.745n 0.0v 44.755n 0.0v 49.745n 0.0v 49.755n 0.0v 54.745n 0.0v 54.755n 0.0v 59.745n 0.0v 59.755n 0.0v 64.745n 0.0v 64.755n 0.95v 69.745n 0.95v 69.755n 0.95v 74.745n 0.95v 74.755n 0.95v 79.745n 0.95v 79.755n 0.95v 84.745n 0.95v 84.755n 0.95v 89.745n 0.95v 89.755n 0.95v 94.745n 0.95v 94.755n 0.95v 99.745n 0.95v 99.755n 0.95v 104.745n 0.95v 104.755n 0.95v 109.745n 0.95v 109.755n 0.95v 114.745n 0.95v 114.755n 0.95v 119.745n 0.95v 119.755n 0.95v 124.745n 0.95v 124.755n 0.0v 129.745n 0.0v 129.755n 0.0v 134.745n 0.0v 134.755n 0.0v 139.745n 0.0v 139.755n 0.0v 144.745n 0.0v 144.755n 0.0v 149.745n 0.0v 149.755n 0.0v 154.745n 0.0v 154.755n 0.0v 159.745n 0.0v 159.755n 0.0v 164.745n 0.0v 164.755n 0.0v 169.745n 0.0v 169.755n 0.0v 174.745n 0.0v 174.755n 0.0v 179.745n 0.0v 179.755n 0.0v 184.745n 0.0v 184.755n 0.0v 189.745n 0.0v 189.755n 0.0v 194.745n 0.0v 194.755n 0.0v 199.745n 0.0v 199.755n 0.0v 204.745n 0.0v 204.755n 0.0v 209.745n 0.0v 209.755n 0.0v 214.745n 0.0v 214.755n 0.95v 219.745n 0.95v 219.755n 0.95v 224.745n 0.95v 224.755n 0.95v 229.745n 0.95v 229.755n 0.95v 234.745n 0.95v 234.755n 0.95v 239.745n 0.95v 239.755n 0.95v 244.745n 0.95v 244.755n 0.0v 249.745n 0.0v 249.755n 0.0v 254.745n 0.0v 254.755n 0.0v 259.745n 0.0v 259.755n 0.95v 264.745n 0.95v 264.755n 0.0v 269.745n 0.0v 269.755n 0.0v 274.745n 0.0v 274.755n 0.0v 279.745n 0.0v 279.755n 0.0v 284.745n 0.0v 284.755n 0.0v 289.745n 0.0v 289.755n 0.0v 294.745n 0.0v 294.755n 0.0v 299.745n 0.0v 299.755n 0.0v 304.745n 0.0v 304.755n 0.0v 309.745n 0.0v 309.755n 0.0v 314.745n 0.0v 314.755n 0.0v 319.745n 0.0v 319.755n 0.0v 324.745n 0.0v 324.755n 0.0v 329.745n 0.0v 329.755n 0.0v 334.745n 0.0v 334.755n 0.0v 339.745n 0.0v 339.755n 0.0v 344.745n 0.0v 344.755n 0.0v 349.745n 0.0v 349.755n 0.0v 354.745n 0.0v 354.755n 0.95v 359.745n 0.95v 359.755n 0.95v 364.745n 0.95v 364.755n 0.0v 369.745n 0.0v 369.755n 0.0v 374.745n 0.0v 374.755n 0.0v 379.745n 0.0v 379.755n 0.0v 384.745n 0.0v 384.755n 0.0v 389.745n 0.0v 389.755n 0.0v 394.745n 0.0v 394.755n 0.0v 399.745n 0.0v 399.755n 0.0v 404.745n 0.0v 404.755n 0.95v 409.745n 0.95v 409.755n 0.95v 414.745n 0.95v 414.755n 0.95v 419.745n 0.95v 419.755n 0.95v 424.745n 0.95v 424.755n 0.95v 429.745n 0.95v 429.755n 0.95v 434.745n 0.95v 434.755n 0.95v 439.745n 0.95v 439.755n 0.95v 444.745n 0.95v 444.755n 0.95v 449.745n 0.95v 449.755n 0.95v 454.745n 0.95v 454.755n 0.95v 459.745n 0.95v 459.755n 0.95v 464.745n 0.95v 464.755n 0.95v 469.745n 0.95v 469.755n 0.0v 474.745n 0.0v 474.755n 0.0v 479.745n 0.0v 479.755n 0.0v 484.745n 0.0v 484.755n 0.0v 489.745n 0.0v 489.755n 0.95v 494.745n 0.95v 494.755n 0.95v 499.745n 0.95v 499.755n 0.95v 504.745n 0.95v 504.755n 0.95v 509.745n 0.95v 509.755n 0.95v 514.745n 0.95v 514.755n 0.95v 519.745n 0.95v 519.755n 0.95v 524.745n 0.95v 524.755n 0.95v 529.745n 0.95v 529.755n 0.95v 534.745n 0.95v 534.755n 0.95v 539.745n 0.95v 539.755n 0.95v 544.745n 0.95v 544.755n 0.95v 549.745n 0.95v 549.755n 0.95v 554.745n 0.95v 554.755n 0.95v 559.745n 0.95v 559.755n 0.95v 564.745n 0.95v 564.755n 0.95v 569.745n 0.95v 569.755n 0.95v 574.745n 0.95v 574.755n 0.95v 579.745n 0.95v 579.755n 0.95v 584.745n 0.95v 584.755n 0.95v 589.745n 0.95v 589.755n 0.95v 594.745n 0.95v 594.755n 0.95v 599.745n 0.95v 599.755n 0.95v 604.745n 0.95v 604.755n 0.95v 609.745n 0.95v 609.755n 0.0v 614.745n 0.0v 614.755n 0.95v 619.745n 0.95v 619.755n 0.0v 624.745n 0.0v 624.755n 0.0v 629.745n 0.0v 629.755n 0.0v 634.745n 0.0v 634.755n 0.0v 639.745n 0.0v 639.755n 0.0v 644.745n 0.0v 644.755n 0.0v 649.745n 0.0v 649.755n 0.0v 654.745n 0.0v 654.755n 0.0v 659.745n 0.0v 659.755n 0.0v 664.745n 0.0v 664.755n 0.0v 669.745n 0.0v 669.755n 0.0v 674.745n 0.0v 674.755n 0.95v 679.745n 0.95v 679.755n 0.95v 684.745n 0.95v 684.755n 0.95v 689.745n 0.95v 689.755n 0.95v 694.745n 0.95v 694.755n 0.95v 699.745n 0.95v 699.755n 0.95v 704.745n 0.95v 704.755n 0.95v 709.745n 0.95v 709.755n 0.95v 714.745n 0.95v 714.755n 0.95v 719.745n 0.95v 719.755n 0.95v 724.745n 0.95v 724.755n 0.95v 729.745n 0.95v 729.755n 0.0v 734.745n 0.0v 734.755n 0.95v 739.745n 0.95v 739.755n 0.0v 744.745n 0.0v 744.755n 0.0v 749.745n 0.0v 749.755n 0.0v 754.745n 0.0v 754.755n 0.0v 759.745n 0.0v 759.755n 0.0v 764.745n 0.0v 764.755n 0.0v 769.745n 0.0v 769.755n 0.0v 774.745n 0.0v 774.755n 0.0v 779.745n 0.0v 779.755n 0.95v 784.745n 0.95v 784.755n 0.95v 789.745n 0.95v 789.755n 0.95v 794.745n 0.95v 794.755n 0.95v 799.745n 0.95v 799.755n 0.95v 804.745n 0.95v 804.755n 0.95v 809.745n 0.95v 809.755n 0.95v 814.745n 0.95v 814.755n 0.95v 819.745n 0.95v 819.755n 0.0v 824.745n 0.0v 824.755n 0.0v 829.745n 0.0v 829.755n 0.95v 834.745n 0.95v 834.755n 0.95v 839.745n 0.95v 839.755n 0.95v 844.745n 0.95v 844.755n 0.95v 849.745n 0.95v 849.755n 0.95v 854.745n 0.95v 854.755n 0.95v 859.745n 0.95v 859.755n 0.95v 864.745n 0.95v 864.755n 0.95v 869.745n 0.95v 869.755n 0.95v 874.745n 0.95v 874.755n 0.95v 879.745n 0.95v 879.755n 0.95v 884.745n 0.95v 884.755n 0.95v 889.745n 0.95v 889.755n 0.0v 894.745n 0.0v 894.755n 0.0v 899.745n 0.0v 899.755n 0.0v 904.745n 0.0v 904.755n 0.0v 909.745n 0.0v 909.755n 0.0v 914.745n 0.0v 914.755n 0.0v 919.745n 0.0v 919.755n 0.95v 924.745n 0.95v 924.755n 0.95v 929.745n 0.95v 929.755n 0.95v 934.745n 0.95v 934.755n 0.95v 939.745n 0.95v 939.755n 0.95v 944.745n 0.95v 944.755n 0.0v 949.745n 0.0v 949.755n 0.0v 954.745n 0.0v 954.755n 0.0v 959.745n 0.0v 959.755n 0.0v 964.745n 0.0v 964.755n 0.0v 969.745n 0.0v 969.755n 0.0v 974.745n 0.0v 974.755n 0.0v 979.745n 0.0v 979.755n 0.0v 984.745n 0.0v 984.755n 0.0v 989.745n 0.0v 989.755n 0.0v 994.745n 0.0v 994.755n 0.0v 999.745n 0.0v 999.755n 0.0v 1004.745n 0.0v 1004.755n 0.0v 1009.745n 0.0v 1009.755n 0.0v 1014.745n 0.0v 1014.755n 0.0v 1019.745n 0.0v 1019.755n 0.0v 1024.745n 0.0v 1024.755n 0.0v )
* (time, data): [(0, 0), (5, 1), (10, 1), (15, 1), (20, 1), (25, 1), (30, 1), (35, 1), (40, 1), (45, 1), (50, 1), (55, 1), (60, 1), (65, 0), (70, 0), (75, 0), (80, 0), (85, 0), (90, 0), (95, 0), (100, 0), (105, 0), (110, 0), (115, 0), (120, 0), (125, 0), (130, 0), (135, 0), (140, 0), (145, 0), (150, 0), (155, 0), (160, 0), (165, 0), (170, 0), (175, 0), (180, 0), (185, 0), (190, 0), (195, 0), (200, 0), (205, 0), (210, 0), (215, 0), (220, 1), (225, 1), (230, 0), (235, 0), (240, 1), (245, 1), (250, 1), (255, 1), (260, 0), (265, 0), (270, 0), (275, 0), (280, 0), (285, 1), (290, 1), (295, 1), (300, 1), (305, 1), (310, 1), (315, 1), (320, 1), (325, 1), (330, 1), (335, 1), (340, 1), (345, 1), (350, 1), (355, 1), (360, 1), (365, 1), (370, 1), (375, 1), (380, 1), (385, 1), (390, 1), (395, 1), (400, 1), (405, 1), (410, 1), (415, 1), (420, 1), (425, 1), (430, 0), (435, 0), (440, 0), (445, 0), (450, 0), (455, 0), (460, 0), (465, 0), (470, 0), (475, 0), (480, 0), (485, 0), (490, 0), (495, 0), (500, 0), (505, 0), (510, 0), (515, 0), (520, 0), (525, 0), (530, 0), (535, 0), (540, 0), (545, 0), (550, 0), (555, 0), (560, 0), (565, 0), (570, 0), (575, 0), (580, 1), (585, 1), (590, 1), (595, 1), (600, 1), (605, 1), (610, 1), (615, 0), (620, 1), (625, 1), (630, 1), (635, 1), (640, 1), (645, 1), (650, 1), (655, 1), (660, 0), (665, 0), (670, 0), (675, 0), (680, 0), (685, 1), (690, 1), (695, 1), (700, 1), (705, 0), (710, 1), (715, 1), (720, 1), (725, 1), (730, 0), (735, 0), (740, 1), (745, 1), (750, 1), (755, 1), (760, 1), (765, 1), (770, 1), (775, 1), (780, 1), (785, 1), (790, 1), (795, 1), (800, 0), (805, 0), (810, 0), (815, 0), (820, 1), (825, 1), (830, 0), (835, 0), (840, 0), (845, 0), (850, 0), (855, 1), (860, 1), (865, 1), (870, 1), (875, 1), (880, 0), (885, 0), (890, 0), (895, 0), (900, 0), (905, 0), (910, 0), (915, 0), (920, 1), (925, 1), (930, 1), (935, 1), (940, 1), (945, 1), (950, 0), (955, 0), (960, 1), (965, 1), (970, 1), (975, 1), (980, 1), (985, 1), (990, 1), (995, 1), (1000, 1), (1005, 0), (1010, 0), (1015, 0), (1020, 0), (1025, 0)]
Vdin0_16  din0_16  0 PWL (0n 0.0v 4.745n 0.0v 4.755n 0.95v 9.745n 0.95v 9.755n 0.95v 14.745n 0.95v 14.755n 0.95v 19.745n 0.95v 19.755n 0.95v 24.745n 0.95v 24.755n 0.95v 29.745n 0.95v 29.755n 0.95v 34.745n 0.95v 34.755n 0.95v 39.745n 0.95v 39.755n 0.95v 44.745n 0.95v 44.755n 0.95v 49.745n 0.95v 49.755n 0.95v 54.745n 0.95v 54.755n 0.95v 59.745n 0.95v 59.755n 0.95v 64.745n 0.95v 64.755n 0.0v 69.745n 0.0v 69.755n 0.0v 74.745n 0.0v 74.755n 0.0v 79.745n 0.0v 79.755n 0.0v 84.745n 0.0v 84.755n 0.0v 89.745n 0.0v 89.755n 0.0v 94.745n 0.0v 94.755n 0.0v 99.745n 0.0v 99.755n 0.0v 104.745n 0.0v 104.755n 0.0v 109.745n 0.0v 109.755n 0.0v 114.745n 0.0v 114.755n 0.0v 119.745n 0.0v 119.755n 0.0v 124.745n 0.0v 124.755n 0.0v 129.745n 0.0v 129.755n 0.0v 134.745n 0.0v 134.755n 0.0v 139.745n 0.0v 139.755n 0.0v 144.745n 0.0v 144.755n 0.0v 149.745n 0.0v 149.755n 0.0v 154.745n 0.0v 154.755n 0.0v 159.745n 0.0v 159.755n 0.0v 164.745n 0.0v 164.755n 0.0v 169.745n 0.0v 169.755n 0.0v 174.745n 0.0v 174.755n 0.0v 179.745n 0.0v 179.755n 0.0v 184.745n 0.0v 184.755n 0.0v 189.745n 0.0v 189.755n 0.0v 194.745n 0.0v 194.755n 0.0v 199.745n 0.0v 199.755n 0.0v 204.745n 0.0v 204.755n 0.0v 209.745n 0.0v 209.755n 0.0v 214.745n 0.0v 214.755n 0.0v 219.745n 0.0v 219.755n 0.95v 224.745n 0.95v 224.755n 0.95v 229.745n 0.95v 229.755n 0.0v 234.745n 0.0v 234.755n 0.0v 239.745n 0.0v 239.755n 0.95v 244.745n 0.95v 244.755n 0.95v 249.745n 0.95v 249.755n 0.95v 254.745n 0.95v 254.755n 0.95v 259.745n 0.95v 259.755n 0.0v 264.745n 0.0v 264.755n 0.0v 269.745n 0.0v 269.755n 0.0v 274.745n 0.0v 274.755n 0.0v 279.745n 0.0v 279.755n 0.0v 284.745n 0.0v 284.755n 0.95v 289.745n 0.95v 289.755n 0.95v 294.745n 0.95v 294.755n 0.95v 299.745n 0.95v 299.755n 0.95v 304.745n 0.95v 304.755n 0.95v 309.745n 0.95v 309.755n 0.95v 314.745n 0.95v 314.755n 0.95v 319.745n 0.95v 319.755n 0.95v 324.745n 0.95v 324.755n 0.95v 329.745n 0.95v 329.755n 0.95v 334.745n 0.95v 334.755n 0.95v 339.745n 0.95v 339.755n 0.95v 344.745n 0.95v 344.755n 0.95v 349.745n 0.95v 349.755n 0.95v 354.745n 0.95v 354.755n 0.95v 359.745n 0.95v 359.755n 0.95v 364.745n 0.95v 364.755n 0.95v 369.745n 0.95v 369.755n 0.95v 374.745n 0.95v 374.755n 0.95v 379.745n 0.95v 379.755n 0.95v 384.745n 0.95v 384.755n 0.95v 389.745n 0.95v 389.755n 0.95v 394.745n 0.95v 394.755n 0.95v 399.745n 0.95v 399.755n 0.95v 404.745n 0.95v 404.755n 0.95v 409.745n 0.95v 409.755n 0.95v 414.745n 0.95v 414.755n 0.95v 419.745n 0.95v 419.755n 0.95v 424.745n 0.95v 424.755n 0.95v 429.745n 0.95v 429.755n 0.0v 434.745n 0.0v 434.755n 0.0v 439.745n 0.0v 439.755n 0.0v 444.745n 0.0v 444.755n 0.0v 449.745n 0.0v 449.755n 0.0v 454.745n 0.0v 454.755n 0.0v 459.745n 0.0v 459.755n 0.0v 464.745n 0.0v 464.755n 0.0v 469.745n 0.0v 469.755n 0.0v 474.745n 0.0v 474.755n 0.0v 479.745n 0.0v 479.755n 0.0v 484.745n 0.0v 484.755n 0.0v 489.745n 0.0v 489.755n 0.0v 494.745n 0.0v 494.755n 0.0v 499.745n 0.0v 499.755n 0.0v 504.745n 0.0v 504.755n 0.0v 509.745n 0.0v 509.755n 0.0v 514.745n 0.0v 514.755n 0.0v 519.745n 0.0v 519.755n 0.0v 524.745n 0.0v 524.755n 0.0v 529.745n 0.0v 529.755n 0.0v 534.745n 0.0v 534.755n 0.0v 539.745n 0.0v 539.755n 0.0v 544.745n 0.0v 544.755n 0.0v 549.745n 0.0v 549.755n 0.0v 554.745n 0.0v 554.755n 0.0v 559.745n 0.0v 559.755n 0.0v 564.745n 0.0v 564.755n 0.0v 569.745n 0.0v 569.755n 0.0v 574.745n 0.0v 574.755n 0.0v 579.745n 0.0v 579.755n 0.95v 584.745n 0.95v 584.755n 0.95v 589.745n 0.95v 589.755n 0.95v 594.745n 0.95v 594.755n 0.95v 599.745n 0.95v 599.755n 0.95v 604.745n 0.95v 604.755n 0.95v 609.745n 0.95v 609.755n 0.95v 614.745n 0.95v 614.755n 0.0v 619.745n 0.0v 619.755n 0.95v 624.745n 0.95v 624.755n 0.95v 629.745n 0.95v 629.755n 0.95v 634.745n 0.95v 634.755n 0.95v 639.745n 0.95v 639.755n 0.95v 644.745n 0.95v 644.755n 0.95v 649.745n 0.95v 649.755n 0.95v 654.745n 0.95v 654.755n 0.95v 659.745n 0.95v 659.755n 0.0v 664.745n 0.0v 664.755n 0.0v 669.745n 0.0v 669.755n 0.0v 674.745n 0.0v 674.755n 0.0v 679.745n 0.0v 679.755n 0.0v 684.745n 0.0v 684.755n 0.95v 689.745n 0.95v 689.755n 0.95v 694.745n 0.95v 694.755n 0.95v 699.745n 0.95v 699.755n 0.95v 704.745n 0.95v 704.755n 0.0v 709.745n 0.0v 709.755n 0.95v 714.745n 0.95v 714.755n 0.95v 719.745n 0.95v 719.755n 0.95v 724.745n 0.95v 724.755n 0.95v 729.745n 0.95v 729.755n 0.0v 734.745n 0.0v 734.755n 0.0v 739.745n 0.0v 739.755n 0.95v 744.745n 0.95v 744.755n 0.95v 749.745n 0.95v 749.755n 0.95v 754.745n 0.95v 754.755n 0.95v 759.745n 0.95v 759.755n 0.95v 764.745n 0.95v 764.755n 0.95v 769.745n 0.95v 769.755n 0.95v 774.745n 0.95v 774.755n 0.95v 779.745n 0.95v 779.755n 0.95v 784.745n 0.95v 784.755n 0.95v 789.745n 0.95v 789.755n 0.95v 794.745n 0.95v 794.755n 0.95v 799.745n 0.95v 799.755n 0.0v 804.745n 0.0v 804.755n 0.0v 809.745n 0.0v 809.755n 0.0v 814.745n 0.0v 814.755n 0.0v 819.745n 0.0v 819.755n 0.95v 824.745n 0.95v 824.755n 0.95v 829.745n 0.95v 829.755n 0.0v 834.745n 0.0v 834.755n 0.0v 839.745n 0.0v 839.755n 0.0v 844.745n 0.0v 844.755n 0.0v 849.745n 0.0v 849.755n 0.0v 854.745n 0.0v 854.755n 0.95v 859.745n 0.95v 859.755n 0.95v 864.745n 0.95v 864.755n 0.95v 869.745n 0.95v 869.755n 0.95v 874.745n 0.95v 874.755n 0.95v 879.745n 0.95v 879.755n 0.0v 884.745n 0.0v 884.755n 0.0v 889.745n 0.0v 889.755n 0.0v 894.745n 0.0v 894.755n 0.0v 899.745n 0.0v 899.755n 0.0v 904.745n 0.0v 904.755n 0.0v 909.745n 0.0v 909.755n 0.0v 914.745n 0.0v 914.755n 0.0v 919.745n 0.0v 919.755n 0.95v 924.745n 0.95v 924.755n 0.95v 929.745n 0.95v 929.755n 0.95v 934.745n 0.95v 934.755n 0.95v 939.745n 0.95v 939.755n 0.95v 944.745n 0.95v 944.755n 0.95v 949.745n 0.95v 949.755n 0.0v 954.745n 0.0v 954.755n 0.0v 959.745n 0.0v 959.755n 0.95v 964.745n 0.95v 964.755n 0.95v 969.745n 0.95v 969.755n 0.95v 974.745n 0.95v 974.755n 0.95v 979.745n 0.95v 979.755n 0.95v 984.745n 0.95v 984.755n 0.95v 989.745n 0.95v 989.755n 0.95v 994.745n 0.95v 994.755n 0.95v 999.745n 0.95v 999.755n 0.95v 1004.745n 0.95v 1004.755n 0.0v 1009.745n 0.0v 1009.755n 0.0v 1014.745n 0.0v 1014.755n 0.0v 1019.745n 0.0v 1019.755n 0.0v 1024.745n 0.0v 1024.755n 0.0v )
* (time, data): [(0, 0), (5, 1), (10, 1), (15, 1), (20, 1), (25, 1), (30, 1), (35, 1), (40, 1), (45, 0), (50, 0), (55, 0), (60, 0), (65, 1), (70, 1), (75, 1), (80, 1), (85, 1), (90, 1), (95, 1), (100, 1), (105, 1), (110, 1), (115, 1), (120, 1), (125, 1), (130, 1), (135, 1), (140, 1), (145, 1), (150, 1), (155, 0), (160, 0), (165, 0), (170, 0), (175, 0), (180, 0), (185, 0), (190, 0), (195, 0), (200, 0), (205, 0), (210, 0), (215, 0), (220, 1), (225, 1), (230, 0), (235, 0), (240, 0), (245, 0), (250, 0), (255, 0), (260, 0), (265, 0), (270, 0), (275, 0), (280, 0), (285, 0), (290, 0), (295, 0), (300, 0), (305, 0), (310, 0), (315, 0), (320, 0), (325, 0), (330, 0), (335, 0), (340, 0), (345, 0), (350, 0), (355, 1), (360, 1), (365, 1), (370, 1), (375, 1), (380, 1), (385, 1), (390, 0), (395, 0), (400, 0), (405, 0), (410, 0), (415, 0), (420, 0), (425, 0), (430, 1), (435, 1), (440, 1), (445, 1), (450, 1), (455, 1), (460, 1), (465, 1), (470, 1), (475, 1), (480, 1), (485, 1), (490, 0), (495, 0), (500, 0), (505, 0), (510, 0), (515, 0), (520, 0), (525, 0), (530, 0), (535, 0), (540, 0), (545, 0), (550, 0), (555, 0), (560, 0), (565, 0), (570, 0), (575, 0), (580, 0), (585, 0), (590, 0), (595, 0), (600, 1), (605, 1), (610, 0), (615, 0), (620, 0), (625, 0), (630, 0), (635, 0), (640, 0), (645, 0), (650, 0), (655, 0), (660, 1), (665, 1), (670, 1), (675, 0), (680, 0), (685, 0), (690, 0), (695, 0), (700, 0), (705, 1), (710, 0), (715, 0), (720, 0), (725, 0), (730, 1), (735, 1), (740, 0), (745, 0), (750, 0), (755, 0), (760, 0), (765, 0), (770, 0), (775, 0), (780, 1), (785, 1), (790, 1), (795, 1), (800, 1), (805, 1), (810, 1), (815, 1), (820, 1), (825, 1), (830, 0), (835, 0), (840, 0), (845, 0), (850, 0), (855, 0), (860, 0), (865, 0), (870, 0), (875, 0), (880, 1), (885, 1), (890, 1), (895, 1), (900, 1), (905, 1), (910, 1), (915, 1), (920, 1), (925, 1), (930, 1), (935, 1), (940, 1), (945, 1), (950, 0), (955, 0), (960, 1), (965, 1), (970, 1), (975, 1), (980, 1), (985, 0), (990, 0), (995, 0), (1000, 0), (1005, 1), (1010, 1), (1015, 1), (1020, 1), (1025, 1)]
Vdin0_17  din0_17  0 PWL (0n 0.0v 4.745n 0.0v 4.755n 0.95v 9.745n 0.95v 9.755n 0.95v 14.745n 0.95v 14.755n 0.95v 19.745n 0.95v 19.755n 0.95v 24.745n 0.95v 24.755n 0.95v 29.745n 0.95v 29.755n 0.95v 34.745n 0.95v 34.755n 0.95v 39.745n 0.95v 39.755n 0.95v 44.745n 0.95v 44.755n 0.0v 49.745n 0.0v 49.755n 0.0v 54.745n 0.0v 54.755n 0.0v 59.745n 0.0v 59.755n 0.0v 64.745n 0.0v 64.755n 0.95v 69.745n 0.95v 69.755n 0.95v 74.745n 0.95v 74.755n 0.95v 79.745n 0.95v 79.755n 0.95v 84.745n 0.95v 84.755n 0.95v 89.745n 0.95v 89.755n 0.95v 94.745n 0.95v 94.755n 0.95v 99.745n 0.95v 99.755n 0.95v 104.745n 0.95v 104.755n 0.95v 109.745n 0.95v 109.755n 0.95v 114.745n 0.95v 114.755n 0.95v 119.745n 0.95v 119.755n 0.95v 124.745n 0.95v 124.755n 0.95v 129.745n 0.95v 129.755n 0.95v 134.745n 0.95v 134.755n 0.95v 139.745n 0.95v 139.755n 0.95v 144.745n 0.95v 144.755n 0.95v 149.745n 0.95v 149.755n 0.95v 154.745n 0.95v 154.755n 0.0v 159.745n 0.0v 159.755n 0.0v 164.745n 0.0v 164.755n 0.0v 169.745n 0.0v 169.755n 0.0v 174.745n 0.0v 174.755n 0.0v 179.745n 0.0v 179.755n 0.0v 184.745n 0.0v 184.755n 0.0v 189.745n 0.0v 189.755n 0.0v 194.745n 0.0v 194.755n 0.0v 199.745n 0.0v 199.755n 0.0v 204.745n 0.0v 204.755n 0.0v 209.745n 0.0v 209.755n 0.0v 214.745n 0.0v 214.755n 0.0v 219.745n 0.0v 219.755n 0.95v 224.745n 0.95v 224.755n 0.95v 229.745n 0.95v 229.755n 0.0v 234.745n 0.0v 234.755n 0.0v 239.745n 0.0v 239.755n 0.0v 244.745n 0.0v 244.755n 0.0v 249.745n 0.0v 249.755n 0.0v 254.745n 0.0v 254.755n 0.0v 259.745n 0.0v 259.755n 0.0v 264.745n 0.0v 264.755n 0.0v 269.745n 0.0v 269.755n 0.0v 274.745n 0.0v 274.755n 0.0v 279.745n 0.0v 279.755n 0.0v 284.745n 0.0v 284.755n 0.0v 289.745n 0.0v 289.755n 0.0v 294.745n 0.0v 294.755n 0.0v 299.745n 0.0v 299.755n 0.0v 304.745n 0.0v 304.755n 0.0v 309.745n 0.0v 309.755n 0.0v 314.745n 0.0v 314.755n 0.0v 319.745n 0.0v 319.755n 0.0v 324.745n 0.0v 324.755n 0.0v 329.745n 0.0v 329.755n 0.0v 334.745n 0.0v 334.755n 0.0v 339.745n 0.0v 339.755n 0.0v 344.745n 0.0v 344.755n 0.0v 349.745n 0.0v 349.755n 0.0v 354.745n 0.0v 354.755n 0.95v 359.745n 0.95v 359.755n 0.95v 364.745n 0.95v 364.755n 0.95v 369.745n 0.95v 369.755n 0.95v 374.745n 0.95v 374.755n 0.95v 379.745n 0.95v 379.755n 0.95v 384.745n 0.95v 384.755n 0.95v 389.745n 0.95v 389.755n 0.0v 394.745n 0.0v 394.755n 0.0v 399.745n 0.0v 399.755n 0.0v 404.745n 0.0v 404.755n 0.0v 409.745n 0.0v 409.755n 0.0v 414.745n 0.0v 414.755n 0.0v 419.745n 0.0v 419.755n 0.0v 424.745n 0.0v 424.755n 0.0v 429.745n 0.0v 429.755n 0.95v 434.745n 0.95v 434.755n 0.95v 439.745n 0.95v 439.755n 0.95v 444.745n 0.95v 444.755n 0.95v 449.745n 0.95v 449.755n 0.95v 454.745n 0.95v 454.755n 0.95v 459.745n 0.95v 459.755n 0.95v 464.745n 0.95v 464.755n 0.95v 469.745n 0.95v 469.755n 0.95v 474.745n 0.95v 474.755n 0.95v 479.745n 0.95v 479.755n 0.95v 484.745n 0.95v 484.755n 0.95v 489.745n 0.95v 489.755n 0.0v 494.745n 0.0v 494.755n 0.0v 499.745n 0.0v 499.755n 0.0v 504.745n 0.0v 504.755n 0.0v 509.745n 0.0v 509.755n 0.0v 514.745n 0.0v 514.755n 0.0v 519.745n 0.0v 519.755n 0.0v 524.745n 0.0v 524.755n 0.0v 529.745n 0.0v 529.755n 0.0v 534.745n 0.0v 534.755n 0.0v 539.745n 0.0v 539.755n 0.0v 544.745n 0.0v 544.755n 0.0v 549.745n 0.0v 549.755n 0.0v 554.745n 0.0v 554.755n 0.0v 559.745n 0.0v 559.755n 0.0v 564.745n 0.0v 564.755n 0.0v 569.745n 0.0v 569.755n 0.0v 574.745n 0.0v 574.755n 0.0v 579.745n 0.0v 579.755n 0.0v 584.745n 0.0v 584.755n 0.0v 589.745n 0.0v 589.755n 0.0v 594.745n 0.0v 594.755n 0.0v 599.745n 0.0v 599.755n 0.95v 604.745n 0.95v 604.755n 0.95v 609.745n 0.95v 609.755n 0.0v 614.745n 0.0v 614.755n 0.0v 619.745n 0.0v 619.755n 0.0v 624.745n 0.0v 624.755n 0.0v 629.745n 0.0v 629.755n 0.0v 634.745n 0.0v 634.755n 0.0v 639.745n 0.0v 639.755n 0.0v 644.745n 0.0v 644.755n 0.0v 649.745n 0.0v 649.755n 0.0v 654.745n 0.0v 654.755n 0.0v 659.745n 0.0v 659.755n 0.95v 664.745n 0.95v 664.755n 0.95v 669.745n 0.95v 669.755n 0.95v 674.745n 0.95v 674.755n 0.0v 679.745n 0.0v 679.755n 0.0v 684.745n 0.0v 684.755n 0.0v 689.745n 0.0v 689.755n 0.0v 694.745n 0.0v 694.755n 0.0v 699.745n 0.0v 699.755n 0.0v 704.745n 0.0v 704.755n 0.95v 709.745n 0.95v 709.755n 0.0v 714.745n 0.0v 714.755n 0.0v 719.745n 0.0v 719.755n 0.0v 724.745n 0.0v 724.755n 0.0v 729.745n 0.0v 729.755n 0.95v 734.745n 0.95v 734.755n 0.95v 739.745n 0.95v 739.755n 0.0v 744.745n 0.0v 744.755n 0.0v 749.745n 0.0v 749.755n 0.0v 754.745n 0.0v 754.755n 0.0v 759.745n 0.0v 759.755n 0.0v 764.745n 0.0v 764.755n 0.0v 769.745n 0.0v 769.755n 0.0v 774.745n 0.0v 774.755n 0.0v 779.745n 0.0v 779.755n 0.95v 784.745n 0.95v 784.755n 0.95v 789.745n 0.95v 789.755n 0.95v 794.745n 0.95v 794.755n 0.95v 799.745n 0.95v 799.755n 0.95v 804.745n 0.95v 804.755n 0.95v 809.745n 0.95v 809.755n 0.95v 814.745n 0.95v 814.755n 0.95v 819.745n 0.95v 819.755n 0.95v 824.745n 0.95v 824.755n 0.95v 829.745n 0.95v 829.755n 0.0v 834.745n 0.0v 834.755n 0.0v 839.745n 0.0v 839.755n 0.0v 844.745n 0.0v 844.755n 0.0v 849.745n 0.0v 849.755n 0.0v 854.745n 0.0v 854.755n 0.0v 859.745n 0.0v 859.755n 0.0v 864.745n 0.0v 864.755n 0.0v 869.745n 0.0v 869.755n 0.0v 874.745n 0.0v 874.755n 0.0v 879.745n 0.0v 879.755n 0.95v 884.745n 0.95v 884.755n 0.95v 889.745n 0.95v 889.755n 0.95v 894.745n 0.95v 894.755n 0.95v 899.745n 0.95v 899.755n 0.95v 904.745n 0.95v 904.755n 0.95v 909.745n 0.95v 909.755n 0.95v 914.745n 0.95v 914.755n 0.95v 919.745n 0.95v 919.755n 0.95v 924.745n 0.95v 924.755n 0.95v 929.745n 0.95v 929.755n 0.95v 934.745n 0.95v 934.755n 0.95v 939.745n 0.95v 939.755n 0.95v 944.745n 0.95v 944.755n 0.95v 949.745n 0.95v 949.755n 0.0v 954.745n 0.0v 954.755n 0.0v 959.745n 0.0v 959.755n 0.95v 964.745n 0.95v 964.755n 0.95v 969.745n 0.95v 969.755n 0.95v 974.745n 0.95v 974.755n 0.95v 979.745n 0.95v 979.755n 0.95v 984.745n 0.95v 984.755n 0.0v 989.745n 0.0v 989.755n 0.0v 994.745n 0.0v 994.755n 0.0v 999.745n 0.0v 999.755n 0.0v 1004.745n 0.0v 1004.755n 0.95v 1009.745n 0.95v 1009.755n 0.95v 1014.745n 0.95v 1014.755n 0.95v 1019.745n 0.95v 1019.755n 0.95v 1024.745n 0.95v 1024.755n 0.95v )
* (time, data): [(0, 0), (5, 1), (10, 0), (15, 0), (20, 0), (25, 0), (30, 0), (35, 0), (40, 0), (45, 1), (50, 1), (55, 1), (60, 1), (65, 0), (70, 0), (75, 0), (80, 0), (85, 0), (90, 0), (95, 0), (100, 0), (105, 0), (110, 0), (115, 0), (120, 0), (125, 1), (130, 1), (135, 1), (140, 1), (145, 1), (150, 1), (155, 1), (160, 1), (165, 1), (170, 1), (175, 1), (180, 1), (185, 0), (190, 0), (195, 0), (200, 0), (205, 0), (210, 0), (215, 1), (220, 0), (225, 0), (230, 1), (235, 1), (240, 0), (245, 0), (250, 0), (255, 0), (260, 1), (265, 0), (270, 0), (275, 0), (280, 0), (285, 0), (290, 0), (295, 0), (300, 0), (305, 0), (310, 0), (315, 0), (320, 0), (325, 0), (330, 0), (335, 0), (340, 0), (345, 0), (350, 0), (355, 0), (360, 0), (365, 0), (370, 0), (375, 0), (380, 0), (385, 0), (390, 1), (395, 1), (400, 1), (405, 1), (410, 1), (415, 1), (420, 1), (425, 1), (430, 1), (435, 1), (440, 1), (445, 1), (450, 1), (455, 1), (460, 1), (465, 1), (470, 1), (475, 1), (480, 1), (485, 1), (490, 1), (495, 1), (500, 1), (505, 1), (510, 1), (515, 1), (520, 1), (525, 1), (530, 1), (535, 1), (540, 1), (545, 1), (550, 1), (555, 1), (560, 1), (565, 1), (570, 1), (575, 1), (580, 1), (585, 1), (590, 0), (595, 0), (600, 1), (605, 1), (610, 0), (615, 1), (620, 0), (625, 0), (630, 0), (635, 0), (640, 0), (645, 0), (650, 0), (655, 0), (660, 0), (665, 0), (670, 0), (675, 0), (680, 0), (685, 1), (690, 1), (695, 1), (700, 1), (705, 0), (710, 1), (715, 1), (720, 1), (725, 1), (730, 0), (735, 0), (740, 0), (745, 0), (750, 0), (755, 0), (760, 0), (765, 0), (770, 0), (775, 0), (780, 0), (785, 0), (790, 0), (795, 0), (800, 0), (805, 0), (810, 0), (815, 0), (820, 1), (825, 1), (830, 0), (835, 0), (840, 0), (845, 0), (850, 0), (855, 1), (860, 1), (865, 1), (870, 1), (875, 1), (880, 0), (885, 0), (890, 0), (895, 0), (900, 0), (905, 0), (910, 0), (915, 0), (920, 0), (925, 0), (930, 0), (935, 0), (940, 0), (945, 0), (950, 0), (955, 0), (960, 1), (965, 1), (970, 1), (975, 1), (980, 1), (985, 0), (990, 0), (995, 0), (1000, 0), (1005, 1), (1010, 1), (1015, 1), (1020, 1), (1025, 1)]
Vdin0_18  din0_18  0 PWL (0n 0.0v 4.745n 0.0v 4.755n 0.95v 9.745n 0.95v 9.755n 0.0v 14.745n 0.0v 14.755n 0.0v 19.745n 0.0v 19.755n 0.0v 24.745n 0.0v 24.755n 0.0v 29.745n 0.0v 29.755n 0.0v 34.745n 0.0v 34.755n 0.0v 39.745n 0.0v 39.755n 0.0v 44.745n 0.0v 44.755n 0.95v 49.745n 0.95v 49.755n 0.95v 54.745n 0.95v 54.755n 0.95v 59.745n 0.95v 59.755n 0.95v 64.745n 0.95v 64.755n 0.0v 69.745n 0.0v 69.755n 0.0v 74.745n 0.0v 74.755n 0.0v 79.745n 0.0v 79.755n 0.0v 84.745n 0.0v 84.755n 0.0v 89.745n 0.0v 89.755n 0.0v 94.745n 0.0v 94.755n 0.0v 99.745n 0.0v 99.755n 0.0v 104.745n 0.0v 104.755n 0.0v 109.745n 0.0v 109.755n 0.0v 114.745n 0.0v 114.755n 0.0v 119.745n 0.0v 119.755n 0.0v 124.745n 0.0v 124.755n 0.95v 129.745n 0.95v 129.755n 0.95v 134.745n 0.95v 134.755n 0.95v 139.745n 0.95v 139.755n 0.95v 144.745n 0.95v 144.755n 0.95v 149.745n 0.95v 149.755n 0.95v 154.745n 0.95v 154.755n 0.95v 159.745n 0.95v 159.755n 0.95v 164.745n 0.95v 164.755n 0.95v 169.745n 0.95v 169.755n 0.95v 174.745n 0.95v 174.755n 0.95v 179.745n 0.95v 179.755n 0.95v 184.745n 0.95v 184.755n 0.0v 189.745n 0.0v 189.755n 0.0v 194.745n 0.0v 194.755n 0.0v 199.745n 0.0v 199.755n 0.0v 204.745n 0.0v 204.755n 0.0v 209.745n 0.0v 209.755n 0.0v 214.745n 0.0v 214.755n 0.95v 219.745n 0.95v 219.755n 0.0v 224.745n 0.0v 224.755n 0.0v 229.745n 0.0v 229.755n 0.95v 234.745n 0.95v 234.755n 0.95v 239.745n 0.95v 239.755n 0.0v 244.745n 0.0v 244.755n 0.0v 249.745n 0.0v 249.755n 0.0v 254.745n 0.0v 254.755n 0.0v 259.745n 0.0v 259.755n 0.95v 264.745n 0.95v 264.755n 0.0v 269.745n 0.0v 269.755n 0.0v 274.745n 0.0v 274.755n 0.0v 279.745n 0.0v 279.755n 0.0v 284.745n 0.0v 284.755n 0.0v 289.745n 0.0v 289.755n 0.0v 294.745n 0.0v 294.755n 0.0v 299.745n 0.0v 299.755n 0.0v 304.745n 0.0v 304.755n 0.0v 309.745n 0.0v 309.755n 0.0v 314.745n 0.0v 314.755n 0.0v 319.745n 0.0v 319.755n 0.0v 324.745n 0.0v 324.755n 0.0v 329.745n 0.0v 329.755n 0.0v 334.745n 0.0v 334.755n 0.0v 339.745n 0.0v 339.755n 0.0v 344.745n 0.0v 344.755n 0.0v 349.745n 0.0v 349.755n 0.0v 354.745n 0.0v 354.755n 0.0v 359.745n 0.0v 359.755n 0.0v 364.745n 0.0v 364.755n 0.0v 369.745n 0.0v 369.755n 0.0v 374.745n 0.0v 374.755n 0.0v 379.745n 0.0v 379.755n 0.0v 384.745n 0.0v 384.755n 0.0v 389.745n 0.0v 389.755n 0.95v 394.745n 0.95v 394.755n 0.95v 399.745n 0.95v 399.755n 0.95v 404.745n 0.95v 404.755n 0.95v 409.745n 0.95v 409.755n 0.95v 414.745n 0.95v 414.755n 0.95v 419.745n 0.95v 419.755n 0.95v 424.745n 0.95v 424.755n 0.95v 429.745n 0.95v 429.755n 0.95v 434.745n 0.95v 434.755n 0.95v 439.745n 0.95v 439.755n 0.95v 444.745n 0.95v 444.755n 0.95v 449.745n 0.95v 449.755n 0.95v 454.745n 0.95v 454.755n 0.95v 459.745n 0.95v 459.755n 0.95v 464.745n 0.95v 464.755n 0.95v 469.745n 0.95v 469.755n 0.95v 474.745n 0.95v 474.755n 0.95v 479.745n 0.95v 479.755n 0.95v 484.745n 0.95v 484.755n 0.95v 489.745n 0.95v 489.755n 0.95v 494.745n 0.95v 494.755n 0.95v 499.745n 0.95v 499.755n 0.95v 504.745n 0.95v 504.755n 0.95v 509.745n 0.95v 509.755n 0.95v 514.745n 0.95v 514.755n 0.95v 519.745n 0.95v 519.755n 0.95v 524.745n 0.95v 524.755n 0.95v 529.745n 0.95v 529.755n 0.95v 534.745n 0.95v 534.755n 0.95v 539.745n 0.95v 539.755n 0.95v 544.745n 0.95v 544.755n 0.95v 549.745n 0.95v 549.755n 0.95v 554.745n 0.95v 554.755n 0.95v 559.745n 0.95v 559.755n 0.95v 564.745n 0.95v 564.755n 0.95v 569.745n 0.95v 569.755n 0.95v 574.745n 0.95v 574.755n 0.95v 579.745n 0.95v 579.755n 0.95v 584.745n 0.95v 584.755n 0.95v 589.745n 0.95v 589.755n 0.0v 594.745n 0.0v 594.755n 0.0v 599.745n 0.0v 599.755n 0.95v 604.745n 0.95v 604.755n 0.95v 609.745n 0.95v 609.755n 0.0v 614.745n 0.0v 614.755n 0.95v 619.745n 0.95v 619.755n 0.0v 624.745n 0.0v 624.755n 0.0v 629.745n 0.0v 629.755n 0.0v 634.745n 0.0v 634.755n 0.0v 639.745n 0.0v 639.755n 0.0v 644.745n 0.0v 644.755n 0.0v 649.745n 0.0v 649.755n 0.0v 654.745n 0.0v 654.755n 0.0v 659.745n 0.0v 659.755n 0.0v 664.745n 0.0v 664.755n 0.0v 669.745n 0.0v 669.755n 0.0v 674.745n 0.0v 674.755n 0.0v 679.745n 0.0v 679.755n 0.0v 684.745n 0.0v 684.755n 0.95v 689.745n 0.95v 689.755n 0.95v 694.745n 0.95v 694.755n 0.95v 699.745n 0.95v 699.755n 0.95v 704.745n 0.95v 704.755n 0.0v 709.745n 0.0v 709.755n 0.95v 714.745n 0.95v 714.755n 0.95v 719.745n 0.95v 719.755n 0.95v 724.745n 0.95v 724.755n 0.95v 729.745n 0.95v 729.755n 0.0v 734.745n 0.0v 734.755n 0.0v 739.745n 0.0v 739.755n 0.0v 744.745n 0.0v 744.755n 0.0v 749.745n 0.0v 749.755n 0.0v 754.745n 0.0v 754.755n 0.0v 759.745n 0.0v 759.755n 0.0v 764.745n 0.0v 764.755n 0.0v 769.745n 0.0v 769.755n 0.0v 774.745n 0.0v 774.755n 0.0v 779.745n 0.0v 779.755n 0.0v 784.745n 0.0v 784.755n 0.0v 789.745n 0.0v 789.755n 0.0v 794.745n 0.0v 794.755n 0.0v 799.745n 0.0v 799.755n 0.0v 804.745n 0.0v 804.755n 0.0v 809.745n 0.0v 809.755n 0.0v 814.745n 0.0v 814.755n 0.0v 819.745n 0.0v 819.755n 0.95v 824.745n 0.95v 824.755n 0.95v 829.745n 0.95v 829.755n 0.0v 834.745n 0.0v 834.755n 0.0v 839.745n 0.0v 839.755n 0.0v 844.745n 0.0v 844.755n 0.0v 849.745n 0.0v 849.755n 0.0v 854.745n 0.0v 854.755n 0.95v 859.745n 0.95v 859.755n 0.95v 864.745n 0.95v 864.755n 0.95v 869.745n 0.95v 869.755n 0.95v 874.745n 0.95v 874.755n 0.95v 879.745n 0.95v 879.755n 0.0v 884.745n 0.0v 884.755n 0.0v 889.745n 0.0v 889.755n 0.0v 894.745n 0.0v 894.755n 0.0v 899.745n 0.0v 899.755n 0.0v 904.745n 0.0v 904.755n 0.0v 909.745n 0.0v 909.755n 0.0v 914.745n 0.0v 914.755n 0.0v 919.745n 0.0v 919.755n 0.0v 924.745n 0.0v 924.755n 0.0v 929.745n 0.0v 929.755n 0.0v 934.745n 0.0v 934.755n 0.0v 939.745n 0.0v 939.755n 0.0v 944.745n 0.0v 944.755n 0.0v 949.745n 0.0v 949.755n 0.0v 954.745n 0.0v 954.755n 0.0v 959.745n 0.0v 959.755n 0.95v 964.745n 0.95v 964.755n 0.95v 969.745n 0.95v 969.755n 0.95v 974.745n 0.95v 974.755n 0.95v 979.745n 0.95v 979.755n 0.95v 984.745n 0.95v 984.755n 0.0v 989.745n 0.0v 989.755n 0.0v 994.745n 0.0v 994.755n 0.0v 999.745n 0.0v 999.755n 0.0v 1004.745n 0.0v 1004.755n 0.95v 1009.745n 0.95v 1009.755n 0.95v 1014.745n 0.95v 1014.755n 0.95v 1019.745n 0.95v 1019.755n 0.95v 1024.745n 0.95v 1024.755n 0.95v )
* (time, data): [(0, 0), (5, 1), (10, 1), (15, 1), (20, 1), (25, 1), (30, 1), (35, 1), (40, 1), (45, 0), (50, 0), (55, 0), (60, 0), (65, 1), (70, 1), (75, 1), (80, 1), (85, 1), (90, 1), (95, 1), (100, 1), (105, 1), (110, 1), (115, 1), (120, 1), (125, 0), (130, 0), (135, 0), (140, 0), (145, 0), (150, 0), (155, 0), (160, 0), (165, 0), (170, 0), (175, 0), (180, 0), (185, 0), (190, 0), (195, 0), (200, 0), (205, 0), (210, 0), (215, 0), (220, 1), (225, 1), (230, 1), (235, 1), (240, 1), (245, 1), (250, 1), (255, 1), (260, 1), (265, 1), (270, 1), (275, 1), (280, 1), (285, 1), (290, 1), (295, 1), (300, 1), (305, 1), (310, 1), (315, 1), (320, 1), (325, 1), (330, 1), (335, 1), (340, 1), (345, 1), (350, 1), (355, 1), (360, 1), (365, 1), (370, 1), (375, 1), (380, 0), (385, 0), (390, 1), (395, 1), (400, 1), (405, 1), (410, 1), (415, 1), (420, 1), (425, 1), (430, 0), (435, 0), (440, 0), (445, 0), (450, 0), (455, 0), (460, 0), (465, 0), (470, 0), (475, 0), (480, 0), (485, 1), (490, 1), (495, 1), (500, 1), (505, 1), (510, 1), (515, 1), (520, 1), (525, 1), (530, 1), (535, 1), (540, 1), (545, 1), (550, 1), (555, 1), (560, 1), (565, 1), (570, 1), (575, 1), (580, 1), (585, 1), (590, 1), (595, 1), (600, 1), (605, 1), (610, 0), (615, 1), (620, 0), (625, 0), (630, 0), (635, 0), (640, 0), (645, 0), (650, 0), (655, 0), (660, 1), (665, 1), (670, 1), (675, 1), (680, 1), (685, 1), (690, 1), (695, 1), (700, 1), (705, 0), (710, 1), (715, 1), (720, 1), (725, 1), (730, 1), (735, 0), (740, 1), (745, 1), (750, 1), (755, 1), (760, 1), (765, 1), (770, 1), (775, 1), (780, 0), (785, 0), (790, 0), (795, 0), (800, 0), (805, 0), (810, 0), (815, 0), (820, 0), (825, 0), (830, 0), (835, 0), (840, 0), (845, 0), (850, 0), (855, 1), (860, 1), (865, 1), (870, 1), (875, 1), (880, 0), (885, 0), (890, 1), (895, 1), (900, 1), (905, 1), (910, 1), (915, 1), (920, 1), (925, 1), (930, 1), (935, 1), (940, 1), (945, 0), (950, 0), (955, 0), (960, 1), (965, 1), (970, 1), (975, 1), (980, 1), (985, 1), (990, 1), (995, 1), (1000, 1), (1005, 1), (1010, 1), (1015, 1), (1020, 1), (1025, 1)]
Vdin0_19  din0_19  0 PWL (0n 0.0v 4.745n 0.0v 4.755n 0.95v 9.745n 0.95v 9.755n 0.95v 14.745n 0.95v 14.755n 0.95v 19.745n 0.95v 19.755n 0.95v 24.745n 0.95v 24.755n 0.95v 29.745n 0.95v 29.755n 0.95v 34.745n 0.95v 34.755n 0.95v 39.745n 0.95v 39.755n 0.95v 44.745n 0.95v 44.755n 0.0v 49.745n 0.0v 49.755n 0.0v 54.745n 0.0v 54.755n 0.0v 59.745n 0.0v 59.755n 0.0v 64.745n 0.0v 64.755n 0.95v 69.745n 0.95v 69.755n 0.95v 74.745n 0.95v 74.755n 0.95v 79.745n 0.95v 79.755n 0.95v 84.745n 0.95v 84.755n 0.95v 89.745n 0.95v 89.755n 0.95v 94.745n 0.95v 94.755n 0.95v 99.745n 0.95v 99.755n 0.95v 104.745n 0.95v 104.755n 0.95v 109.745n 0.95v 109.755n 0.95v 114.745n 0.95v 114.755n 0.95v 119.745n 0.95v 119.755n 0.95v 124.745n 0.95v 124.755n 0.0v 129.745n 0.0v 129.755n 0.0v 134.745n 0.0v 134.755n 0.0v 139.745n 0.0v 139.755n 0.0v 144.745n 0.0v 144.755n 0.0v 149.745n 0.0v 149.755n 0.0v 154.745n 0.0v 154.755n 0.0v 159.745n 0.0v 159.755n 0.0v 164.745n 0.0v 164.755n 0.0v 169.745n 0.0v 169.755n 0.0v 174.745n 0.0v 174.755n 0.0v 179.745n 0.0v 179.755n 0.0v 184.745n 0.0v 184.755n 0.0v 189.745n 0.0v 189.755n 0.0v 194.745n 0.0v 194.755n 0.0v 199.745n 0.0v 199.755n 0.0v 204.745n 0.0v 204.755n 0.0v 209.745n 0.0v 209.755n 0.0v 214.745n 0.0v 214.755n 0.0v 219.745n 0.0v 219.755n 0.95v 224.745n 0.95v 224.755n 0.95v 229.745n 0.95v 229.755n 0.95v 234.745n 0.95v 234.755n 0.95v 239.745n 0.95v 239.755n 0.95v 244.745n 0.95v 244.755n 0.95v 249.745n 0.95v 249.755n 0.95v 254.745n 0.95v 254.755n 0.95v 259.745n 0.95v 259.755n 0.95v 264.745n 0.95v 264.755n 0.95v 269.745n 0.95v 269.755n 0.95v 274.745n 0.95v 274.755n 0.95v 279.745n 0.95v 279.755n 0.95v 284.745n 0.95v 284.755n 0.95v 289.745n 0.95v 289.755n 0.95v 294.745n 0.95v 294.755n 0.95v 299.745n 0.95v 299.755n 0.95v 304.745n 0.95v 304.755n 0.95v 309.745n 0.95v 309.755n 0.95v 314.745n 0.95v 314.755n 0.95v 319.745n 0.95v 319.755n 0.95v 324.745n 0.95v 324.755n 0.95v 329.745n 0.95v 329.755n 0.95v 334.745n 0.95v 334.755n 0.95v 339.745n 0.95v 339.755n 0.95v 344.745n 0.95v 344.755n 0.95v 349.745n 0.95v 349.755n 0.95v 354.745n 0.95v 354.755n 0.95v 359.745n 0.95v 359.755n 0.95v 364.745n 0.95v 364.755n 0.95v 369.745n 0.95v 369.755n 0.95v 374.745n 0.95v 374.755n 0.95v 379.745n 0.95v 379.755n 0.0v 384.745n 0.0v 384.755n 0.0v 389.745n 0.0v 389.755n 0.95v 394.745n 0.95v 394.755n 0.95v 399.745n 0.95v 399.755n 0.95v 404.745n 0.95v 404.755n 0.95v 409.745n 0.95v 409.755n 0.95v 414.745n 0.95v 414.755n 0.95v 419.745n 0.95v 419.755n 0.95v 424.745n 0.95v 424.755n 0.95v 429.745n 0.95v 429.755n 0.0v 434.745n 0.0v 434.755n 0.0v 439.745n 0.0v 439.755n 0.0v 444.745n 0.0v 444.755n 0.0v 449.745n 0.0v 449.755n 0.0v 454.745n 0.0v 454.755n 0.0v 459.745n 0.0v 459.755n 0.0v 464.745n 0.0v 464.755n 0.0v 469.745n 0.0v 469.755n 0.0v 474.745n 0.0v 474.755n 0.0v 479.745n 0.0v 479.755n 0.0v 484.745n 0.0v 484.755n 0.95v 489.745n 0.95v 489.755n 0.95v 494.745n 0.95v 494.755n 0.95v 499.745n 0.95v 499.755n 0.95v 504.745n 0.95v 504.755n 0.95v 509.745n 0.95v 509.755n 0.95v 514.745n 0.95v 514.755n 0.95v 519.745n 0.95v 519.755n 0.95v 524.745n 0.95v 524.755n 0.95v 529.745n 0.95v 529.755n 0.95v 534.745n 0.95v 534.755n 0.95v 539.745n 0.95v 539.755n 0.95v 544.745n 0.95v 544.755n 0.95v 549.745n 0.95v 549.755n 0.95v 554.745n 0.95v 554.755n 0.95v 559.745n 0.95v 559.755n 0.95v 564.745n 0.95v 564.755n 0.95v 569.745n 0.95v 569.755n 0.95v 574.745n 0.95v 574.755n 0.95v 579.745n 0.95v 579.755n 0.95v 584.745n 0.95v 584.755n 0.95v 589.745n 0.95v 589.755n 0.95v 594.745n 0.95v 594.755n 0.95v 599.745n 0.95v 599.755n 0.95v 604.745n 0.95v 604.755n 0.95v 609.745n 0.95v 609.755n 0.0v 614.745n 0.0v 614.755n 0.95v 619.745n 0.95v 619.755n 0.0v 624.745n 0.0v 624.755n 0.0v 629.745n 0.0v 629.755n 0.0v 634.745n 0.0v 634.755n 0.0v 639.745n 0.0v 639.755n 0.0v 644.745n 0.0v 644.755n 0.0v 649.745n 0.0v 649.755n 0.0v 654.745n 0.0v 654.755n 0.0v 659.745n 0.0v 659.755n 0.95v 664.745n 0.95v 664.755n 0.95v 669.745n 0.95v 669.755n 0.95v 674.745n 0.95v 674.755n 0.95v 679.745n 0.95v 679.755n 0.95v 684.745n 0.95v 684.755n 0.95v 689.745n 0.95v 689.755n 0.95v 694.745n 0.95v 694.755n 0.95v 699.745n 0.95v 699.755n 0.95v 704.745n 0.95v 704.755n 0.0v 709.745n 0.0v 709.755n 0.95v 714.745n 0.95v 714.755n 0.95v 719.745n 0.95v 719.755n 0.95v 724.745n 0.95v 724.755n 0.95v 729.745n 0.95v 729.755n 0.95v 734.745n 0.95v 734.755n 0.0v 739.745n 0.0v 739.755n 0.95v 744.745n 0.95v 744.755n 0.95v 749.745n 0.95v 749.755n 0.95v 754.745n 0.95v 754.755n 0.95v 759.745n 0.95v 759.755n 0.95v 764.745n 0.95v 764.755n 0.95v 769.745n 0.95v 769.755n 0.95v 774.745n 0.95v 774.755n 0.95v 779.745n 0.95v 779.755n 0.0v 784.745n 0.0v 784.755n 0.0v 789.745n 0.0v 789.755n 0.0v 794.745n 0.0v 794.755n 0.0v 799.745n 0.0v 799.755n 0.0v 804.745n 0.0v 804.755n 0.0v 809.745n 0.0v 809.755n 0.0v 814.745n 0.0v 814.755n 0.0v 819.745n 0.0v 819.755n 0.0v 824.745n 0.0v 824.755n 0.0v 829.745n 0.0v 829.755n 0.0v 834.745n 0.0v 834.755n 0.0v 839.745n 0.0v 839.755n 0.0v 844.745n 0.0v 844.755n 0.0v 849.745n 0.0v 849.755n 0.0v 854.745n 0.0v 854.755n 0.95v 859.745n 0.95v 859.755n 0.95v 864.745n 0.95v 864.755n 0.95v 869.745n 0.95v 869.755n 0.95v 874.745n 0.95v 874.755n 0.95v 879.745n 0.95v 879.755n 0.0v 884.745n 0.0v 884.755n 0.0v 889.745n 0.0v 889.755n 0.95v 894.745n 0.95v 894.755n 0.95v 899.745n 0.95v 899.755n 0.95v 904.745n 0.95v 904.755n 0.95v 909.745n 0.95v 909.755n 0.95v 914.745n 0.95v 914.755n 0.95v 919.745n 0.95v 919.755n 0.95v 924.745n 0.95v 924.755n 0.95v 929.745n 0.95v 929.755n 0.95v 934.745n 0.95v 934.755n 0.95v 939.745n 0.95v 939.755n 0.95v 944.745n 0.95v 944.755n 0.0v 949.745n 0.0v 949.755n 0.0v 954.745n 0.0v 954.755n 0.0v 959.745n 0.0v 959.755n 0.95v 964.745n 0.95v 964.755n 0.95v 969.745n 0.95v 969.755n 0.95v 974.745n 0.95v 974.755n 0.95v 979.745n 0.95v 979.755n 0.95v 984.745n 0.95v 984.755n 0.95v 989.745n 0.95v 989.755n 0.95v 994.745n 0.95v 994.755n 0.95v 999.745n 0.95v 999.755n 0.95v 1004.745n 0.95v 1004.755n 0.95v 1009.745n 0.95v 1009.755n 0.95v 1014.745n 0.95v 1014.755n 0.95v 1019.745n 0.95v 1019.755n 0.95v 1024.745n 0.95v 1024.755n 0.95v )
* (time, data): [(0, 0), (5, 1), (10, 1), (15, 1), (20, 1), (25, 1), (30, 0), (35, 0), (40, 0), (45, 1), (50, 1), (55, 1), (60, 1), (65, 0), (70, 0), (75, 0), (80, 0), (85, 0), (90, 0), (95, 0), (100, 0), (105, 0), (110, 0), (115, 0), (120, 0), (125, 0), (130, 0), (135, 0), (140, 0), (145, 0), (150, 0), (155, 0), (160, 0), (165, 0), (170, 0), (175, 0), (180, 0), (185, 0), (190, 0), (195, 0), (200, 0), (205, 0), (210, 0), (215, 0), (220, 0), (225, 0), (230, 0), (235, 0), (240, 0), (245, 1), (250, 1), (255, 1), (260, 0), (265, 1), (270, 1), (275, 1), (280, 1), (285, 1), (290, 1), (295, 1), (300, 1), (305, 1), (310, 1), (315, 1), (320, 1), (325, 1), (330, 1), (335, 1), (340, 1), (345, 1), (350, 1), (355, 1), (360, 1), (365, 0), (370, 0), (375, 0), (380, 1), (385, 1), (390, 0), (395, 0), (400, 0), (405, 1), (410, 1), (415, 1), (420, 1), (425, 1), (430, 1), (435, 1), (440, 1), (445, 1), (450, 1), (455, 1), (460, 1), (465, 1), (470, 0), (475, 0), (480, 0), (485, 1), (490, 0), (495, 0), (500, 0), (505, 0), (510, 0), (515, 0), (520, 0), (525, 0), (530, 0), (535, 0), (540, 0), (545, 0), (550, 0), (555, 0), (560, 0), (565, 0), (570, 0), (575, 0), (580, 1), (585, 1), (590, 1), (595, 1), (600, 0), (605, 0), (610, 1), (615, 1), (620, 1), (625, 1), (630, 1), (635, 1), (640, 1), (645, 1), (650, 1), (655, 1), (660, 1), (665, 1), (670, 1), (675, 1), (680, 1), (685, 0), (690, 0), (695, 0), (700, 0), (705, 0), (710, 0), (715, 0), (720, 0), (725, 0), (730, 1), (735, 1), (740, 0), (745, 0), (750, 0), (755, 0), (760, 0), (765, 0), (770, 0), (775, 0), (780, 0), (785, 0), (790, 0), (795, 0), (800, 0), (805, 0), (810, 0), (815, 0), (820, 0), (825, 0), (830, 1), (835, 1), (840, 1), (845, 1), (850, 1), (855, 0), (860, 0), (865, 0), (870, 0), (875, 0), (880, 0), (885, 0), (890, 1), (895, 1), (900, 1), (905, 1), (910, 0), (915, 0), (920, 0), (925, 0), (930, 0), (935, 0), (940, 0), (945, 0), (950, 1), (955, 1), (960, 1), (965, 1), (970, 1), (975, 1), (980, 1), (985, 1), (990, 1), (995, 1), (1000, 1), (1005, 0), (1010, 0), (1015, 0), (1020, 0), (1025, 0)]
Vdin0_20  din0_20  0 PWL (0n 0.0v 4.745n 0.0v 4.755n 0.95v 9.745n 0.95v 9.755n 0.95v 14.745n 0.95v 14.755n 0.95v 19.745n 0.95v 19.755n 0.95v 24.745n 0.95v 24.755n 0.95v 29.745n 0.95v 29.755n 0.0v 34.745n 0.0v 34.755n 0.0v 39.745n 0.0v 39.755n 0.0v 44.745n 0.0v 44.755n 0.95v 49.745n 0.95v 49.755n 0.95v 54.745n 0.95v 54.755n 0.95v 59.745n 0.95v 59.755n 0.95v 64.745n 0.95v 64.755n 0.0v 69.745n 0.0v 69.755n 0.0v 74.745n 0.0v 74.755n 0.0v 79.745n 0.0v 79.755n 0.0v 84.745n 0.0v 84.755n 0.0v 89.745n 0.0v 89.755n 0.0v 94.745n 0.0v 94.755n 0.0v 99.745n 0.0v 99.755n 0.0v 104.745n 0.0v 104.755n 0.0v 109.745n 0.0v 109.755n 0.0v 114.745n 0.0v 114.755n 0.0v 119.745n 0.0v 119.755n 0.0v 124.745n 0.0v 124.755n 0.0v 129.745n 0.0v 129.755n 0.0v 134.745n 0.0v 134.755n 0.0v 139.745n 0.0v 139.755n 0.0v 144.745n 0.0v 144.755n 0.0v 149.745n 0.0v 149.755n 0.0v 154.745n 0.0v 154.755n 0.0v 159.745n 0.0v 159.755n 0.0v 164.745n 0.0v 164.755n 0.0v 169.745n 0.0v 169.755n 0.0v 174.745n 0.0v 174.755n 0.0v 179.745n 0.0v 179.755n 0.0v 184.745n 0.0v 184.755n 0.0v 189.745n 0.0v 189.755n 0.0v 194.745n 0.0v 194.755n 0.0v 199.745n 0.0v 199.755n 0.0v 204.745n 0.0v 204.755n 0.0v 209.745n 0.0v 209.755n 0.0v 214.745n 0.0v 214.755n 0.0v 219.745n 0.0v 219.755n 0.0v 224.745n 0.0v 224.755n 0.0v 229.745n 0.0v 229.755n 0.0v 234.745n 0.0v 234.755n 0.0v 239.745n 0.0v 239.755n 0.0v 244.745n 0.0v 244.755n 0.95v 249.745n 0.95v 249.755n 0.95v 254.745n 0.95v 254.755n 0.95v 259.745n 0.95v 259.755n 0.0v 264.745n 0.0v 264.755n 0.95v 269.745n 0.95v 269.755n 0.95v 274.745n 0.95v 274.755n 0.95v 279.745n 0.95v 279.755n 0.95v 284.745n 0.95v 284.755n 0.95v 289.745n 0.95v 289.755n 0.95v 294.745n 0.95v 294.755n 0.95v 299.745n 0.95v 299.755n 0.95v 304.745n 0.95v 304.755n 0.95v 309.745n 0.95v 309.755n 0.95v 314.745n 0.95v 314.755n 0.95v 319.745n 0.95v 319.755n 0.95v 324.745n 0.95v 324.755n 0.95v 329.745n 0.95v 329.755n 0.95v 334.745n 0.95v 334.755n 0.95v 339.745n 0.95v 339.755n 0.95v 344.745n 0.95v 344.755n 0.95v 349.745n 0.95v 349.755n 0.95v 354.745n 0.95v 354.755n 0.95v 359.745n 0.95v 359.755n 0.95v 364.745n 0.95v 364.755n 0.0v 369.745n 0.0v 369.755n 0.0v 374.745n 0.0v 374.755n 0.0v 379.745n 0.0v 379.755n 0.95v 384.745n 0.95v 384.755n 0.95v 389.745n 0.95v 389.755n 0.0v 394.745n 0.0v 394.755n 0.0v 399.745n 0.0v 399.755n 0.0v 404.745n 0.0v 404.755n 0.95v 409.745n 0.95v 409.755n 0.95v 414.745n 0.95v 414.755n 0.95v 419.745n 0.95v 419.755n 0.95v 424.745n 0.95v 424.755n 0.95v 429.745n 0.95v 429.755n 0.95v 434.745n 0.95v 434.755n 0.95v 439.745n 0.95v 439.755n 0.95v 444.745n 0.95v 444.755n 0.95v 449.745n 0.95v 449.755n 0.95v 454.745n 0.95v 454.755n 0.95v 459.745n 0.95v 459.755n 0.95v 464.745n 0.95v 464.755n 0.95v 469.745n 0.95v 469.755n 0.0v 474.745n 0.0v 474.755n 0.0v 479.745n 0.0v 479.755n 0.0v 484.745n 0.0v 484.755n 0.95v 489.745n 0.95v 489.755n 0.0v 494.745n 0.0v 494.755n 0.0v 499.745n 0.0v 499.755n 0.0v 504.745n 0.0v 504.755n 0.0v 509.745n 0.0v 509.755n 0.0v 514.745n 0.0v 514.755n 0.0v 519.745n 0.0v 519.755n 0.0v 524.745n 0.0v 524.755n 0.0v 529.745n 0.0v 529.755n 0.0v 534.745n 0.0v 534.755n 0.0v 539.745n 0.0v 539.755n 0.0v 544.745n 0.0v 544.755n 0.0v 549.745n 0.0v 549.755n 0.0v 554.745n 0.0v 554.755n 0.0v 559.745n 0.0v 559.755n 0.0v 564.745n 0.0v 564.755n 0.0v 569.745n 0.0v 569.755n 0.0v 574.745n 0.0v 574.755n 0.0v 579.745n 0.0v 579.755n 0.95v 584.745n 0.95v 584.755n 0.95v 589.745n 0.95v 589.755n 0.95v 594.745n 0.95v 594.755n 0.95v 599.745n 0.95v 599.755n 0.0v 604.745n 0.0v 604.755n 0.0v 609.745n 0.0v 609.755n 0.95v 614.745n 0.95v 614.755n 0.95v 619.745n 0.95v 619.755n 0.95v 624.745n 0.95v 624.755n 0.95v 629.745n 0.95v 629.755n 0.95v 634.745n 0.95v 634.755n 0.95v 639.745n 0.95v 639.755n 0.95v 644.745n 0.95v 644.755n 0.95v 649.745n 0.95v 649.755n 0.95v 654.745n 0.95v 654.755n 0.95v 659.745n 0.95v 659.755n 0.95v 664.745n 0.95v 664.755n 0.95v 669.745n 0.95v 669.755n 0.95v 674.745n 0.95v 674.755n 0.95v 679.745n 0.95v 679.755n 0.95v 684.745n 0.95v 684.755n 0.0v 689.745n 0.0v 689.755n 0.0v 694.745n 0.0v 694.755n 0.0v 699.745n 0.0v 699.755n 0.0v 704.745n 0.0v 704.755n 0.0v 709.745n 0.0v 709.755n 0.0v 714.745n 0.0v 714.755n 0.0v 719.745n 0.0v 719.755n 0.0v 724.745n 0.0v 724.755n 0.0v 729.745n 0.0v 729.755n 0.95v 734.745n 0.95v 734.755n 0.95v 739.745n 0.95v 739.755n 0.0v 744.745n 0.0v 744.755n 0.0v 749.745n 0.0v 749.755n 0.0v 754.745n 0.0v 754.755n 0.0v 759.745n 0.0v 759.755n 0.0v 764.745n 0.0v 764.755n 0.0v 769.745n 0.0v 769.755n 0.0v 774.745n 0.0v 774.755n 0.0v 779.745n 0.0v 779.755n 0.0v 784.745n 0.0v 784.755n 0.0v 789.745n 0.0v 789.755n 0.0v 794.745n 0.0v 794.755n 0.0v 799.745n 0.0v 799.755n 0.0v 804.745n 0.0v 804.755n 0.0v 809.745n 0.0v 809.755n 0.0v 814.745n 0.0v 814.755n 0.0v 819.745n 0.0v 819.755n 0.0v 824.745n 0.0v 824.755n 0.0v 829.745n 0.0v 829.755n 0.95v 834.745n 0.95v 834.755n 0.95v 839.745n 0.95v 839.755n 0.95v 844.745n 0.95v 844.755n 0.95v 849.745n 0.95v 849.755n 0.95v 854.745n 0.95v 854.755n 0.0v 859.745n 0.0v 859.755n 0.0v 864.745n 0.0v 864.755n 0.0v 869.745n 0.0v 869.755n 0.0v 874.745n 0.0v 874.755n 0.0v 879.745n 0.0v 879.755n 0.0v 884.745n 0.0v 884.755n 0.0v 889.745n 0.0v 889.755n 0.95v 894.745n 0.95v 894.755n 0.95v 899.745n 0.95v 899.755n 0.95v 904.745n 0.95v 904.755n 0.95v 909.745n 0.95v 909.755n 0.0v 914.745n 0.0v 914.755n 0.0v 919.745n 0.0v 919.755n 0.0v 924.745n 0.0v 924.755n 0.0v 929.745n 0.0v 929.755n 0.0v 934.745n 0.0v 934.755n 0.0v 939.745n 0.0v 939.755n 0.0v 944.745n 0.0v 944.755n 0.0v 949.745n 0.0v 949.755n 0.95v 954.745n 0.95v 954.755n 0.95v 959.745n 0.95v 959.755n 0.95v 964.745n 0.95v 964.755n 0.95v 969.745n 0.95v 969.755n 0.95v 974.745n 0.95v 974.755n 0.95v 979.745n 0.95v 979.755n 0.95v 984.745n 0.95v 984.755n 0.95v 989.745n 0.95v 989.755n 0.95v 994.745n 0.95v 994.755n 0.95v 999.745n 0.95v 999.755n 0.95v 1004.745n 0.95v 1004.755n 0.0v 1009.745n 0.0v 1009.755n 0.0v 1014.745n 0.0v 1014.755n 0.0v 1019.745n 0.0v 1019.755n 0.0v 1024.745n 0.0v 1024.755n 0.0v )
* (time, data): [(0, 0), (5, 0), (10, 1), (15, 1), (20, 1), (25, 1), (30, 0), (35, 0), (40, 0), (45, 0), (50, 1), (55, 0), (60, 0), (65, 0), (70, 1), (75, 1), (80, 0), (85, 0), (90, 0), (95, 0), (100, 0), (105, 0), (110, 0), (115, 0), (120, 0), (125, 1), (130, 0), (135, 0), (140, 0), (145, 1), (150, 1), (155, 0), (160, 0), (165, 1), (170, 1), (175, 1), (180, 1), (185, 0), (190, 0), (195, 0), (200, 1), (205, 0), (210, 1), (215, 1), (220, 0), (225, 0), (230, 0), (235, 1), (240, 1), (245, 0), (250, 1), (255, 1), (260, 0), (265, 0), (270, 0), (275, 0), (280, 0), (285, 1), (290, 0), (295, 0), (300, 1), (305, 0), (310, 0), (315, 1), (320, 1), (325, 1), (330, 1), (335, 1), (340, 1), (345, 1), (350, 1), (355, 1), (360, 1), (365, 1), (370, 1), (375, 1), (380, 0), (385, 0), (390, 1), (395, 1), (400, 0), (405, 1), (410, 1), (415, 1), (420, 0), (425, 1), (430, 0), (435, 1), (440, 1), (445, 1), (450, 1), (455, 1), (460, 0), (465, 0), (470, 1), (475, 1), (480, 0), (485, 1), (490, 1), (495, 0), (500, 1), (505, 1), (510, 1), (515, 1), (520, 1), (525, 1), (530, 0), (535, 0), (540, 0), (545, 0), (550, 0), (555, 0), (560, 0), (565, 1), (570, 1), (575, 1), (580, 1), (585, 0), (590, 0), (595, 0), (600, 1), (605, 1), (610, 1), (615, 1), (620, 1), (625, 1), (630, 0), (635, 0), (640, 0), (645, 1), (650, 1), (655, 0), (660, 1), (665, 1), (670, 1), (675, 0), (680, 1), (685, 1), (690, 1), (695, 1), (700, 1), (705, 0), (710, 0), (715, 0), (720, 0), (725, 1), (730, 1), (735, 0), (740, 0), (745, 1), (750, 0), (755, 0), (760, 0), (765, 0), (770, 1), (775, 1), (780, 1), (785, 1), (790, 1), (795, 0), (800, 1), (805, 1), (810, 1), (815, 0), (820, 1), (825, 1), (830, 1), (835, 1), (840, 1), (845, 0), (850, 0), (855, 1), (860, 0), (865, 0), (870, 1), (875, 1), (880, 0), (885, 0), (890, 1), (895, 0), (900, 0), (905, 1), (910, 0), (915, 1), (920, 0), (925, 1), (930, 1), (935, 1), (940, 0), (945, 1), (950, 0), (955, 1), (960, 0), (965, 0), (970, 0), (975, 1), (980, 1), (985, 1), (990, 1), (995, 1), (1000, 0), (1005, 0), (1010, 0), (1015, 0), (1020, 0), (1025, 0)]
Va0_0  a0_0  0 PWL (0n 0.0v 4.745n 0.0v 4.755n 0.0v 9.745n 0.0v 9.755n 0.95v 14.745n 0.95v 14.755n 0.95v 19.745n 0.95v 19.755n 0.95v 24.745n 0.95v 24.755n 0.95v 29.745n 0.95v 29.755n 0.0v 34.745n 0.0v 34.755n 0.0v 39.745n 0.0v 39.755n 0.0v 44.745n 0.0v 44.755n 0.0v 49.745n 0.0v 49.755n 0.95v 54.745n 0.95v 54.755n 0.0v 59.745n 0.0v 59.755n 0.0v 64.745n 0.0v 64.755n 0.0v 69.745n 0.0v 69.755n 0.95v 74.745n 0.95v 74.755n 0.95v 79.745n 0.95v 79.755n 0.0v 84.745n 0.0v 84.755n 0.0v 89.745n 0.0v 89.755n 0.0v 94.745n 0.0v 94.755n 0.0v 99.745n 0.0v 99.755n 0.0v 104.745n 0.0v 104.755n 0.0v 109.745n 0.0v 109.755n 0.0v 114.745n 0.0v 114.755n 0.0v 119.745n 0.0v 119.755n 0.0v 124.745n 0.0v 124.755n 0.95v 129.745n 0.95v 129.755n 0.0v 134.745n 0.0v 134.755n 0.0v 139.745n 0.0v 139.755n 0.0v 144.745n 0.0v 144.755n 0.95v 149.745n 0.95v 149.755n 0.95v 154.745n 0.95v 154.755n 0.0v 159.745n 0.0v 159.755n 0.0v 164.745n 0.0v 164.755n 0.95v 169.745n 0.95v 169.755n 0.95v 174.745n 0.95v 174.755n 0.95v 179.745n 0.95v 179.755n 0.95v 184.745n 0.95v 184.755n 0.0v 189.745n 0.0v 189.755n 0.0v 194.745n 0.0v 194.755n 0.0v 199.745n 0.0v 199.755n 0.95v 204.745n 0.95v 204.755n 0.0v 209.745n 0.0v 209.755n 0.95v 214.745n 0.95v 214.755n 0.95v 219.745n 0.95v 219.755n 0.0v 224.745n 0.0v 224.755n 0.0v 229.745n 0.0v 229.755n 0.0v 234.745n 0.0v 234.755n 0.95v 239.745n 0.95v 239.755n 0.95v 244.745n 0.95v 244.755n 0.0v 249.745n 0.0v 249.755n 0.95v 254.745n 0.95v 254.755n 0.95v 259.745n 0.95v 259.755n 0.0v 264.745n 0.0v 264.755n 0.0v 269.745n 0.0v 269.755n 0.0v 274.745n 0.0v 274.755n 0.0v 279.745n 0.0v 279.755n 0.0v 284.745n 0.0v 284.755n 0.95v 289.745n 0.95v 289.755n 0.0v 294.745n 0.0v 294.755n 0.0v 299.745n 0.0v 299.755n 0.95v 304.745n 0.95v 304.755n 0.0v 309.745n 0.0v 309.755n 0.0v 314.745n 0.0v 314.755n 0.95v 319.745n 0.95v 319.755n 0.95v 324.745n 0.95v 324.755n 0.95v 329.745n 0.95v 329.755n 0.95v 334.745n 0.95v 334.755n 0.95v 339.745n 0.95v 339.755n 0.95v 344.745n 0.95v 344.755n 0.95v 349.745n 0.95v 349.755n 0.95v 354.745n 0.95v 354.755n 0.95v 359.745n 0.95v 359.755n 0.95v 364.745n 0.95v 364.755n 0.95v 369.745n 0.95v 369.755n 0.95v 374.745n 0.95v 374.755n 0.95v 379.745n 0.95v 379.755n 0.0v 384.745n 0.0v 384.755n 0.0v 389.745n 0.0v 389.755n 0.95v 394.745n 0.95v 394.755n 0.95v 399.745n 0.95v 399.755n 0.0v 404.745n 0.0v 404.755n 0.95v 409.745n 0.95v 409.755n 0.95v 414.745n 0.95v 414.755n 0.95v 419.745n 0.95v 419.755n 0.0v 424.745n 0.0v 424.755n 0.95v 429.745n 0.95v 429.755n 0.0v 434.745n 0.0v 434.755n 0.95v 439.745n 0.95v 439.755n 0.95v 444.745n 0.95v 444.755n 0.95v 449.745n 0.95v 449.755n 0.95v 454.745n 0.95v 454.755n 0.95v 459.745n 0.95v 459.755n 0.0v 464.745n 0.0v 464.755n 0.0v 469.745n 0.0v 469.755n 0.95v 474.745n 0.95v 474.755n 0.95v 479.745n 0.95v 479.755n 0.0v 484.745n 0.0v 484.755n 0.95v 489.745n 0.95v 489.755n 0.95v 494.745n 0.95v 494.755n 0.0v 499.745n 0.0v 499.755n 0.95v 504.745n 0.95v 504.755n 0.95v 509.745n 0.95v 509.755n 0.95v 514.745n 0.95v 514.755n 0.95v 519.745n 0.95v 519.755n 0.95v 524.745n 0.95v 524.755n 0.95v 529.745n 0.95v 529.755n 0.0v 534.745n 0.0v 534.755n 0.0v 539.745n 0.0v 539.755n 0.0v 544.745n 0.0v 544.755n 0.0v 549.745n 0.0v 549.755n 0.0v 554.745n 0.0v 554.755n 0.0v 559.745n 0.0v 559.755n 0.0v 564.745n 0.0v 564.755n 0.95v 569.745n 0.95v 569.755n 0.95v 574.745n 0.95v 574.755n 0.95v 579.745n 0.95v 579.755n 0.95v 584.745n 0.95v 584.755n 0.0v 589.745n 0.0v 589.755n 0.0v 594.745n 0.0v 594.755n 0.0v 599.745n 0.0v 599.755n 0.95v 604.745n 0.95v 604.755n 0.95v 609.745n 0.95v 609.755n 0.95v 614.745n 0.95v 614.755n 0.95v 619.745n 0.95v 619.755n 0.95v 624.745n 0.95v 624.755n 0.95v 629.745n 0.95v 629.755n 0.0v 634.745n 0.0v 634.755n 0.0v 639.745n 0.0v 639.755n 0.0v 644.745n 0.0v 644.755n 0.95v 649.745n 0.95v 649.755n 0.95v 654.745n 0.95v 654.755n 0.0v 659.745n 0.0v 659.755n 0.95v 664.745n 0.95v 664.755n 0.95v 669.745n 0.95v 669.755n 0.95v 674.745n 0.95v 674.755n 0.0v 679.745n 0.0v 679.755n 0.95v 684.745n 0.95v 684.755n 0.95v 689.745n 0.95v 689.755n 0.95v 694.745n 0.95v 694.755n 0.95v 699.745n 0.95v 699.755n 0.95v 704.745n 0.95v 704.755n 0.0v 709.745n 0.0v 709.755n 0.0v 714.745n 0.0v 714.755n 0.0v 719.745n 0.0v 719.755n 0.0v 724.745n 0.0v 724.755n 0.95v 729.745n 0.95v 729.755n 0.95v 734.745n 0.95v 734.755n 0.0v 739.745n 0.0v 739.755n 0.0v 744.745n 0.0v 744.755n 0.95v 749.745n 0.95v 749.755n 0.0v 754.745n 0.0v 754.755n 0.0v 759.745n 0.0v 759.755n 0.0v 764.745n 0.0v 764.755n 0.0v 769.745n 0.0v 769.755n 0.95v 774.745n 0.95v 774.755n 0.95v 779.745n 0.95v 779.755n 0.95v 784.745n 0.95v 784.755n 0.95v 789.745n 0.95v 789.755n 0.95v 794.745n 0.95v 794.755n 0.0v 799.745n 0.0v 799.755n 0.95v 804.745n 0.95v 804.755n 0.95v 809.745n 0.95v 809.755n 0.95v 814.745n 0.95v 814.755n 0.0v 819.745n 0.0v 819.755n 0.95v 824.745n 0.95v 824.755n 0.95v 829.745n 0.95v 829.755n 0.95v 834.745n 0.95v 834.755n 0.95v 839.745n 0.95v 839.755n 0.95v 844.745n 0.95v 844.755n 0.0v 849.745n 0.0v 849.755n 0.0v 854.745n 0.0v 854.755n 0.95v 859.745n 0.95v 859.755n 0.0v 864.745n 0.0v 864.755n 0.0v 869.745n 0.0v 869.755n 0.95v 874.745n 0.95v 874.755n 0.95v 879.745n 0.95v 879.755n 0.0v 884.745n 0.0v 884.755n 0.0v 889.745n 0.0v 889.755n 0.95v 894.745n 0.95v 894.755n 0.0v 899.745n 0.0v 899.755n 0.0v 904.745n 0.0v 904.755n 0.95v 909.745n 0.95v 909.755n 0.0v 914.745n 0.0v 914.755n 0.95v 919.745n 0.95v 919.755n 0.0v 924.745n 0.0v 924.755n 0.95v 929.745n 0.95v 929.755n 0.95v 934.745n 0.95v 934.755n 0.95v 939.745n 0.95v 939.755n 0.0v 944.745n 0.0v 944.755n 0.95v 949.745n 0.95v 949.755n 0.0v 954.745n 0.0v 954.755n 0.95v 959.745n 0.95v 959.755n 0.0v 964.745n 0.0v 964.755n 0.0v 969.745n 0.0v 969.755n 0.0v 974.745n 0.0v 974.755n 0.95v 979.745n 0.95v 979.755n 0.95v 984.745n 0.95v 984.755n 0.95v 989.745n 0.95v 989.755n 0.95v 994.745n 0.95v 994.755n 0.95v 999.745n 0.95v 999.755n 0.0v 1004.745n 0.0v 1004.755n 0.0v 1009.745n 0.0v 1009.755n 0.0v 1014.745n 0.0v 1014.755n 0.0v 1019.745n 0.0v 1019.755n 0.0v 1024.745n 0.0v 1024.755n 0.0v )
* (time, data): [(0, 0), (5, 0), (10, 0), (15, 0), (20, 0), (25, 0), (30, 0), (35, 0), (40, 0), (45, 0), (50, 0), (55, 0), (60, 0), (65, 0), (70, 0), (75, 0), (80, 0), (85, 0), (90, 0), (95, 0), (100, 0), (105, 0), (110, 0), (115, 0), (120, 0), (125, 0), (130, 0), (135, 0), (140, 0), (145, 0), (150, 0), (155, 1), (160, 1), (165, 0), (170, 0), (175, 0), (180, 0), (185, 0), (190, 0), (195, 0), (200, 0), (205, 0), (210, 0), (215, 0), (220, 1), (225, 1), (230, 0), (235, 0), (240, 0), (245, 1), (250, 0), (255, 0), (260, 0), (265, 0), (270, 0), (275, 0), (280, 0), (285, 0), (290, 0), (295, 0), (300, 0), (305, 0), (310, 0), (315, 0), (320, 0), (325, 0), (330, 0), (335, 0), (340, 0), (345, 0), (350, 0), (355, 0), (360, 0), (365, 0), (370, 0), (375, 0), (380, 0), (385, 1), (390, 0), (395, 0), (400, 1), (405, 0), (410, 0), (415, 0), (420, 0), (425, 0), (430, 0), (435, 0), (440, 0), (445, 0), (450, 0), (455, 0), (460, 0), (465, 0), (470, 0), (475, 0), (480, 1), (485, 0), (490, 0), (495, 0), (500, 0), (505, 0), (510, 0), (515, 0), (520, 0), (525, 0), (530, 0), (535, 0), (540, 1), (545, 0), (550, 0), (555, 1), (560, 1), (565, 0), (570, 0), (575, 0), (580, 0), (585, 1), (590, 0), (595, 0), (600, 0), (605, 0), (610, 0), (615, 0), (620, 0), (625, 0), (630, 1), (635, 0), (640, 1), (645, 0), (650, 0), (655, 1), (660, 0), (665, 0), (670, 0), (675, 1), (680, 0), (685, 0), (690, 0), (695, 0), (700, 0), (705, 1), (710, 1), (715, 0), (720, 0), (725, 0), (730, 0), (735, 0), (740, 0), (745, 0), (750, 0), (755, 0), (760, 1), (765, 1), (770, 0), (775, 0), (780, 0), (785, 0), (790, 0), (795, 0), (800, 0), (805, 0), (810, 0), (815, 1), (820, 0), (825, 0), (830, 0), (835, 0), (840, 0), (845, 1), (850, 1), (855, 0), (860, 0), (865, 0), (870, 0), (875, 0), (880, 1), (885, 1), (890, 0), (895, 0), (900, 1), (905, 0), (910, 0), (915, 0), (920, 0), (925, 0), (930, 0), (935, 0), (940, 1), (945, 0), (950, 0), (955, 0), (960, 0), (965, 0), (970, 0), (975, 0), (980, 0), (985, 0), (990, 0), (995, 0), (1000, 1), (1005, 0), (1010, 0), (1015, 0), (1020, 1), (1025, 1)]
Va0_1  a0_1  0 PWL (0n 0.0v 4.745n 0.0v 4.755n 0.0v 9.745n 0.0v 9.755n 0.0v 14.745n 0.0v 14.755n 0.0v 19.745n 0.0v 19.755n 0.0v 24.745n 0.0v 24.755n 0.0v 29.745n 0.0v 29.755n 0.0v 34.745n 0.0v 34.755n 0.0v 39.745n 0.0v 39.755n 0.0v 44.745n 0.0v 44.755n 0.0v 49.745n 0.0v 49.755n 0.0v 54.745n 0.0v 54.755n 0.0v 59.745n 0.0v 59.755n 0.0v 64.745n 0.0v 64.755n 0.0v 69.745n 0.0v 69.755n 0.0v 74.745n 0.0v 74.755n 0.0v 79.745n 0.0v 79.755n 0.0v 84.745n 0.0v 84.755n 0.0v 89.745n 0.0v 89.755n 0.0v 94.745n 0.0v 94.755n 0.0v 99.745n 0.0v 99.755n 0.0v 104.745n 0.0v 104.755n 0.0v 109.745n 0.0v 109.755n 0.0v 114.745n 0.0v 114.755n 0.0v 119.745n 0.0v 119.755n 0.0v 124.745n 0.0v 124.755n 0.0v 129.745n 0.0v 129.755n 0.0v 134.745n 0.0v 134.755n 0.0v 139.745n 0.0v 139.755n 0.0v 144.745n 0.0v 144.755n 0.0v 149.745n 0.0v 149.755n 0.0v 154.745n 0.0v 154.755n 0.95v 159.745n 0.95v 159.755n 0.95v 164.745n 0.95v 164.755n 0.0v 169.745n 0.0v 169.755n 0.0v 174.745n 0.0v 174.755n 0.0v 179.745n 0.0v 179.755n 0.0v 184.745n 0.0v 184.755n 0.0v 189.745n 0.0v 189.755n 0.0v 194.745n 0.0v 194.755n 0.0v 199.745n 0.0v 199.755n 0.0v 204.745n 0.0v 204.755n 0.0v 209.745n 0.0v 209.755n 0.0v 214.745n 0.0v 214.755n 0.0v 219.745n 0.0v 219.755n 0.95v 224.745n 0.95v 224.755n 0.95v 229.745n 0.95v 229.755n 0.0v 234.745n 0.0v 234.755n 0.0v 239.745n 0.0v 239.755n 0.0v 244.745n 0.0v 244.755n 0.95v 249.745n 0.95v 249.755n 0.0v 254.745n 0.0v 254.755n 0.0v 259.745n 0.0v 259.755n 0.0v 264.745n 0.0v 264.755n 0.0v 269.745n 0.0v 269.755n 0.0v 274.745n 0.0v 274.755n 0.0v 279.745n 0.0v 279.755n 0.0v 284.745n 0.0v 284.755n 0.0v 289.745n 0.0v 289.755n 0.0v 294.745n 0.0v 294.755n 0.0v 299.745n 0.0v 299.755n 0.0v 304.745n 0.0v 304.755n 0.0v 309.745n 0.0v 309.755n 0.0v 314.745n 0.0v 314.755n 0.0v 319.745n 0.0v 319.755n 0.0v 324.745n 0.0v 324.755n 0.0v 329.745n 0.0v 329.755n 0.0v 334.745n 0.0v 334.755n 0.0v 339.745n 0.0v 339.755n 0.0v 344.745n 0.0v 344.755n 0.0v 349.745n 0.0v 349.755n 0.0v 354.745n 0.0v 354.755n 0.0v 359.745n 0.0v 359.755n 0.0v 364.745n 0.0v 364.755n 0.0v 369.745n 0.0v 369.755n 0.0v 374.745n 0.0v 374.755n 0.0v 379.745n 0.0v 379.755n 0.0v 384.745n 0.0v 384.755n 0.95v 389.745n 0.95v 389.755n 0.0v 394.745n 0.0v 394.755n 0.0v 399.745n 0.0v 399.755n 0.95v 404.745n 0.95v 404.755n 0.0v 409.745n 0.0v 409.755n 0.0v 414.745n 0.0v 414.755n 0.0v 419.745n 0.0v 419.755n 0.0v 424.745n 0.0v 424.755n 0.0v 429.745n 0.0v 429.755n 0.0v 434.745n 0.0v 434.755n 0.0v 439.745n 0.0v 439.755n 0.0v 444.745n 0.0v 444.755n 0.0v 449.745n 0.0v 449.755n 0.0v 454.745n 0.0v 454.755n 0.0v 459.745n 0.0v 459.755n 0.0v 464.745n 0.0v 464.755n 0.0v 469.745n 0.0v 469.755n 0.0v 474.745n 0.0v 474.755n 0.0v 479.745n 0.0v 479.755n 0.95v 484.745n 0.95v 484.755n 0.0v 489.745n 0.0v 489.755n 0.0v 494.745n 0.0v 494.755n 0.0v 499.745n 0.0v 499.755n 0.0v 504.745n 0.0v 504.755n 0.0v 509.745n 0.0v 509.755n 0.0v 514.745n 0.0v 514.755n 0.0v 519.745n 0.0v 519.755n 0.0v 524.745n 0.0v 524.755n 0.0v 529.745n 0.0v 529.755n 0.0v 534.745n 0.0v 534.755n 0.0v 539.745n 0.0v 539.755n 0.95v 544.745n 0.95v 544.755n 0.0v 549.745n 0.0v 549.755n 0.0v 554.745n 0.0v 554.755n 0.95v 559.745n 0.95v 559.755n 0.95v 564.745n 0.95v 564.755n 0.0v 569.745n 0.0v 569.755n 0.0v 574.745n 0.0v 574.755n 0.0v 579.745n 0.0v 579.755n 0.0v 584.745n 0.0v 584.755n 0.95v 589.745n 0.95v 589.755n 0.0v 594.745n 0.0v 594.755n 0.0v 599.745n 0.0v 599.755n 0.0v 604.745n 0.0v 604.755n 0.0v 609.745n 0.0v 609.755n 0.0v 614.745n 0.0v 614.755n 0.0v 619.745n 0.0v 619.755n 0.0v 624.745n 0.0v 624.755n 0.0v 629.745n 0.0v 629.755n 0.95v 634.745n 0.95v 634.755n 0.0v 639.745n 0.0v 639.755n 0.95v 644.745n 0.95v 644.755n 0.0v 649.745n 0.0v 649.755n 0.0v 654.745n 0.0v 654.755n 0.95v 659.745n 0.95v 659.755n 0.0v 664.745n 0.0v 664.755n 0.0v 669.745n 0.0v 669.755n 0.0v 674.745n 0.0v 674.755n 0.95v 679.745n 0.95v 679.755n 0.0v 684.745n 0.0v 684.755n 0.0v 689.745n 0.0v 689.755n 0.0v 694.745n 0.0v 694.755n 0.0v 699.745n 0.0v 699.755n 0.0v 704.745n 0.0v 704.755n 0.95v 709.745n 0.95v 709.755n 0.95v 714.745n 0.95v 714.755n 0.0v 719.745n 0.0v 719.755n 0.0v 724.745n 0.0v 724.755n 0.0v 729.745n 0.0v 729.755n 0.0v 734.745n 0.0v 734.755n 0.0v 739.745n 0.0v 739.755n 0.0v 744.745n 0.0v 744.755n 0.0v 749.745n 0.0v 749.755n 0.0v 754.745n 0.0v 754.755n 0.0v 759.745n 0.0v 759.755n 0.95v 764.745n 0.95v 764.755n 0.95v 769.745n 0.95v 769.755n 0.0v 774.745n 0.0v 774.755n 0.0v 779.745n 0.0v 779.755n 0.0v 784.745n 0.0v 784.755n 0.0v 789.745n 0.0v 789.755n 0.0v 794.745n 0.0v 794.755n 0.0v 799.745n 0.0v 799.755n 0.0v 804.745n 0.0v 804.755n 0.0v 809.745n 0.0v 809.755n 0.0v 814.745n 0.0v 814.755n 0.95v 819.745n 0.95v 819.755n 0.0v 824.745n 0.0v 824.755n 0.0v 829.745n 0.0v 829.755n 0.0v 834.745n 0.0v 834.755n 0.0v 839.745n 0.0v 839.755n 0.0v 844.745n 0.0v 844.755n 0.95v 849.745n 0.95v 849.755n 0.95v 854.745n 0.95v 854.755n 0.0v 859.745n 0.0v 859.755n 0.0v 864.745n 0.0v 864.755n 0.0v 869.745n 0.0v 869.755n 0.0v 874.745n 0.0v 874.755n 0.0v 879.745n 0.0v 879.755n 0.95v 884.745n 0.95v 884.755n 0.95v 889.745n 0.95v 889.755n 0.0v 894.745n 0.0v 894.755n 0.0v 899.745n 0.0v 899.755n 0.95v 904.745n 0.95v 904.755n 0.0v 909.745n 0.0v 909.755n 0.0v 914.745n 0.0v 914.755n 0.0v 919.745n 0.0v 919.755n 0.0v 924.745n 0.0v 924.755n 0.0v 929.745n 0.0v 929.755n 0.0v 934.745n 0.0v 934.755n 0.0v 939.745n 0.0v 939.755n 0.95v 944.745n 0.95v 944.755n 0.0v 949.745n 0.0v 949.755n 0.0v 954.745n 0.0v 954.755n 0.0v 959.745n 0.0v 959.755n 0.0v 964.745n 0.0v 964.755n 0.0v 969.745n 0.0v 969.755n 0.0v 974.745n 0.0v 974.755n 0.0v 979.745n 0.0v 979.755n 0.0v 984.745n 0.0v 984.755n 0.0v 989.745n 0.0v 989.755n 0.0v 994.745n 0.0v 994.755n 0.0v 999.745n 0.0v 999.755n 0.95v 1004.745n 0.95v 1004.755n 0.0v 1009.745n 0.0v 1009.755n 0.0v 1014.745n 0.0v 1014.755n 0.0v 1019.745n 0.0v 1019.755n 0.95v 1024.745n 0.95v 1024.755n 0.95v )
* (time, data): [(0, 0), (5, 0), (10, 0), (15, 0), (20, 0), (25, 0), (30, 0), (35, 0), (40, 0), (45, 0), (50, 0), (55, 0), (60, 0), (65, 0), (70, 0), (75, 0), (80, 0), (85, 0), (90, 0), (95, 0), (100, 0), (105, 0), (110, 0), (115, 0), (120, 0), (125, 1), (130, 0), (135, 0), (140, 0), (145, 0), (150, 0), (155, 1), (160, 1), (165, 0), (170, 0), (175, 0), (180, 1), (185, 0), (190, 0), (195, 0), (200, 0), (205, 0), (210, 0), (215, 1), (220, 1), (225, 1), (230, 0), (235, 0), (240, 0), (245, 1), (250, 0), (255, 0), (260, 0), (265, 0), (270, 0), (275, 0), (280, 0), (285, 1), (290, 0), (295, 0), (300, 0), (305, 0), (310, 0), (315, 0), (320, 0), (325, 0), (330, 0), (335, 0), (340, 0), (345, 1), (350, 1), (355, 0), (360, 0), (365, 0), (370, 0), (375, 0), (380, 0), (385, 1), (390, 1), (395, 1), (400, 1), (405, 1), (410, 1), (415, 1), (420, 0), (425, 1), (430, 0), (435, 0), (440, 0), (445, 0), (450, 0), (455, 0), (460, 0), (465, 0), (470, 0), (475, 0), (480, 1), (485, 1), (490, 0), (495, 0), (500, 1), (505, 0), (510, 0), (515, 1), (520, 1), (525, 1), (530, 0), (535, 0), (540, 1), (545, 0), (550, 0), (555, 1), (560, 1), (565, 0), (570, 0), (575, 0), (580, 0), (585, 1), (590, 0), (595, 0), (600, 1), (605, 0), (610, 0), (615, 0), (620, 0), (625, 1), (630, 1), (635, 0), (640, 1), (645, 1), (650, 0), (655, 1), (660, 0), (665, 0), (670, 1), (675, 1), (680, 0), (685, 0), (690, 0), (695, 0), (700, 0), (705, 1), (710, 1), (715, 0), (720, 0), (725, 0), (730, 0), (735, 0), (740, 0), (745, 0), (750, 0), (755, 0), (760, 1), (765, 1), (770, 1), (775, 1), (780, 1), (785, 1), (790, 0), (795, 0), (800, 0), (805, 0), (810, 1), (815, 1), (820, 0), (825, 1), (830, 1), (835, 1), (840, 1), (845, 1), (850, 1), (855, 0), (860, 0), (865, 0), (870, 0), (875, 1), (880, 1), (885, 1), (890, 1), (895, 0), (900, 1), (905, 1), (910, 0), (915, 0), (920, 0), (925, 0), (930, 0), (935, 0), (940, 1), (945, 0), (950, 0), (955, 0), (960, 0), (965, 0), (970, 0), (975, 0), (980, 0), (985, 0), (990, 0), (995, 1), (1000, 1), (1005, 0), (1010, 0), (1015, 0), (1020, 1), (1025, 1)]
Va0_2  a0_2  0 PWL (0n 0.0v 4.745n 0.0v 4.755n 0.0v 9.745n 0.0v 9.755n 0.0v 14.745n 0.0v 14.755n 0.0v 19.745n 0.0v 19.755n 0.0v 24.745n 0.0v 24.755n 0.0v 29.745n 0.0v 29.755n 0.0v 34.745n 0.0v 34.755n 0.0v 39.745n 0.0v 39.755n 0.0v 44.745n 0.0v 44.755n 0.0v 49.745n 0.0v 49.755n 0.0v 54.745n 0.0v 54.755n 0.0v 59.745n 0.0v 59.755n 0.0v 64.745n 0.0v 64.755n 0.0v 69.745n 0.0v 69.755n 0.0v 74.745n 0.0v 74.755n 0.0v 79.745n 0.0v 79.755n 0.0v 84.745n 0.0v 84.755n 0.0v 89.745n 0.0v 89.755n 0.0v 94.745n 0.0v 94.755n 0.0v 99.745n 0.0v 99.755n 0.0v 104.745n 0.0v 104.755n 0.0v 109.745n 0.0v 109.755n 0.0v 114.745n 0.0v 114.755n 0.0v 119.745n 0.0v 119.755n 0.0v 124.745n 0.0v 124.755n 0.95v 129.745n 0.95v 129.755n 0.0v 134.745n 0.0v 134.755n 0.0v 139.745n 0.0v 139.755n 0.0v 144.745n 0.0v 144.755n 0.0v 149.745n 0.0v 149.755n 0.0v 154.745n 0.0v 154.755n 0.95v 159.745n 0.95v 159.755n 0.95v 164.745n 0.95v 164.755n 0.0v 169.745n 0.0v 169.755n 0.0v 174.745n 0.0v 174.755n 0.0v 179.745n 0.0v 179.755n 0.95v 184.745n 0.95v 184.755n 0.0v 189.745n 0.0v 189.755n 0.0v 194.745n 0.0v 194.755n 0.0v 199.745n 0.0v 199.755n 0.0v 204.745n 0.0v 204.755n 0.0v 209.745n 0.0v 209.755n 0.0v 214.745n 0.0v 214.755n 0.95v 219.745n 0.95v 219.755n 0.95v 224.745n 0.95v 224.755n 0.95v 229.745n 0.95v 229.755n 0.0v 234.745n 0.0v 234.755n 0.0v 239.745n 0.0v 239.755n 0.0v 244.745n 0.0v 244.755n 0.95v 249.745n 0.95v 249.755n 0.0v 254.745n 0.0v 254.755n 0.0v 259.745n 0.0v 259.755n 0.0v 264.745n 0.0v 264.755n 0.0v 269.745n 0.0v 269.755n 0.0v 274.745n 0.0v 274.755n 0.0v 279.745n 0.0v 279.755n 0.0v 284.745n 0.0v 284.755n 0.95v 289.745n 0.95v 289.755n 0.0v 294.745n 0.0v 294.755n 0.0v 299.745n 0.0v 299.755n 0.0v 304.745n 0.0v 304.755n 0.0v 309.745n 0.0v 309.755n 0.0v 314.745n 0.0v 314.755n 0.0v 319.745n 0.0v 319.755n 0.0v 324.745n 0.0v 324.755n 0.0v 329.745n 0.0v 329.755n 0.0v 334.745n 0.0v 334.755n 0.0v 339.745n 0.0v 339.755n 0.0v 344.745n 0.0v 344.755n 0.95v 349.745n 0.95v 349.755n 0.95v 354.745n 0.95v 354.755n 0.0v 359.745n 0.0v 359.755n 0.0v 364.745n 0.0v 364.755n 0.0v 369.745n 0.0v 369.755n 0.0v 374.745n 0.0v 374.755n 0.0v 379.745n 0.0v 379.755n 0.0v 384.745n 0.0v 384.755n 0.95v 389.745n 0.95v 389.755n 0.95v 394.745n 0.95v 394.755n 0.95v 399.745n 0.95v 399.755n 0.95v 404.745n 0.95v 404.755n 0.95v 409.745n 0.95v 409.755n 0.95v 414.745n 0.95v 414.755n 0.95v 419.745n 0.95v 419.755n 0.0v 424.745n 0.0v 424.755n 0.95v 429.745n 0.95v 429.755n 0.0v 434.745n 0.0v 434.755n 0.0v 439.745n 0.0v 439.755n 0.0v 444.745n 0.0v 444.755n 0.0v 449.745n 0.0v 449.755n 0.0v 454.745n 0.0v 454.755n 0.0v 459.745n 0.0v 459.755n 0.0v 464.745n 0.0v 464.755n 0.0v 469.745n 0.0v 469.755n 0.0v 474.745n 0.0v 474.755n 0.0v 479.745n 0.0v 479.755n 0.95v 484.745n 0.95v 484.755n 0.95v 489.745n 0.95v 489.755n 0.0v 494.745n 0.0v 494.755n 0.0v 499.745n 0.0v 499.755n 0.95v 504.745n 0.95v 504.755n 0.0v 509.745n 0.0v 509.755n 0.0v 514.745n 0.0v 514.755n 0.95v 519.745n 0.95v 519.755n 0.95v 524.745n 0.95v 524.755n 0.95v 529.745n 0.95v 529.755n 0.0v 534.745n 0.0v 534.755n 0.0v 539.745n 0.0v 539.755n 0.95v 544.745n 0.95v 544.755n 0.0v 549.745n 0.0v 549.755n 0.0v 554.745n 0.0v 554.755n 0.95v 559.745n 0.95v 559.755n 0.95v 564.745n 0.95v 564.755n 0.0v 569.745n 0.0v 569.755n 0.0v 574.745n 0.0v 574.755n 0.0v 579.745n 0.0v 579.755n 0.0v 584.745n 0.0v 584.755n 0.95v 589.745n 0.95v 589.755n 0.0v 594.745n 0.0v 594.755n 0.0v 599.745n 0.0v 599.755n 0.95v 604.745n 0.95v 604.755n 0.0v 609.745n 0.0v 609.755n 0.0v 614.745n 0.0v 614.755n 0.0v 619.745n 0.0v 619.755n 0.0v 624.745n 0.0v 624.755n 0.95v 629.745n 0.95v 629.755n 0.95v 634.745n 0.95v 634.755n 0.0v 639.745n 0.0v 639.755n 0.95v 644.745n 0.95v 644.755n 0.95v 649.745n 0.95v 649.755n 0.0v 654.745n 0.0v 654.755n 0.95v 659.745n 0.95v 659.755n 0.0v 664.745n 0.0v 664.755n 0.0v 669.745n 0.0v 669.755n 0.95v 674.745n 0.95v 674.755n 0.95v 679.745n 0.95v 679.755n 0.0v 684.745n 0.0v 684.755n 0.0v 689.745n 0.0v 689.755n 0.0v 694.745n 0.0v 694.755n 0.0v 699.745n 0.0v 699.755n 0.0v 704.745n 0.0v 704.755n 0.95v 709.745n 0.95v 709.755n 0.95v 714.745n 0.95v 714.755n 0.0v 719.745n 0.0v 719.755n 0.0v 724.745n 0.0v 724.755n 0.0v 729.745n 0.0v 729.755n 0.0v 734.745n 0.0v 734.755n 0.0v 739.745n 0.0v 739.755n 0.0v 744.745n 0.0v 744.755n 0.0v 749.745n 0.0v 749.755n 0.0v 754.745n 0.0v 754.755n 0.0v 759.745n 0.0v 759.755n 0.95v 764.745n 0.95v 764.755n 0.95v 769.745n 0.95v 769.755n 0.95v 774.745n 0.95v 774.755n 0.95v 779.745n 0.95v 779.755n 0.95v 784.745n 0.95v 784.755n 0.95v 789.745n 0.95v 789.755n 0.0v 794.745n 0.0v 794.755n 0.0v 799.745n 0.0v 799.755n 0.0v 804.745n 0.0v 804.755n 0.0v 809.745n 0.0v 809.755n 0.95v 814.745n 0.95v 814.755n 0.95v 819.745n 0.95v 819.755n 0.0v 824.745n 0.0v 824.755n 0.95v 829.745n 0.95v 829.755n 0.95v 834.745n 0.95v 834.755n 0.95v 839.745n 0.95v 839.755n 0.95v 844.745n 0.95v 844.755n 0.95v 849.745n 0.95v 849.755n 0.95v 854.745n 0.95v 854.755n 0.0v 859.745n 0.0v 859.755n 0.0v 864.745n 0.0v 864.755n 0.0v 869.745n 0.0v 869.755n 0.0v 874.745n 0.0v 874.755n 0.95v 879.745n 0.95v 879.755n 0.95v 884.745n 0.95v 884.755n 0.95v 889.745n 0.95v 889.755n 0.95v 894.745n 0.95v 894.755n 0.0v 899.745n 0.0v 899.755n 0.95v 904.745n 0.95v 904.755n 0.95v 909.745n 0.95v 909.755n 0.0v 914.745n 0.0v 914.755n 0.0v 919.745n 0.0v 919.755n 0.0v 924.745n 0.0v 924.755n 0.0v 929.745n 0.0v 929.755n 0.0v 934.745n 0.0v 934.755n 0.0v 939.745n 0.0v 939.755n 0.95v 944.745n 0.95v 944.755n 0.0v 949.745n 0.0v 949.755n 0.0v 954.745n 0.0v 954.755n 0.0v 959.745n 0.0v 959.755n 0.0v 964.745n 0.0v 964.755n 0.0v 969.745n 0.0v 969.755n 0.0v 974.745n 0.0v 974.755n 0.0v 979.745n 0.0v 979.755n 0.0v 984.745n 0.0v 984.755n 0.0v 989.745n 0.0v 989.755n 0.0v 994.745n 0.0v 994.755n 0.95v 999.745n 0.95v 999.755n 0.95v 1004.745n 0.95v 1004.755n 0.0v 1009.745n 0.0v 1009.755n 0.0v 1014.745n 0.0v 1014.755n 0.0v 1019.745n 0.0v 1019.755n 0.95v 1024.745n 0.95v 1024.755n 0.95v )
* (time, data): [(0, 0), (5, 0), (10, 0), (15, 0), (20, 0), (25, 0), (30, 0), (35, 0), (40, 0), (45, 0), (50, 0), (55, 0), (60, 0), (65, 0), (70, 0), (75, 0), (80, 0), (85, 0), (90, 0), (95, 0), (100, 0), (105, 0), (110, 0), (115, 0), (120, 0), (125, 1), (130, 0), (135, 0), (140, 0), (145, 0), (150, 0), (155, 1), (160, 1), (165, 0), (170, 0), (175, 0), (180, 1), (185, 0), (190, 0), (195, 0), (200, 0), (205, 0), (210, 0), (215, 1), (220, 1), (225, 1), (230, 0), (235, 0), (240, 0), (245, 1), (250, 0), (255, 0), (260, 0), (265, 0), (270, 0), (275, 0), (280, 0), (285, 1), (290, 0), (295, 0), (300, 0), (305, 0), (310, 0), (315, 0), (320, 0), (325, 0), (330, 0), (335, 0), (340, 0), (345, 1), (350, 1), (355, 0), (360, 0), (365, 0), (370, 0), (375, 0), (380, 0), (385, 1), (390, 1), (395, 1), (400, 1), (405, 1), (410, 1), (415, 1), (420, 0), (425, 1), (430, 0), (435, 0), (440, 0), (445, 0), (450, 0), (455, 0), (460, 0), (465, 0), (470, 0), (475, 0), (480, 1), (485, 1), (490, 0), (495, 0), (500, 1), (505, 0), (510, 0), (515, 1), (520, 1), (525, 1), (530, 0), (535, 0), (540, 1), (545, 0), (550, 0), (555, 1), (560, 1), (565, 0), (570, 0), (575, 0), (580, 0), (585, 1), (590, 0), (595, 0), (600, 1), (605, 0), (610, 0), (615, 0), (620, 0), (625, 1), (630, 1), (635, 0), (640, 1), (645, 1), (650, 0), (655, 1), (660, 0), (665, 0), (670, 1), (675, 1), (680, 0), (685, 0), (690, 0), (695, 0), (700, 0), (705, 1), (710, 1), (715, 0), (720, 0), (725, 0), (730, 0), (735, 0), (740, 0), (745, 0), (750, 0), (755, 0), (760, 1), (765, 1), (770, 1), (775, 1), (780, 1), (785, 1), (790, 0), (795, 0), (800, 0), (805, 0), (810, 1), (815, 1), (820, 0), (825, 1), (830, 1), (835, 1), (840, 1), (845, 1), (850, 1), (855, 0), (860, 0), (865, 0), (870, 0), (875, 1), (880, 1), (885, 1), (890, 1), (895, 0), (900, 1), (905, 1), (910, 0), (915, 0), (920, 0), (925, 0), (930, 0), (935, 0), (940, 1), (945, 0), (950, 0), (955, 0), (960, 0), (965, 0), (970, 0), (975, 0), (980, 0), (985, 0), (990, 0), (995, 1), (1000, 1), (1005, 0), (1010, 0), (1015, 0), (1020, 1), (1025, 1)]
Va0_3  a0_3  0 PWL (0n 0.0v 4.745n 0.0v 4.755n 0.0v 9.745n 0.0v 9.755n 0.0v 14.745n 0.0v 14.755n 0.0v 19.745n 0.0v 19.755n 0.0v 24.745n 0.0v 24.755n 0.0v 29.745n 0.0v 29.755n 0.0v 34.745n 0.0v 34.755n 0.0v 39.745n 0.0v 39.755n 0.0v 44.745n 0.0v 44.755n 0.0v 49.745n 0.0v 49.755n 0.0v 54.745n 0.0v 54.755n 0.0v 59.745n 0.0v 59.755n 0.0v 64.745n 0.0v 64.755n 0.0v 69.745n 0.0v 69.755n 0.0v 74.745n 0.0v 74.755n 0.0v 79.745n 0.0v 79.755n 0.0v 84.745n 0.0v 84.755n 0.0v 89.745n 0.0v 89.755n 0.0v 94.745n 0.0v 94.755n 0.0v 99.745n 0.0v 99.755n 0.0v 104.745n 0.0v 104.755n 0.0v 109.745n 0.0v 109.755n 0.0v 114.745n 0.0v 114.755n 0.0v 119.745n 0.0v 119.755n 0.0v 124.745n 0.0v 124.755n 0.95v 129.745n 0.95v 129.755n 0.0v 134.745n 0.0v 134.755n 0.0v 139.745n 0.0v 139.755n 0.0v 144.745n 0.0v 144.755n 0.0v 149.745n 0.0v 149.755n 0.0v 154.745n 0.0v 154.755n 0.95v 159.745n 0.95v 159.755n 0.95v 164.745n 0.95v 164.755n 0.0v 169.745n 0.0v 169.755n 0.0v 174.745n 0.0v 174.755n 0.0v 179.745n 0.0v 179.755n 0.95v 184.745n 0.95v 184.755n 0.0v 189.745n 0.0v 189.755n 0.0v 194.745n 0.0v 194.755n 0.0v 199.745n 0.0v 199.755n 0.0v 204.745n 0.0v 204.755n 0.0v 209.745n 0.0v 209.755n 0.0v 214.745n 0.0v 214.755n 0.95v 219.745n 0.95v 219.755n 0.95v 224.745n 0.95v 224.755n 0.95v 229.745n 0.95v 229.755n 0.0v 234.745n 0.0v 234.755n 0.0v 239.745n 0.0v 239.755n 0.0v 244.745n 0.0v 244.755n 0.95v 249.745n 0.95v 249.755n 0.0v 254.745n 0.0v 254.755n 0.0v 259.745n 0.0v 259.755n 0.0v 264.745n 0.0v 264.755n 0.0v 269.745n 0.0v 269.755n 0.0v 274.745n 0.0v 274.755n 0.0v 279.745n 0.0v 279.755n 0.0v 284.745n 0.0v 284.755n 0.95v 289.745n 0.95v 289.755n 0.0v 294.745n 0.0v 294.755n 0.0v 299.745n 0.0v 299.755n 0.0v 304.745n 0.0v 304.755n 0.0v 309.745n 0.0v 309.755n 0.0v 314.745n 0.0v 314.755n 0.0v 319.745n 0.0v 319.755n 0.0v 324.745n 0.0v 324.755n 0.0v 329.745n 0.0v 329.755n 0.0v 334.745n 0.0v 334.755n 0.0v 339.745n 0.0v 339.755n 0.0v 344.745n 0.0v 344.755n 0.95v 349.745n 0.95v 349.755n 0.95v 354.745n 0.95v 354.755n 0.0v 359.745n 0.0v 359.755n 0.0v 364.745n 0.0v 364.755n 0.0v 369.745n 0.0v 369.755n 0.0v 374.745n 0.0v 374.755n 0.0v 379.745n 0.0v 379.755n 0.0v 384.745n 0.0v 384.755n 0.95v 389.745n 0.95v 389.755n 0.95v 394.745n 0.95v 394.755n 0.95v 399.745n 0.95v 399.755n 0.95v 404.745n 0.95v 404.755n 0.95v 409.745n 0.95v 409.755n 0.95v 414.745n 0.95v 414.755n 0.95v 419.745n 0.95v 419.755n 0.0v 424.745n 0.0v 424.755n 0.95v 429.745n 0.95v 429.755n 0.0v 434.745n 0.0v 434.755n 0.0v 439.745n 0.0v 439.755n 0.0v 444.745n 0.0v 444.755n 0.0v 449.745n 0.0v 449.755n 0.0v 454.745n 0.0v 454.755n 0.0v 459.745n 0.0v 459.755n 0.0v 464.745n 0.0v 464.755n 0.0v 469.745n 0.0v 469.755n 0.0v 474.745n 0.0v 474.755n 0.0v 479.745n 0.0v 479.755n 0.95v 484.745n 0.95v 484.755n 0.95v 489.745n 0.95v 489.755n 0.0v 494.745n 0.0v 494.755n 0.0v 499.745n 0.0v 499.755n 0.95v 504.745n 0.95v 504.755n 0.0v 509.745n 0.0v 509.755n 0.0v 514.745n 0.0v 514.755n 0.95v 519.745n 0.95v 519.755n 0.95v 524.745n 0.95v 524.755n 0.95v 529.745n 0.95v 529.755n 0.0v 534.745n 0.0v 534.755n 0.0v 539.745n 0.0v 539.755n 0.95v 544.745n 0.95v 544.755n 0.0v 549.745n 0.0v 549.755n 0.0v 554.745n 0.0v 554.755n 0.95v 559.745n 0.95v 559.755n 0.95v 564.745n 0.95v 564.755n 0.0v 569.745n 0.0v 569.755n 0.0v 574.745n 0.0v 574.755n 0.0v 579.745n 0.0v 579.755n 0.0v 584.745n 0.0v 584.755n 0.95v 589.745n 0.95v 589.755n 0.0v 594.745n 0.0v 594.755n 0.0v 599.745n 0.0v 599.755n 0.95v 604.745n 0.95v 604.755n 0.0v 609.745n 0.0v 609.755n 0.0v 614.745n 0.0v 614.755n 0.0v 619.745n 0.0v 619.755n 0.0v 624.745n 0.0v 624.755n 0.95v 629.745n 0.95v 629.755n 0.95v 634.745n 0.95v 634.755n 0.0v 639.745n 0.0v 639.755n 0.95v 644.745n 0.95v 644.755n 0.95v 649.745n 0.95v 649.755n 0.0v 654.745n 0.0v 654.755n 0.95v 659.745n 0.95v 659.755n 0.0v 664.745n 0.0v 664.755n 0.0v 669.745n 0.0v 669.755n 0.95v 674.745n 0.95v 674.755n 0.95v 679.745n 0.95v 679.755n 0.0v 684.745n 0.0v 684.755n 0.0v 689.745n 0.0v 689.755n 0.0v 694.745n 0.0v 694.755n 0.0v 699.745n 0.0v 699.755n 0.0v 704.745n 0.0v 704.755n 0.95v 709.745n 0.95v 709.755n 0.95v 714.745n 0.95v 714.755n 0.0v 719.745n 0.0v 719.755n 0.0v 724.745n 0.0v 724.755n 0.0v 729.745n 0.0v 729.755n 0.0v 734.745n 0.0v 734.755n 0.0v 739.745n 0.0v 739.755n 0.0v 744.745n 0.0v 744.755n 0.0v 749.745n 0.0v 749.755n 0.0v 754.745n 0.0v 754.755n 0.0v 759.745n 0.0v 759.755n 0.95v 764.745n 0.95v 764.755n 0.95v 769.745n 0.95v 769.755n 0.95v 774.745n 0.95v 774.755n 0.95v 779.745n 0.95v 779.755n 0.95v 784.745n 0.95v 784.755n 0.95v 789.745n 0.95v 789.755n 0.0v 794.745n 0.0v 794.755n 0.0v 799.745n 0.0v 799.755n 0.0v 804.745n 0.0v 804.755n 0.0v 809.745n 0.0v 809.755n 0.95v 814.745n 0.95v 814.755n 0.95v 819.745n 0.95v 819.755n 0.0v 824.745n 0.0v 824.755n 0.95v 829.745n 0.95v 829.755n 0.95v 834.745n 0.95v 834.755n 0.95v 839.745n 0.95v 839.755n 0.95v 844.745n 0.95v 844.755n 0.95v 849.745n 0.95v 849.755n 0.95v 854.745n 0.95v 854.755n 0.0v 859.745n 0.0v 859.755n 0.0v 864.745n 0.0v 864.755n 0.0v 869.745n 0.0v 869.755n 0.0v 874.745n 0.0v 874.755n 0.95v 879.745n 0.95v 879.755n 0.95v 884.745n 0.95v 884.755n 0.95v 889.745n 0.95v 889.755n 0.95v 894.745n 0.95v 894.755n 0.0v 899.745n 0.0v 899.755n 0.95v 904.745n 0.95v 904.755n 0.95v 909.745n 0.95v 909.755n 0.0v 914.745n 0.0v 914.755n 0.0v 919.745n 0.0v 919.755n 0.0v 924.745n 0.0v 924.755n 0.0v 929.745n 0.0v 929.755n 0.0v 934.745n 0.0v 934.755n 0.0v 939.745n 0.0v 939.755n 0.95v 944.745n 0.95v 944.755n 0.0v 949.745n 0.0v 949.755n 0.0v 954.745n 0.0v 954.755n 0.0v 959.745n 0.0v 959.755n 0.0v 964.745n 0.0v 964.755n 0.0v 969.745n 0.0v 969.755n 0.0v 974.745n 0.0v 974.755n 0.0v 979.745n 0.0v 979.755n 0.0v 984.745n 0.0v 984.755n 0.0v 989.745n 0.0v 989.755n 0.0v 994.745n 0.0v 994.755n 0.95v 999.745n 0.95v 999.755n 0.95v 1004.745n 0.95v 1004.755n 0.0v 1009.745n 0.0v 1009.755n 0.0v 1014.745n 0.0v 1014.755n 0.0v 1019.745n 0.0v 1019.755n 0.95v 1024.745n 0.95v 1024.755n 0.95v )
* (time, data): [(0, 0), (5, 0), (10, 0), (15, 0), (20, 0), (25, 0), (30, 0), (35, 0), (40, 0), (45, 0), (50, 0), (55, 0), (60, 0), (65, 0), (70, 0), (75, 0), (80, 0), (85, 0), (90, 0), (95, 0), (100, 0), (105, 0), (110, 0), (115, 0), (120, 0), (125, 1), (130, 0), (135, 0), (140, 0), (145, 0), (150, 0), (155, 1), (160, 1), (165, 0), (170, 0), (175, 0), (180, 1), (185, 0), (190, 0), (195, 0), (200, 0), (205, 0), (210, 0), (215, 1), (220, 1), (225, 1), (230, 0), (235, 0), (240, 0), (245, 1), (250, 0), (255, 0), (260, 0), (265, 0), (270, 0), (275, 0), (280, 0), (285, 1), (290, 0), (295, 0), (300, 0), (305, 0), (310, 0), (315, 0), (320, 0), (325, 0), (330, 0), (335, 0), (340, 0), (345, 1), (350, 1), (355, 0), (360, 0), (365, 0), (370, 0), (375, 0), (380, 0), (385, 1), (390, 1), (395, 1), (400, 1), (405, 1), (410, 1), (415, 1), (420, 0), (425, 1), (430, 0), (435, 0), (440, 0), (445, 0), (450, 0), (455, 0), (460, 0), (465, 0), (470, 0), (475, 0), (480, 1), (485, 1), (490, 0), (495, 0), (500, 1), (505, 0), (510, 0), (515, 1), (520, 1), (525, 1), (530, 0), (535, 0), (540, 1), (545, 0), (550, 0), (555, 1), (560, 1), (565, 0), (570, 0), (575, 0), (580, 0), (585, 1), (590, 0), (595, 0), (600, 1), (605, 0), (610, 0), (615, 0), (620, 0), (625, 1), (630, 1), (635, 0), (640, 1), (645, 1), (650, 0), (655, 1), (660, 0), (665, 0), (670, 1), (675, 1), (680, 0), (685, 0), (690, 0), (695, 0), (700, 0), (705, 1), (710, 1), (715, 0), (720, 0), (725, 0), (730, 0), (735, 0), (740, 0), (745, 0), (750, 0), (755, 0), (760, 1), (765, 1), (770, 1), (775, 1), (780, 1), (785, 1), (790, 0), (795, 0), (800, 0), (805, 0), (810, 1), (815, 1), (820, 0), (825, 1), (830, 1), (835, 1), (840, 1), (845, 1), (850, 1), (855, 0), (860, 0), (865, 0), (870, 0), (875, 1), (880, 1), (885, 1), (890, 1), (895, 0), (900, 1), (905, 1), (910, 0), (915, 0), (920, 0), (925, 0), (930, 0), (935, 0), (940, 1), (945, 0), (950, 0), (955, 0), (960, 0), (965, 0), (970, 0), (975, 0), (980, 0), (985, 0), (990, 0), (995, 1), (1000, 1), (1005, 0), (1010, 0), (1015, 0), (1020, 1), (1025, 1)]
Va0_4  a0_4  0 PWL (0n 0.0v 4.745n 0.0v 4.755n 0.0v 9.745n 0.0v 9.755n 0.0v 14.745n 0.0v 14.755n 0.0v 19.745n 0.0v 19.755n 0.0v 24.745n 0.0v 24.755n 0.0v 29.745n 0.0v 29.755n 0.0v 34.745n 0.0v 34.755n 0.0v 39.745n 0.0v 39.755n 0.0v 44.745n 0.0v 44.755n 0.0v 49.745n 0.0v 49.755n 0.0v 54.745n 0.0v 54.755n 0.0v 59.745n 0.0v 59.755n 0.0v 64.745n 0.0v 64.755n 0.0v 69.745n 0.0v 69.755n 0.0v 74.745n 0.0v 74.755n 0.0v 79.745n 0.0v 79.755n 0.0v 84.745n 0.0v 84.755n 0.0v 89.745n 0.0v 89.755n 0.0v 94.745n 0.0v 94.755n 0.0v 99.745n 0.0v 99.755n 0.0v 104.745n 0.0v 104.755n 0.0v 109.745n 0.0v 109.755n 0.0v 114.745n 0.0v 114.755n 0.0v 119.745n 0.0v 119.755n 0.0v 124.745n 0.0v 124.755n 0.95v 129.745n 0.95v 129.755n 0.0v 134.745n 0.0v 134.755n 0.0v 139.745n 0.0v 139.755n 0.0v 144.745n 0.0v 144.755n 0.0v 149.745n 0.0v 149.755n 0.0v 154.745n 0.0v 154.755n 0.95v 159.745n 0.95v 159.755n 0.95v 164.745n 0.95v 164.755n 0.0v 169.745n 0.0v 169.755n 0.0v 174.745n 0.0v 174.755n 0.0v 179.745n 0.0v 179.755n 0.95v 184.745n 0.95v 184.755n 0.0v 189.745n 0.0v 189.755n 0.0v 194.745n 0.0v 194.755n 0.0v 199.745n 0.0v 199.755n 0.0v 204.745n 0.0v 204.755n 0.0v 209.745n 0.0v 209.755n 0.0v 214.745n 0.0v 214.755n 0.95v 219.745n 0.95v 219.755n 0.95v 224.745n 0.95v 224.755n 0.95v 229.745n 0.95v 229.755n 0.0v 234.745n 0.0v 234.755n 0.0v 239.745n 0.0v 239.755n 0.0v 244.745n 0.0v 244.755n 0.95v 249.745n 0.95v 249.755n 0.0v 254.745n 0.0v 254.755n 0.0v 259.745n 0.0v 259.755n 0.0v 264.745n 0.0v 264.755n 0.0v 269.745n 0.0v 269.755n 0.0v 274.745n 0.0v 274.755n 0.0v 279.745n 0.0v 279.755n 0.0v 284.745n 0.0v 284.755n 0.95v 289.745n 0.95v 289.755n 0.0v 294.745n 0.0v 294.755n 0.0v 299.745n 0.0v 299.755n 0.0v 304.745n 0.0v 304.755n 0.0v 309.745n 0.0v 309.755n 0.0v 314.745n 0.0v 314.755n 0.0v 319.745n 0.0v 319.755n 0.0v 324.745n 0.0v 324.755n 0.0v 329.745n 0.0v 329.755n 0.0v 334.745n 0.0v 334.755n 0.0v 339.745n 0.0v 339.755n 0.0v 344.745n 0.0v 344.755n 0.95v 349.745n 0.95v 349.755n 0.95v 354.745n 0.95v 354.755n 0.0v 359.745n 0.0v 359.755n 0.0v 364.745n 0.0v 364.755n 0.0v 369.745n 0.0v 369.755n 0.0v 374.745n 0.0v 374.755n 0.0v 379.745n 0.0v 379.755n 0.0v 384.745n 0.0v 384.755n 0.95v 389.745n 0.95v 389.755n 0.95v 394.745n 0.95v 394.755n 0.95v 399.745n 0.95v 399.755n 0.95v 404.745n 0.95v 404.755n 0.95v 409.745n 0.95v 409.755n 0.95v 414.745n 0.95v 414.755n 0.95v 419.745n 0.95v 419.755n 0.0v 424.745n 0.0v 424.755n 0.95v 429.745n 0.95v 429.755n 0.0v 434.745n 0.0v 434.755n 0.0v 439.745n 0.0v 439.755n 0.0v 444.745n 0.0v 444.755n 0.0v 449.745n 0.0v 449.755n 0.0v 454.745n 0.0v 454.755n 0.0v 459.745n 0.0v 459.755n 0.0v 464.745n 0.0v 464.755n 0.0v 469.745n 0.0v 469.755n 0.0v 474.745n 0.0v 474.755n 0.0v 479.745n 0.0v 479.755n 0.95v 484.745n 0.95v 484.755n 0.95v 489.745n 0.95v 489.755n 0.0v 494.745n 0.0v 494.755n 0.0v 499.745n 0.0v 499.755n 0.95v 504.745n 0.95v 504.755n 0.0v 509.745n 0.0v 509.755n 0.0v 514.745n 0.0v 514.755n 0.95v 519.745n 0.95v 519.755n 0.95v 524.745n 0.95v 524.755n 0.95v 529.745n 0.95v 529.755n 0.0v 534.745n 0.0v 534.755n 0.0v 539.745n 0.0v 539.755n 0.95v 544.745n 0.95v 544.755n 0.0v 549.745n 0.0v 549.755n 0.0v 554.745n 0.0v 554.755n 0.95v 559.745n 0.95v 559.755n 0.95v 564.745n 0.95v 564.755n 0.0v 569.745n 0.0v 569.755n 0.0v 574.745n 0.0v 574.755n 0.0v 579.745n 0.0v 579.755n 0.0v 584.745n 0.0v 584.755n 0.95v 589.745n 0.95v 589.755n 0.0v 594.745n 0.0v 594.755n 0.0v 599.745n 0.0v 599.755n 0.95v 604.745n 0.95v 604.755n 0.0v 609.745n 0.0v 609.755n 0.0v 614.745n 0.0v 614.755n 0.0v 619.745n 0.0v 619.755n 0.0v 624.745n 0.0v 624.755n 0.95v 629.745n 0.95v 629.755n 0.95v 634.745n 0.95v 634.755n 0.0v 639.745n 0.0v 639.755n 0.95v 644.745n 0.95v 644.755n 0.95v 649.745n 0.95v 649.755n 0.0v 654.745n 0.0v 654.755n 0.95v 659.745n 0.95v 659.755n 0.0v 664.745n 0.0v 664.755n 0.0v 669.745n 0.0v 669.755n 0.95v 674.745n 0.95v 674.755n 0.95v 679.745n 0.95v 679.755n 0.0v 684.745n 0.0v 684.755n 0.0v 689.745n 0.0v 689.755n 0.0v 694.745n 0.0v 694.755n 0.0v 699.745n 0.0v 699.755n 0.0v 704.745n 0.0v 704.755n 0.95v 709.745n 0.95v 709.755n 0.95v 714.745n 0.95v 714.755n 0.0v 719.745n 0.0v 719.755n 0.0v 724.745n 0.0v 724.755n 0.0v 729.745n 0.0v 729.755n 0.0v 734.745n 0.0v 734.755n 0.0v 739.745n 0.0v 739.755n 0.0v 744.745n 0.0v 744.755n 0.0v 749.745n 0.0v 749.755n 0.0v 754.745n 0.0v 754.755n 0.0v 759.745n 0.0v 759.755n 0.95v 764.745n 0.95v 764.755n 0.95v 769.745n 0.95v 769.755n 0.95v 774.745n 0.95v 774.755n 0.95v 779.745n 0.95v 779.755n 0.95v 784.745n 0.95v 784.755n 0.95v 789.745n 0.95v 789.755n 0.0v 794.745n 0.0v 794.755n 0.0v 799.745n 0.0v 799.755n 0.0v 804.745n 0.0v 804.755n 0.0v 809.745n 0.0v 809.755n 0.95v 814.745n 0.95v 814.755n 0.95v 819.745n 0.95v 819.755n 0.0v 824.745n 0.0v 824.755n 0.95v 829.745n 0.95v 829.755n 0.95v 834.745n 0.95v 834.755n 0.95v 839.745n 0.95v 839.755n 0.95v 844.745n 0.95v 844.755n 0.95v 849.745n 0.95v 849.755n 0.95v 854.745n 0.95v 854.755n 0.0v 859.745n 0.0v 859.755n 0.0v 864.745n 0.0v 864.755n 0.0v 869.745n 0.0v 869.755n 0.0v 874.745n 0.0v 874.755n 0.95v 879.745n 0.95v 879.755n 0.95v 884.745n 0.95v 884.755n 0.95v 889.745n 0.95v 889.755n 0.95v 894.745n 0.95v 894.755n 0.0v 899.745n 0.0v 899.755n 0.95v 904.745n 0.95v 904.755n 0.95v 909.745n 0.95v 909.755n 0.0v 914.745n 0.0v 914.755n 0.0v 919.745n 0.0v 919.755n 0.0v 924.745n 0.0v 924.755n 0.0v 929.745n 0.0v 929.755n 0.0v 934.745n 0.0v 934.755n 0.0v 939.745n 0.0v 939.755n 0.95v 944.745n 0.95v 944.755n 0.0v 949.745n 0.0v 949.755n 0.0v 954.745n 0.0v 954.755n 0.0v 959.745n 0.0v 959.755n 0.0v 964.745n 0.0v 964.755n 0.0v 969.745n 0.0v 969.755n 0.0v 974.745n 0.0v 974.755n 0.0v 979.745n 0.0v 979.755n 0.0v 984.745n 0.0v 984.755n 0.0v 989.745n 0.0v 989.755n 0.0v 994.745n 0.0v 994.755n 0.95v 999.745n 0.95v 999.755n 0.95v 1004.745n 0.95v 1004.755n 0.0v 1009.745n 0.0v 1009.755n 0.0v 1014.745n 0.0v 1014.755n 0.0v 1019.745n 0.0v 1019.755n 0.95v 1024.745n 0.95v 1024.755n 0.95v )
* (time, data): [(0, 0), (5, 0), (10, 0), (15, 0), (20, 0), (25, 0), (30, 0), (35, 0), (40, 0), (45, 0), (50, 0), (55, 0), (60, 0), (65, 0), (70, 0), (75, 0), (80, 0), (85, 0), (90, 0), (95, 0), (100, 0), (105, 0), (110, 0), (115, 0), (120, 0), (125, 1), (130, 0), (135, 0), (140, 0), (145, 0), (150, 0), (155, 1), (160, 1), (165, 0), (170, 0), (175, 0), (180, 1), (185, 0), (190, 0), (195, 0), (200, 0), (205, 0), (210, 0), (215, 1), (220, 1), (225, 1), (230, 0), (235, 0), (240, 0), (245, 1), (250, 0), (255, 0), (260, 0), (265, 0), (270, 0), (275, 0), (280, 0), (285, 1), (290, 0), (295, 0), (300, 0), (305, 0), (310, 0), (315, 0), (320, 0), (325, 0), (330, 0), (335, 0), (340, 0), (345, 1), (350, 1), (355, 0), (360, 0), (365, 0), (370, 0), (375, 0), (380, 0), (385, 1), (390, 1), (395, 1), (400, 1), (405, 1), (410, 1), (415, 1), (420, 0), (425, 1), (430, 0), (435, 0), (440, 0), (445, 0), (450, 0), (455, 0), (460, 0), (465, 0), (470, 0), (475, 0), (480, 1), (485, 1), (490, 0), (495, 0), (500, 1), (505, 0), (510, 0), (515, 1), (520, 1), (525, 1), (530, 0), (535, 0), (540, 1), (545, 0), (550, 0), (555, 1), (560, 1), (565, 0), (570, 0), (575, 0), (580, 0), (585, 1), (590, 0), (595, 0), (600, 1), (605, 0), (610, 0), (615, 0), (620, 0), (625, 1), (630, 1), (635, 0), (640, 1), (645, 1), (650, 0), (655, 1), (660, 0), (665, 0), (670, 1), (675, 1), (680, 0), (685, 0), (690, 0), (695, 0), (700, 0), (705, 1), (710, 1), (715, 0), (720, 0), (725, 0), (730, 0), (735, 0), (740, 0), (745, 0), (750, 0), (755, 0), (760, 1), (765, 1), (770, 1), (775, 1), (780, 1), (785, 1), (790, 0), (795, 0), (800, 0), (805, 0), (810, 1), (815, 1), (820, 0), (825, 1), (830, 1), (835, 1), (840, 1), (845, 1), (850, 1), (855, 0), (860, 0), (865, 0), (870, 0), (875, 1), (880, 1), (885, 1), (890, 1), (895, 0), (900, 1), (905, 1), (910, 0), (915, 0), (920, 0), (925, 0), (930, 0), (935, 0), (940, 1), (945, 0), (950, 0), (955, 0), (960, 0), (965, 0), (970, 0), (975, 0), (980, 0), (985, 0), (990, 0), (995, 1), (1000, 1), (1005, 0), (1010, 0), (1015, 0), (1020, 1), (1025, 1)]
Va0_5  a0_5  0 PWL (0n 0.0v 4.745n 0.0v 4.755n 0.0v 9.745n 0.0v 9.755n 0.0v 14.745n 0.0v 14.755n 0.0v 19.745n 0.0v 19.755n 0.0v 24.745n 0.0v 24.755n 0.0v 29.745n 0.0v 29.755n 0.0v 34.745n 0.0v 34.755n 0.0v 39.745n 0.0v 39.755n 0.0v 44.745n 0.0v 44.755n 0.0v 49.745n 0.0v 49.755n 0.0v 54.745n 0.0v 54.755n 0.0v 59.745n 0.0v 59.755n 0.0v 64.745n 0.0v 64.755n 0.0v 69.745n 0.0v 69.755n 0.0v 74.745n 0.0v 74.755n 0.0v 79.745n 0.0v 79.755n 0.0v 84.745n 0.0v 84.755n 0.0v 89.745n 0.0v 89.755n 0.0v 94.745n 0.0v 94.755n 0.0v 99.745n 0.0v 99.755n 0.0v 104.745n 0.0v 104.755n 0.0v 109.745n 0.0v 109.755n 0.0v 114.745n 0.0v 114.755n 0.0v 119.745n 0.0v 119.755n 0.0v 124.745n 0.0v 124.755n 0.95v 129.745n 0.95v 129.755n 0.0v 134.745n 0.0v 134.755n 0.0v 139.745n 0.0v 139.755n 0.0v 144.745n 0.0v 144.755n 0.0v 149.745n 0.0v 149.755n 0.0v 154.745n 0.0v 154.755n 0.95v 159.745n 0.95v 159.755n 0.95v 164.745n 0.95v 164.755n 0.0v 169.745n 0.0v 169.755n 0.0v 174.745n 0.0v 174.755n 0.0v 179.745n 0.0v 179.755n 0.95v 184.745n 0.95v 184.755n 0.0v 189.745n 0.0v 189.755n 0.0v 194.745n 0.0v 194.755n 0.0v 199.745n 0.0v 199.755n 0.0v 204.745n 0.0v 204.755n 0.0v 209.745n 0.0v 209.755n 0.0v 214.745n 0.0v 214.755n 0.95v 219.745n 0.95v 219.755n 0.95v 224.745n 0.95v 224.755n 0.95v 229.745n 0.95v 229.755n 0.0v 234.745n 0.0v 234.755n 0.0v 239.745n 0.0v 239.755n 0.0v 244.745n 0.0v 244.755n 0.95v 249.745n 0.95v 249.755n 0.0v 254.745n 0.0v 254.755n 0.0v 259.745n 0.0v 259.755n 0.0v 264.745n 0.0v 264.755n 0.0v 269.745n 0.0v 269.755n 0.0v 274.745n 0.0v 274.755n 0.0v 279.745n 0.0v 279.755n 0.0v 284.745n 0.0v 284.755n 0.95v 289.745n 0.95v 289.755n 0.0v 294.745n 0.0v 294.755n 0.0v 299.745n 0.0v 299.755n 0.0v 304.745n 0.0v 304.755n 0.0v 309.745n 0.0v 309.755n 0.0v 314.745n 0.0v 314.755n 0.0v 319.745n 0.0v 319.755n 0.0v 324.745n 0.0v 324.755n 0.0v 329.745n 0.0v 329.755n 0.0v 334.745n 0.0v 334.755n 0.0v 339.745n 0.0v 339.755n 0.0v 344.745n 0.0v 344.755n 0.95v 349.745n 0.95v 349.755n 0.95v 354.745n 0.95v 354.755n 0.0v 359.745n 0.0v 359.755n 0.0v 364.745n 0.0v 364.755n 0.0v 369.745n 0.0v 369.755n 0.0v 374.745n 0.0v 374.755n 0.0v 379.745n 0.0v 379.755n 0.0v 384.745n 0.0v 384.755n 0.95v 389.745n 0.95v 389.755n 0.95v 394.745n 0.95v 394.755n 0.95v 399.745n 0.95v 399.755n 0.95v 404.745n 0.95v 404.755n 0.95v 409.745n 0.95v 409.755n 0.95v 414.745n 0.95v 414.755n 0.95v 419.745n 0.95v 419.755n 0.0v 424.745n 0.0v 424.755n 0.95v 429.745n 0.95v 429.755n 0.0v 434.745n 0.0v 434.755n 0.0v 439.745n 0.0v 439.755n 0.0v 444.745n 0.0v 444.755n 0.0v 449.745n 0.0v 449.755n 0.0v 454.745n 0.0v 454.755n 0.0v 459.745n 0.0v 459.755n 0.0v 464.745n 0.0v 464.755n 0.0v 469.745n 0.0v 469.755n 0.0v 474.745n 0.0v 474.755n 0.0v 479.745n 0.0v 479.755n 0.95v 484.745n 0.95v 484.755n 0.95v 489.745n 0.95v 489.755n 0.0v 494.745n 0.0v 494.755n 0.0v 499.745n 0.0v 499.755n 0.95v 504.745n 0.95v 504.755n 0.0v 509.745n 0.0v 509.755n 0.0v 514.745n 0.0v 514.755n 0.95v 519.745n 0.95v 519.755n 0.95v 524.745n 0.95v 524.755n 0.95v 529.745n 0.95v 529.755n 0.0v 534.745n 0.0v 534.755n 0.0v 539.745n 0.0v 539.755n 0.95v 544.745n 0.95v 544.755n 0.0v 549.745n 0.0v 549.755n 0.0v 554.745n 0.0v 554.755n 0.95v 559.745n 0.95v 559.755n 0.95v 564.745n 0.95v 564.755n 0.0v 569.745n 0.0v 569.755n 0.0v 574.745n 0.0v 574.755n 0.0v 579.745n 0.0v 579.755n 0.0v 584.745n 0.0v 584.755n 0.95v 589.745n 0.95v 589.755n 0.0v 594.745n 0.0v 594.755n 0.0v 599.745n 0.0v 599.755n 0.95v 604.745n 0.95v 604.755n 0.0v 609.745n 0.0v 609.755n 0.0v 614.745n 0.0v 614.755n 0.0v 619.745n 0.0v 619.755n 0.0v 624.745n 0.0v 624.755n 0.95v 629.745n 0.95v 629.755n 0.95v 634.745n 0.95v 634.755n 0.0v 639.745n 0.0v 639.755n 0.95v 644.745n 0.95v 644.755n 0.95v 649.745n 0.95v 649.755n 0.0v 654.745n 0.0v 654.755n 0.95v 659.745n 0.95v 659.755n 0.0v 664.745n 0.0v 664.755n 0.0v 669.745n 0.0v 669.755n 0.95v 674.745n 0.95v 674.755n 0.95v 679.745n 0.95v 679.755n 0.0v 684.745n 0.0v 684.755n 0.0v 689.745n 0.0v 689.755n 0.0v 694.745n 0.0v 694.755n 0.0v 699.745n 0.0v 699.755n 0.0v 704.745n 0.0v 704.755n 0.95v 709.745n 0.95v 709.755n 0.95v 714.745n 0.95v 714.755n 0.0v 719.745n 0.0v 719.755n 0.0v 724.745n 0.0v 724.755n 0.0v 729.745n 0.0v 729.755n 0.0v 734.745n 0.0v 734.755n 0.0v 739.745n 0.0v 739.755n 0.0v 744.745n 0.0v 744.755n 0.0v 749.745n 0.0v 749.755n 0.0v 754.745n 0.0v 754.755n 0.0v 759.745n 0.0v 759.755n 0.95v 764.745n 0.95v 764.755n 0.95v 769.745n 0.95v 769.755n 0.95v 774.745n 0.95v 774.755n 0.95v 779.745n 0.95v 779.755n 0.95v 784.745n 0.95v 784.755n 0.95v 789.745n 0.95v 789.755n 0.0v 794.745n 0.0v 794.755n 0.0v 799.745n 0.0v 799.755n 0.0v 804.745n 0.0v 804.755n 0.0v 809.745n 0.0v 809.755n 0.95v 814.745n 0.95v 814.755n 0.95v 819.745n 0.95v 819.755n 0.0v 824.745n 0.0v 824.755n 0.95v 829.745n 0.95v 829.755n 0.95v 834.745n 0.95v 834.755n 0.95v 839.745n 0.95v 839.755n 0.95v 844.745n 0.95v 844.755n 0.95v 849.745n 0.95v 849.755n 0.95v 854.745n 0.95v 854.755n 0.0v 859.745n 0.0v 859.755n 0.0v 864.745n 0.0v 864.755n 0.0v 869.745n 0.0v 869.755n 0.0v 874.745n 0.0v 874.755n 0.95v 879.745n 0.95v 879.755n 0.95v 884.745n 0.95v 884.755n 0.95v 889.745n 0.95v 889.755n 0.95v 894.745n 0.95v 894.755n 0.0v 899.745n 0.0v 899.755n 0.95v 904.745n 0.95v 904.755n 0.95v 909.745n 0.95v 909.755n 0.0v 914.745n 0.0v 914.755n 0.0v 919.745n 0.0v 919.755n 0.0v 924.745n 0.0v 924.755n 0.0v 929.745n 0.0v 929.755n 0.0v 934.745n 0.0v 934.755n 0.0v 939.745n 0.0v 939.755n 0.95v 944.745n 0.95v 944.755n 0.0v 949.745n 0.0v 949.755n 0.0v 954.745n 0.0v 954.755n 0.0v 959.745n 0.0v 959.755n 0.0v 964.745n 0.0v 964.755n 0.0v 969.745n 0.0v 969.755n 0.0v 974.745n 0.0v 974.755n 0.0v 979.745n 0.0v 979.755n 0.0v 984.745n 0.0v 984.755n 0.0v 989.745n 0.0v 989.755n 0.0v 994.745n 0.0v 994.755n 0.95v 999.745n 0.95v 999.755n 0.95v 1004.745n 0.95v 1004.755n 0.0v 1009.745n 0.0v 1009.755n 0.0v 1014.745n 0.0v 1014.755n 0.0v 1019.745n 0.0v 1019.755n 0.95v 1024.745n 0.95v 1024.755n 0.95v )

 * Generation of control signals
* (time, data): [(0, 1), (5, 0), (10, 0), (15, 0), (20, 0), (25, 1), (30, 0), (35, 1), (40, 1), (45, 0), (50, 0), (55, 0), (60, 0), (65, 0), (70, 0), (75, 0), (80, 0), (85, 0), (90, 0), (95, 0), (100, 1), (105, 0), (110, 1), (115, 0), (120, 0), (125, 0), (130, 0), (135, 0), (140, 1), (145, 0), (150, 0), (155, 0), (160, 1), (165, 0), (170, 1), (175, 0), (180, 0), (185, 0), (190, 1), (195, 1), (200, 0), (205, 0), (210, 0), (215, 0), (220, 0), (225, 1), (230, 0), (235, 0), (240, 0), (245, 0), (250, 0), (255, 1), (260, 0), (265, 0), (270, 1), (275, 1), (280, 1), (285, 0), (290, 0), (295, 0), (300, 0), (305, 0), (310, 1), (315, 0), (320, 1), (325, 1), (330, 1), (335, 1), (340, 1), (345, 0), (350, 1), (355, 0), (360, 0), (365, 0), (370, 1), (375, 1), (380, 0), (385, 0), (390, 0), (395, 0), (400, 0), (405, 0), (410, 1), (415, 1), (420, 0), (425, 0), (430, 0), (435, 0), (440, 1), (445, 1), (450, 1), (455, 1), (460, 0), (465, 0), (470, 0), (475, 1), (480, 0), (485, 0), (490, 0), (495, 0), (500, 0), (505, 0), (510, 1), (515, 0), (520, 1), (525, 0), (530, 0), (535, 0), (540, 0), (545, 0), (550, 1), (555, 0), (560, 1), (565, 0), (570, 1), (575, 1), (580, 0), (585, 0), (590, 0), (595, 1), (600, 0), (605, 0), (610, 0), (615, 0), (620, 0), (625, 0), (630, 0), (635, 0), (640, 0), (645, 0), (650, 0), (655, 0), (660, 0), (665, 1), (670, 0), (675, 0), (680, 0), (685, 0), (690, 1), (695, 1), (700, 0), (705, 0), (710, 0), (715, 0), (720, 1), (725, 0), (730, 0), (735, 0), (740, 0), (745, 0), (750, 0), (755, 1), (760, 0), (765, 1), (770, 0), (775, 1), (780, 0), (785, 0), (790, 0), (795, 0), (800, 0), (805, 1), (810, 0), (815, 0), (820, 0), (825, 0), (830, 0), (835, 1), (840, 1), (845, 0), (850, 0), (855, 0), (860, 0), (865, 1), (870, 0), (875, 0), (880, 0), (885, 1), (890, 0), (895, 0), (900, 0), (905, 0), (910, 0), (915, 0), (920, 0), (925, 0), (930, 1), (935, 1), (940, 0), (945, 0), (950, 0), (955, 0), (960, 0), (965, 0), (970, 0), (975, 0), (980, 1), (985, 0), (990, 1), (995, 0), (1000, 0), (1005, 0), (1010, 1), (1015, 1), (1020, 0), (1025, 1)]
VCSB0 CSB0 0 PWL (0n 0.95v 4.745n 0.95v 4.755n 0.0v 9.745n 0.0v 9.755n 0.0v 14.745n 0.0v 14.755n 0.0v 19.745n 0.0v 19.755n 0.0v 24.745n 0.0v 24.755n 0.95v 29.745n 0.95v 29.755n 0.0v 34.745n 0.0v 34.755n 0.95v 39.745n 0.95v 39.755n 0.95v 44.745n 0.95v 44.755n 0.0v 49.745n 0.0v 49.755n 0.0v 54.745n 0.0v 54.755n 0.0v 59.745n 0.0v 59.755n 0.0v 64.745n 0.0v 64.755n 0.0v 69.745n 0.0v 69.755n 0.0v 74.745n 0.0v 74.755n 0.0v 79.745n 0.0v 79.755n 0.0v 84.745n 0.0v 84.755n 0.0v 89.745n 0.0v 89.755n 0.0v 94.745n 0.0v 94.755n 0.0v 99.745n 0.0v 99.755n 0.95v 104.745n 0.95v 104.755n 0.0v 109.745n 0.0v 109.755n 0.95v 114.745n 0.95v 114.755n 0.0v 119.745n 0.0v 119.755n 0.0v 124.745n 0.0v 124.755n 0.0v 129.745n 0.0v 129.755n 0.0v 134.745n 0.0v 134.755n 0.0v 139.745n 0.0v 139.755n 0.95v 144.745n 0.95v 144.755n 0.0v 149.745n 0.0v 149.755n 0.0v 154.745n 0.0v 154.755n 0.0v 159.745n 0.0v 159.755n 0.95v 164.745n 0.95v 164.755n 0.0v 169.745n 0.0v 169.755n 0.95v 174.745n 0.95v 174.755n 0.0v 179.745n 0.0v 179.755n 0.0v 184.745n 0.0v 184.755n 0.0v 189.745n 0.0v 189.755n 0.95v 194.745n 0.95v 194.755n 0.95v 199.745n 0.95v 199.755n 0.0v 204.745n 0.0v 204.755n 0.0v 209.745n 0.0v 209.755n 0.0v 214.745n 0.0v 214.755n 0.0v 219.745n 0.0v 219.755n 0.0v 224.745n 0.0v 224.755n 0.95v 229.745n 0.95v 229.755n 0.0v 234.745n 0.0v 234.755n 0.0v 239.745n 0.0v 239.755n 0.0v 244.745n 0.0v 244.755n 0.0v 249.745n 0.0v 249.755n 0.0v 254.745n 0.0v 254.755n 0.95v 259.745n 0.95v 259.755n 0.0v 264.745n 0.0v 264.755n 0.0v 269.745n 0.0v 269.755n 0.95v 274.745n 0.95v 274.755n 0.95v 279.745n 0.95v 279.755n 0.95v 284.745n 0.95v 284.755n 0.0v 289.745n 0.0v 289.755n 0.0v 294.745n 0.0v 294.755n 0.0v 299.745n 0.0v 299.755n 0.0v 304.745n 0.0v 304.755n 0.0v 309.745n 0.0v 309.755n 0.95v 314.745n 0.95v 314.755n 0.0v 319.745n 0.0v 319.755n 0.95v 324.745n 0.95v 324.755n 0.95v 329.745n 0.95v 329.755n 0.95v 334.745n 0.95v 334.755n 0.95v 339.745n 0.95v 339.755n 0.95v 344.745n 0.95v 344.755n 0.0v 349.745n 0.0v 349.755n 0.95v 354.745n 0.95v 354.755n 0.0v 359.745n 0.0v 359.755n 0.0v 364.745n 0.0v 364.755n 0.0v 369.745n 0.0v 369.755n 0.95v 374.745n 0.95v 374.755n 0.95v 379.745n 0.95v 379.755n 0.0v 384.745n 0.0v 384.755n 0.0v 389.745n 0.0v 389.755n 0.0v 394.745n 0.0v 394.755n 0.0v 399.745n 0.0v 399.755n 0.0v 404.745n 0.0v 404.755n 0.0v 409.745n 0.0v 409.755n 0.95v 414.745n 0.95v 414.755n 0.95v 419.745n 0.95v 419.755n 0.0v 424.745n 0.0v 424.755n 0.0v 429.745n 0.0v 429.755n 0.0v 434.745n 0.0v 434.755n 0.0v 439.745n 0.0v 439.755n 0.95v 444.745n 0.95v 444.755n 0.95v 449.745n 0.95v 449.755n 0.95v 454.745n 0.95v 454.755n 0.95v 459.745n 0.95v 459.755n 0.0v 464.745n 0.0v 464.755n 0.0v 469.745n 0.0v 469.755n 0.0v 474.745n 0.0v 474.755n 0.95v 479.745n 0.95v 479.755n 0.0v 484.745n 0.0v 484.755n 0.0v 489.745n 0.0v 489.755n 0.0v 494.745n 0.0v 494.755n 0.0v 499.745n 0.0v 499.755n 0.0v 504.745n 0.0v 504.755n 0.0v 509.745n 0.0v 509.755n 0.95v 514.745n 0.95v 514.755n 0.0v 519.745n 0.0v 519.755n 0.95v 524.745n 0.95v 524.755n 0.0v 529.745n 0.0v 529.755n 0.0v 534.745n 0.0v 534.755n 0.0v 539.745n 0.0v 539.755n 0.0v 544.745n 0.0v 544.755n 0.0v 549.745n 0.0v 549.755n 0.95v 554.745n 0.95v 554.755n 0.0v 559.745n 0.0v 559.755n 0.95v 564.745n 0.95v 564.755n 0.0v 569.745n 0.0v 569.755n 0.95v 574.745n 0.95v 574.755n 0.95v 579.745n 0.95v 579.755n 0.0v 584.745n 0.0v 584.755n 0.0v 589.745n 0.0v 589.755n 0.0v 594.745n 0.0v 594.755n 0.95v 599.745n 0.95v 599.755n 0.0v 604.745n 0.0v 604.755n 0.0v 609.745n 0.0v 609.755n 0.0v 614.745n 0.0v 614.755n 0.0v 619.745n 0.0v 619.755n 0.0v 624.745n 0.0v 624.755n 0.0v 629.745n 0.0v 629.755n 0.0v 634.745n 0.0v 634.755n 0.0v 639.745n 0.0v 639.755n 0.0v 644.745n 0.0v 644.755n 0.0v 649.745n 0.0v 649.755n 0.0v 654.745n 0.0v 654.755n 0.0v 659.745n 0.0v 659.755n 0.0v 664.745n 0.0v 664.755n 0.95v 669.745n 0.95v 669.755n 0.0v 674.745n 0.0v 674.755n 0.0v 679.745n 0.0v 679.755n 0.0v 684.745n 0.0v 684.755n 0.0v 689.745n 0.0v 689.755n 0.95v 694.745n 0.95v 694.755n 0.95v 699.745n 0.95v 699.755n 0.0v 704.745n 0.0v 704.755n 0.0v 709.745n 0.0v 709.755n 0.0v 714.745n 0.0v 714.755n 0.0v 719.745n 0.0v 719.755n 0.95v 724.745n 0.95v 724.755n 0.0v 729.745n 0.0v 729.755n 0.0v 734.745n 0.0v 734.755n 0.0v 739.745n 0.0v 739.755n 0.0v 744.745n 0.0v 744.755n 0.0v 749.745n 0.0v 749.755n 0.0v 754.745n 0.0v 754.755n 0.95v 759.745n 0.95v 759.755n 0.0v 764.745n 0.0v 764.755n 0.95v 769.745n 0.95v 769.755n 0.0v 774.745n 0.0v 774.755n 0.95v 779.745n 0.95v 779.755n 0.0v 784.745n 0.0v 784.755n 0.0v 789.745n 0.0v 789.755n 0.0v 794.745n 0.0v 794.755n 0.0v 799.745n 0.0v 799.755n 0.0v 804.745n 0.0v 804.755n 0.95v 809.745n 0.95v 809.755n 0.0v 814.745n 0.0v 814.755n 0.0v 819.745n 0.0v 819.755n 0.0v 824.745n 0.0v 824.755n 0.0v 829.745n 0.0v 829.755n 0.0v 834.745n 0.0v 834.755n 0.95v 839.745n 0.95v 839.755n 0.95v 844.745n 0.95v 844.755n 0.0v 849.745n 0.0v 849.755n 0.0v 854.745n 0.0v 854.755n 0.0v 859.745n 0.0v 859.755n 0.0v 864.745n 0.0v 864.755n 0.95v 869.745n 0.95v 869.755n 0.0v 874.745n 0.0v 874.755n 0.0v 879.745n 0.0v 879.755n 0.0v 884.745n 0.0v 884.755n 0.95v 889.745n 0.95v 889.755n 0.0v 894.745n 0.0v 894.755n 0.0v 899.745n 0.0v 899.755n 0.0v 904.745n 0.0v 904.755n 0.0v 909.745n 0.0v 909.755n 0.0v 914.745n 0.0v 914.755n 0.0v 919.745n 0.0v 919.755n 0.0v 924.745n 0.0v 924.755n 0.0v 929.745n 0.0v 929.755n 0.95v 934.745n 0.95v 934.755n 0.95v 939.745n 0.95v 939.755n 0.0v 944.745n 0.0v 944.755n 0.0v 949.745n 0.0v 949.755n 0.0v 954.745n 0.0v 954.755n 0.0v 959.745n 0.0v 959.755n 0.0v 964.745n 0.0v 964.755n 0.0v 969.745n 0.0v 969.755n 0.0v 974.745n 0.0v 974.755n 0.0v 979.745n 0.0v 979.755n 0.95v 984.745n 0.95v 984.755n 0.0v 989.745n 0.0v 989.755n 0.95v 994.745n 0.95v 994.755n 0.0v 999.745n 0.0v 999.755n 0.0v 1004.745n 0.0v 1004.755n 0.0v 1009.745n 0.0v 1009.755n 0.95v 1014.745n 0.95v 1014.755n 0.95v 1019.745n 0.95v 1019.755n 0.0v 1024.745n 0.0v 1024.755n 0.95v )
* (time, data): [(0, 1), (5, 0), (10, 0), (15, 0), (20, 1), (25, 1), (30, 0), (35, 1), (40, 1), (45, 0), (50, 1), (55, 1), (60, 1), (65, 0), (70, 1), (75, 1), (80, 1), (85, 1), (90, 1), (95, 1), (100, 1), (105, 1), (110, 1), (115, 1), (120, 1), (125, 0), (130, 1), (135, 1), (140, 1), (145, 1), (150, 1), (155, 0), (160, 1), (165, 1), (170, 1), (175, 1), (180, 1), (185, 0), (190, 1), (195, 1), (200, 1), (205, 1), (210, 1), (215, 0), (220, 0), (225, 1), (230, 0), (235, 1), (240, 0), (245, 0), (250, 1), (255, 1), (260, 0), (265, 0), (270, 1), (275, 1), (280, 1), (285, 0), (290, 1), (295, 1), (300, 1), (305, 1), (310, 1), (315, 1), (320, 1), (325, 1), (330, 1), (335, 1), (340, 1), (345, 1), (350, 1), (355, 0), (360, 1), (365, 0), (370, 1), (375, 1), (380, 0), (385, 1), (390, 0), (395, 1), (400, 1), (405, 0), (410, 1), (415, 1), (420, 1), (425, 1), (430, 0), (435, 1), (440, 1), (445, 1), (450, 1), (455, 1), (460, 1), (465, 1), (470, 0), (475, 1), (480, 1), (485, 0), (490, 0), (495, 1), (500, 1), (505, 1), (510, 1), (515, 1), (520, 1), (525, 1), (530, 1), (535, 1), (540, 1), (545, 1), (550, 1), (555, 1), (560, 1), (565, 1), (570, 1), (575, 1), (580, 0), (585, 1), (590, 0), (595, 1), (600, 0), (605, 1), (610, 0), (615, 0), (620, 0), (625, 1), (630, 1), (635, 1), (640, 1), (645, 1), (650, 1), (655, 1), (660, 0), (665, 1), (670, 1), (675, 0), (680, 1), (685, 0), (690, 1), (695, 1), (700, 1), (705, 0), (710, 0), (715, 1), (720, 1), (725, 1), (730, 0), (735, 0), (740, 0), (745, 1), (750, 1), (755, 1), (760, 1), (765, 1), (770, 1), (775, 1), (780, 0), (785, 1), (790, 1), (795, 1), (800, 0), (805, 1), (810, 1), (815, 1), (820, 0), (825, 1), (830, 0), (835, 1), (840, 1), (845, 1), (850, 1), (855, 0), (860, 1), (865, 1), (870, 1), (875, 1), (880, 0), (885, 1), (890, 0), (895, 1), (900, 1), (905, 1), (910, 0), (915, 1), (920, 0), (925, 1), (930, 1), (935, 1), (940, 1), (945, 0), (950, 0), (955, 1), (960, 0), (965, 1), (970, 1), (975, 1), (980, 1), (985, 0), (990, 1), (995, 1), (1000, 1), (1005, 0), (1010, 1), (1015, 1), (1020, 1), (1025, 1)]
VWEB0 WEB0 0 PWL (0n 0.95v 4.745n 0.95v 4.755n 0.0v 9.745n 0.0v 9.755n 0.0v 14.745n 0.0v 14.755n 0.0v 19.745n 0.0v 19.755n 0.95v 24.745n 0.95v 24.755n 0.95v 29.745n 0.95v 29.755n 0.0v 34.745n 0.0v 34.755n 0.95v 39.745n 0.95v 39.755n 0.95v 44.745n 0.95v 44.755n 0.0v 49.745n 0.0v 49.755n 0.95v 54.745n 0.95v 54.755n 0.95v 59.745n 0.95v 59.755n 0.95v 64.745n 0.95v 64.755n 0.0v 69.745n 0.0v 69.755n 0.95v 74.745n 0.95v 74.755n 0.95v 79.745n 0.95v 79.755n 0.95v 84.745n 0.95v 84.755n 0.95v 89.745n 0.95v 89.755n 0.95v 94.745n 0.95v 94.755n 0.95v 99.745n 0.95v 99.755n 0.95v 104.745n 0.95v 104.755n 0.95v 109.745n 0.95v 109.755n 0.95v 114.745n 0.95v 114.755n 0.95v 119.745n 0.95v 119.755n 0.95v 124.745n 0.95v 124.755n 0.0v 129.745n 0.0v 129.755n 0.95v 134.745n 0.95v 134.755n 0.95v 139.745n 0.95v 139.755n 0.95v 144.745n 0.95v 144.755n 0.95v 149.745n 0.95v 149.755n 0.95v 154.745n 0.95v 154.755n 0.0v 159.745n 0.0v 159.755n 0.95v 164.745n 0.95v 164.755n 0.95v 169.745n 0.95v 169.755n 0.95v 174.745n 0.95v 174.755n 0.95v 179.745n 0.95v 179.755n 0.95v 184.745n 0.95v 184.755n 0.0v 189.745n 0.0v 189.755n 0.95v 194.745n 0.95v 194.755n 0.95v 199.745n 0.95v 199.755n 0.95v 204.745n 0.95v 204.755n 0.95v 209.745n 0.95v 209.755n 0.95v 214.745n 0.95v 214.755n 0.0v 219.745n 0.0v 219.755n 0.0v 224.745n 0.0v 224.755n 0.95v 229.745n 0.95v 229.755n 0.0v 234.745n 0.0v 234.755n 0.95v 239.745n 0.95v 239.755n 0.0v 244.745n 0.0v 244.755n 0.0v 249.745n 0.0v 249.755n 0.95v 254.745n 0.95v 254.755n 0.95v 259.745n 0.95v 259.755n 0.0v 264.745n 0.0v 264.755n 0.0v 269.745n 0.0v 269.755n 0.95v 274.745n 0.95v 274.755n 0.95v 279.745n 0.95v 279.755n 0.95v 284.745n 0.95v 284.755n 0.0v 289.745n 0.0v 289.755n 0.95v 294.745n 0.95v 294.755n 0.95v 299.745n 0.95v 299.755n 0.95v 304.745n 0.95v 304.755n 0.95v 309.745n 0.95v 309.755n 0.95v 314.745n 0.95v 314.755n 0.95v 319.745n 0.95v 319.755n 0.95v 324.745n 0.95v 324.755n 0.95v 329.745n 0.95v 329.755n 0.95v 334.745n 0.95v 334.755n 0.95v 339.745n 0.95v 339.755n 0.95v 344.745n 0.95v 344.755n 0.95v 349.745n 0.95v 349.755n 0.95v 354.745n 0.95v 354.755n 0.0v 359.745n 0.0v 359.755n 0.95v 364.745n 0.95v 364.755n 0.0v 369.745n 0.0v 369.755n 0.95v 374.745n 0.95v 374.755n 0.95v 379.745n 0.95v 379.755n 0.0v 384.745n 0.0v 384.755n 0.95v 389.745n 0.95v 389.755n 0.0v 394.745n 0.0v 394.755n 0.95v 399.745n 0.95v 399.755n 0.95v 404.745n 0.95v 404.755n 0.0v 409.745n 0.0v 409.755n 0.95v 414.745n 0.95v 414.755n 0.95v 419.745n 0.95v 419.755n 0.95v 424.745n 0.95v 424.755n 0.95v 429.745n 0.95v 429.755n 0.0v 434.745n 0.0v 434.755n 0.95v 439.745n 0.95v 439.755n 0.95v 444.745n 0.95v 444.755n 0.95v 449.745n 0.95v 449.755n 0.95v 454.745n 0.95v 454.755n 0.95v 459.745n 0.95v 459.755n 0.95v 464.745n 0.95v 464.755n 0.95v 469.745n 0.95v 469.755n 0.0v 474.745n 0.0v 474.755n 0.95v 479.745n 0.95v 479.755n 0.95v 484.745n 0.95v 484.755n 0.0v 489.745n 0.0v 489.755n 0.0v 494.745n 0.0v 494.755n 0.95v 499.745n 0.95v 499.755n 0.95v 504.745n 0.95v 504.755n 0.95v 509.745n 0.95v 509.755n 0.95v 514.745n 0.95v 514.755n 0.95v 519.745n 0.95v 519.755n 0.95v 524.745n 0.95v 524.755n 0.95v 529.745n 0.95v 529.755n 0.95v 534.745n 0.95v 534.755n 0.95v 539.745n 0.95v 539.755n 0.95v 544.745n 0.95v 544.755n 0.95v 549.745n 0.95v 549.755n 0.95v 554.745n 0.95v 554.755n 0.95v 559.745n 0.95v 559.755n 0.95v 564.745n 0.95v 564.755n 0.95v 569.745n 0.95v 569.755n 0.95v 574.745n 0.95v 574.755n 0.95v 579.745n 0.95v 579.755n 0.0v 584.745n 0.0v 584.755n 0.95v 589.745n 0.95v 589.755n 0.0v 594.745n 0.0v 594.755n 0.95v 599.745n 0.95v 599.755n 0.0v 604.745n 0.0v 604.755n 0.95v 609.745n 0.95v 609.755n 0.0v 614.745n 0.0v 614.755n 0.0v 619.745n 0.0v 619.755n 0.0v 624.745n 0.0v 624.755n 0.95v 629.745n 0.95v 629.755n 0.95v 634.745n 0.95v 634.755n 0.95v 639.745n 0.95v 639.755n 0.95v 644.745n 0.95v 644.755n 0.95v 649.745n 0.95v 649.755n 0.95v 654.745n 0.95v 654.755n 0.95v 659.745n 0.95v 659.755n 0.0v 664.745n 0.0v 664.755n 0.95v 669.745n 0.95v 669.755n 0.95v 674.745n 0.95v 674.755n 0.0v 679.745n 0.0v 679.755n 0.95v 684.745n 0.95v 684.755n 0.0v 689.745n 0.0v 689.755n 0.95v 694.745n 0.95v 694.755n 0.95v 699.745n 0.95v 699.755n 0.95v 704.745n 0.95v 704.755n 0.0v 709.745n 0.0v 709.755n 0.0v 714.745n 0.0v 714.755n 0.95v 719.745n 0.95v 719.755n 0.95v 724.745n 0.95v 724.755n 0.95v 729.745n 0.95v 729.755n 0.0v 734.745n 0.0v 734.755n 0.0v 739.745n 0.0v 739.755n 0.0v 744.745n 0.0v 744.755n 0.95v 749.745n 0.95v 749.755n 0.95v 754.745n 0.95v 754.755n 0.95v 759.745n 0.95v 759.755n 0.95v 764.745n 0.95v 764.755n 0.95v 769.745n 0.95v 769.755n 0.95v 774.745n 0.95v 774.755n 0.95v 779.745n 0.95v 779.755n 0.0v 784.745n 0.0v 784.755n 0.95v 789.745n 0.95v 789.755n 0.95v 794.745n 0.95v 794.755n 0.95v 799.745n 0.95v 799.755n 0.0v 804.745n 0.0v 804.755n 0.95v 809.745n 0.95v 809.755n 0.95v 814.745n 0.95v 814.755n 0.95v 819.745n 0.95v 819.755n 0.0v 824.745n 0.0v 824.755n 0.95v 829.745n 0.95v 829.755n 0.0v 834.745n 0.0v 834.755n 0.95v 839.745n 0.95v 839.755n 0.95v 844.745n 0.95v 844.755n 0.95v 849.745n 0.95v 849.755n 0.95v 854.745n 0.95v 854.755n 0.0v 859.745n 0.0v 859.755n 0.95v 864.745n 0.95v 864.755n 0.95v 869.745n 0.95v 869.755n 0.95v 874.745n 0.95v 874.755n 0.95v 879.745n 0.95v 879.755n 0.0v 884.745n 0.0v 884.755n 0.95v 889.745n 0.95v 889.755n 0.0v 894.745n 0.0v 894.755n 0.95v 899.745n 0.95v 899.755n 0.95v 904.745n 0.95v 904.755n 0.95v 909.745n 0.95v 909.755n 0.0v 914.745n 0.0v 914.755n 0.95v 919.745n 0.95v 919.755n 0.0v 924.745n 0.0v 924.755n 0.95v 929.745n 0.95v 929.755n 0.95v 934.745n 0.95v 934.755n 0.95v 939.745n 0.95v 939.755n 0.95v 944.745n 0.95v 944.755n 0.0v 949.745n 0.0v 949.755n 0.0v 954.745n 0.0v 954.755n 0.95v 959.745n 0.95v 959.755n 0.0v 964.745n 0.0v 964.755n 0.95v 969.745n 0.95v 969.755n 0.95v 974.745n 0.95v 974.755n 0.95v 979.745n 0.95v 979.755n 0.95v 984.745n 0.95v 984.755n 0.0v 989.745n 0.0v 989.755n 0.95v 994.745n 0.95v 994.755n 0.95v 999.745n 0.95v 999.755n 0.95v 1004.745n 0.95v 1004.755n 0.0v 1009.745n 0.0v 1009.755n 0.95v 1014.745n 0.95v 1014.755n 0.95v 1019.745n 0.95v 1019.755n 0.95v 1024.745n 0.95v 1024.755n 0.95v )
* PULSE: period=5
Vclk0 clk0 0 PULSE (0 0.95 4.995n 0.01n 0.01n 2.49n 5n)

 * Generation of dout measurements
* CHECK dout0_0 vdout0_0ck4 = 0.95 time = 25
* CHECK dout0_1 vdout0_1ck4 = 0.95 time = 25
* CHECK dout0_2 vdout0_2ck4 = 0 time = 25
* CHECK dout0_3 vdout0_3ck4 = 0.95 time = 25
* CHECK dout0_4 vdout0_4ck4 = 0.95 time = 25
* CHECK dout0_5 vdout0_5ck4 = 0.95 time = 25
* CHECK dout0_6 vdout0_6ck4 = 0 time = 25
* CHECK dout0_7 vdout0_7ck4 = 0 time = 25
* CHECK dout0_8 vdout0_8ck4 = 0 time = 25
* CHECK dout0_9 vdout0_9ck4 = 0 time = 25
* CHECK dout0_10 vdout0_10ck4 = 0.95 time = 25
* CHECK dout0_11 vdout0_11ck4 = 0 time = 25
* CHECK dout0_12 vdout0_12ck4 = 0 time = 25
* CHECK dout0_13 vdout0_13ck4 = 0 time = 25
* CHECK dout0_14 vdout0_14ck4 = 0 time = 25
* CHECK dout0_15 vdout0_15ck4 = 0 time = 25
* CHECK dout0_16 vdout0_16ck4 = 0.95 time = 25
* CHECK dout0_17 vdout0_17ck4 = 0.95 time = 25
* CHECK dout0_18 vdout0_18ck4 = 0 time = 25
* CHECK dout0_19 vdout0_19ck4 = 0.95 time = 25
* CHECK dout0_20 vdout0_20ck4 = 0.95 time = 25
* CHECK dout0_0 vdout0_0ck10 = 0.95 time = 55
* CHECK dout0_1 vdout0_1ck10 = 0.95 time = 55
* CHECK dout0_2 vdout0_2ck10 = 0 time = 55
* CHECK dout0_3 vdout0_3ck10 = 0.95 time = 55
* CHECK dout0_4 vdout0_4ck10 = 0.95 time = 55
* CHECK dout0_5 vdout0_5ck10 = 0.95 time = 55
* CHECK dout0_6 vdout0_6ck10 = 0 time = 55
* CHECK dout0_7 vdout0_7ck10 = 0 time = 55
* CHECK dout0_8 vdout0_8ck10 = 0 time = 55
* CHECK dout0_9 vdout0_9ck10 = 0 time = 55
* CHECK dout0_10 vdout0_10ck10 = 0.95 time = 55
* CHECK dout0_11 vdout0_11ck10 = 0 time = 55
* CHECK dout0_12 vdout0_12ck10 = 0 time = 55
* CHECK dout0_13 vdout0_13ck10 = 0 time = 55
* CHECK dout0_14 vdout0_14ck10 = 0 time = 55
* CHECK dout0_15 vdout0_15ck10 = 0 time = 55
* CHECK dout0_16 vdout0_16ck10 = 0.95 time = 55
* CHECK dout0_17 vdout0_17ck10 = 0.95 time = 55
* CHECK dout0_18 vdout0_18ck10 = 0 time = 55
* CHECK dout0_19 vdout0_19ck10 = 0.95 time = 55
* CHECK dout0_20 vdout0_20ck10 = 0.95 time = 55
* CHECK dout0_0 vdout0_0ck11 = 0.95 time = 60
* CHECK dout0_1 vdout0_1ck11 = 0.95 time = 60
* CHECK dout0_2 vdout0_2ck11 = 0.95 time = 60
* CHECK dout0_3 vdout0_3ck11 = 0.95 time = 60
* CHECK dout0_4 vdout0_4ck11 = 0 time = 60
* CHECK dout0_5 vdout0_5ck11 = 0.95 time = 60
* CHECK dout0_6 vdout0_6ck11 = 0.95 time = 60
* CHECK dout0_7 vdout0_7ck11 = 0 time = 60
* CHECK dout0_8 vdout0_8ck11 = 0 time = 60
* CHECK dout0_9 vdout0_9ck11 = 0.95 time = 60
* CHECK dout0_10 vdout0_10ck11 = 0 time = 60
* CHECK dout0_11 vdout0_11ck11 = 0.95 time = 60
* CHECK dout0_12 vdout0_12ck11 = 0.95 time = 60
* CHECK dout0_13 vdout0_13ck11 = 0.95 time = 60
* CHECK dout0_14 vdout0_14ck11 = 0 time = 60
* CHECK dout0_15 vdout0_15ck11 = 0 time = 60
* CHECK dout0_16 vdout0_16ck11 = 0.95 time = 60
* CHECK dout0_17 vdout0_17ck11 = 0 time = 60
* CHECK dout0_18 vdout0_18ck11 = 0.95 time = 60
* CHECK dout0_19 vdout0_19ck11 = 0 time = 60
* CHECK dout0_20 vdout0_20ck11 = 0.95 time = 60
* CHECK dout0_0 vdout0_0ck12 = 0.95 time = 65
* CHECK dout0_1 vdout0_1ck12 = 0.95 time = 65
* CHECK dout0_2 vdout0_2ck12 = 0.95 time = 65
* CHECK dout0_3 vdout0_3ck12 = 0.95 time = 65
* CHECK dout0_4 vdout0_4ck12 = 0 time = 65
* CHECK dout0_5 vdout0_5ck12 = 0.95 time = 65
* CHECK dout0_6 vdout0_6ck12 = 0.95 time = 65
* CHECK dout0_7 vdout0_7ck12 = 0 time = 65
* CHECK dout0_8 vdout0_8ck12 = 0 time = 65
* CHECK dout0_9 vdout0_9ck12 = 0.95 time = 65
* CHECK dout0_10 vdout0_10ck12 = 0 time = 65
* CHECK dout0_11 vdout0_11ck12 = 0.95 time = 65
* CHECK dout0_12 vdout0_12ck12 = 0.95 time = 65
* CHECK dout0_13 vdout0_13ck12 = 0.95 time = 65
* CHECK dout0_14 vdout0_14ck12 = 0 time = 65
* CHECK dout0_15 vdout0_15ck12 = 0 time = 65
* CHECK dout0_16 vdout0_16ck12 = 0.95 time = 65
* CHECK dout0_17 vdout0_17ck12 = 0 time = 65
* CHECK dout0_18 vdout0_18ck12 = 0.95 time = 65
* CHECK dout0_19 vdout0_19ck12 = 0 time = 65
* CHECK dout0_20 vdout0_20ck12 = 0.95 time = 65
* CHECK dout0_0 vdout0_0ck14 = 0.95 time = 75
* CHECK dout0_1 vdout0_1ck14 = 0.95 time = 75
* CHECK dout0_2 vdout0_2ck14 = 0 time = 75
* CHECK dout0_3 vdout0_3ck14 = 0.95 time = 75
* CHECK dout0_4 vdout0_4ck14 = 0.95 time = 75
* CHECK dout0_5 vdout0_5ck14 = 0.95 time = 75
* CHECK dout0_6 vdout0_6ck14 = 0 time = 75
* CHECK dout0_7 vdout0_7ck14 = 0 time = 75
* CHECK dout0_8 vdout0_8ck14 = 0 time = 75
* CHECK dout0_9 vdout0_9ck14 = 0 time = 75
* CHECK dout0_10 vdout0_10ck14 = 0.95 time = 75
* CHECK dout0_11 vdout0_11ck14 = 0 time = 75
* CHECK dout0_12 vdout0_12ck14 = 0 time = 75
* CHECK dout0_13 vdout0_13ck14 = 0 time = 75
* CHECK dout0_14 vdout0_14ck14 = 0 time = 75
* CHECK dout0_15 vdout0_15ck14 = 0 time = 75
* CHECK dout0_16 vdout0_16ck14 = 0.95 time = 75
* CHECK dout0_17 vdout0_17ck14 = 0.95 time = 75
* CHECK dout0_18 vdout0_18ck14 = 0 time = 75
* CHECK dout0_19 vdout0_19ck14 = 0.95 time = 75
* CHECK dout0_20 vdout0_20ck14 = 0.95 time = 75
* CHECK dout0_0 vdout0_0ck15 = 0.95 time = 80
* CHECK dout0_1 vdout0_1ck15 = 0.95 time = 80
* CHECK dout0_2 vdout0_2ck15 = 0 time = 80
* CHECK dout0_3 vdout0_3ck15 = 0.95 time = 80
* CHECK dout0_4 vdout0_4ck15 = 0.95 time = 80
* CHECK dout0_5 vdout0_5ck15 = 0.95 time = 80
* CHECK dout0_6 vdout0_6ck15 = 0 time = 80
* CHECK dout0_7 vdout0_7ck15 = 0 time = 80
* CHECK dout0_8 vdout0_8ck15 = 0 time = 80
* CHECK dout0_9 vdout0_9ck15 = 0 time = 80
* CHECK dout0_10 vdout0_10ck15 = 0.95 time = 80
* CHECK dout0_11 vdout0_11ck15 = 0 time = 80
* CHECK dout0_12 vdout0_12ck15 = 0 time = 80
* CHECK dout0_13 vdout0_13ck15 = 0 time = 80
* CHECK dout0_14 vdout0_14ck15 = 0 time = 80
* CHECK dout0_15 vdout0_15ck15 = 0 time = 80
* CHECK dout0_16 vdout0_16ck15 = 0.95 time = 80
* CHECK dout0_17 vdout0_17ck15 = 0.95 time = 80
* CHECK dout0_18 vdout0_18ck15 = 0 time = 80
* CHECK dout0_19 vdout0_19ck15 = 0.95 time = 80
* CHECK dout0_20 vdout0_20ck15 = 0.95 time = 80
* CHECK dout0_0 vdout0_0ck16 = 0.95 time = 85
* CHECK dout0_1 vdout0_1ck16 = 0.95 time = 85
* CHECK dout0_2 vdout0_2ck16 = 0.95 time = 85
* CHECK dout0_3 vdout0_3ck16 = 0.95 time = 85
* CHECK dout0_4 vdout0_4ck16 = 0.95 time = 85
* CHECK dout0_5 vdout0_5ck16 = 0 time = 85
* CHECK dout0_6 vdout0_6ck16 = 0 time = 85
* CHECK dout0_7 vdout0_7ck16 = 0 time = 85
* CHECK dout0_8 vdout0_8ck16 = 0 time = 85
* CHECK dout0_9 vdout0_9ck16 = 0 time = 85
* CHECK dout0_10 vdout0_10ck16 = 0 time = 85
* CHECK dout0_11 vdout0_11ck16 = 0 time = 85
* CHECK dout0_12 vdout0_12ck16 = 0 time = 85
* CHECK dout0_13 vdout0_13ck16 = 0.95 time = 85
* CHECK dout0_14 vdout0_14ck16 = 0 time = 85
* CHECK dout0_15 vdout0_15ck16 = 0.95 time = 85
* CHECK dout0_16 vdout0_16ck16 = 0 time = 85
* CHECK dout0_17 vdout0_17ck16 = 0.95 time = 85
* CHECK dout0_18 vdout0_18ck16 = 0 time = 85
* CHECK dout0_19 vdout0_19ck16 = 0.95 time = 85
* CHECK dout0_20 vdout0_20ck16 = 0 time = 85
* CHECK dout0_0 vdout0_0ck17 = 0.95 time = 90
* CHECK dout0_1 vdout0_1ck17 = 0.95 time = 90
* CHECK dout0_2 vdout0_2ck17 = 0.95 time = 90
* CHECK dout0_3 vdout0_3ck17 = 0.95 time = 90
* CHECK dout0_4 vdout0_4ck17 = 0.95 time = 90
* CHECK dout0_5 vdout0_5ck17 = 0 time = 90
* CHECK dout0_6 vdout0_6ck17 = 0 time = 90
* CHECK dout0_7 vdout0_7ck17 = 0 time = 90
* CHECK dout0_8 vdout0_8ck17 = 0 time = 90
* CHECK dout0_9 vdout0_9ck17 = 0 time = 90
* CHECK dout0_10 vdout0_10ck17 = 0 time = 90
* CHECK dout0_11 vdout0_11ck17 = 0 time = 90
* CHECK dout0_12 vdout0_12ck17 = 0 time = 90
* CHECK dout0_13 vdout0_13ck17 = 0.95 time = 90
* CHECK dout0_14 vdout0_14ck17 = 0 time = 90
* CHECK dout0_15 vdout0_15ck17 = 0.95 time = 90
* CHECK dout0_16 vdout0_16ck17 = 0 time = 90
* CHECK dout0_17 vdout0_17ck17 = 0.95 time = 90
* CHECK dout0_18 vdout0_18ck17 = 0 time = 90
* CHECK dout0_19 vdout0_19ck17 = 0.95 time = 90
* CHECK dout0_20 vdout0_20ck17 = 0 time = 90
* CHECK dout0_0 vdout0_0ck18 = 0.95 time = 95
* CHECK dout0_1 vdout0_1ck18 = 0.95 time = 95
* CHECK dout0_2 vdout0_2ck18 = 0.95 time = 95
* CHECK dout0_3 vdout0_3ck18 = 0.95 time = 95
* CHECK dout0_4 vdout0_4ck18 = 0.95 time = 95
* CHECK dout0_5 vdout0_5ck18 = 0 time = 95
* CHECK dout0_6 vdout0_6ck18 = 0 time = 95
* CHECK dout0_7 vdout0_7ck18 = 0 time = 95
* CHECK dout0_8 vdout0_8ck18 = 0 time = 95
* CHECK dout0_9 vdout0_9ck18 = 0 time = 95
* CHECK dout0_10 vdout0_10ck18 = 0 time = 95
* CHECK dout0_11 vdout0_11ck18 = 0 time = 95
* CHECK dout0_12 vdout0_12ck18 = 0 time = 95
* CHECK dout0_13 vdout0_13ck18 = 0.95 time = 95
* CHECK dout0_14 vdout0_14ck18 = 0 time = 95
* CHECK dout0_15 vdout0_15ck18 = 0.95 time = 95
* CHECK dout0_16 vdout0_16ck18 = 0 time = 95
* CHECK dout0_17 vdout0_17ck18 = 0.95 time = 95
* CHECK dout0_18 vdout0_18ck18 = 0 time = 95
* CHECK dout0_19 vdout0_19ck18 = 0.95 time = 95
* CHECK dout0_20 vdout0_20ck18 = 0 time = 95
* CHECK dout0_0 vdout0_0ck19 = 0.95 time = 100
* CHECK dout0_1 vdout0_1ck19 = 0.95 time = 100
* CHECK dout0_2 vdout0_2ck19 = 0.95 time = 100
* CHECK dout0_3 vdout0_3ck19 = 0.95 time = 100
* CHECK dout0_4 vdout0_4ck19 = 0.95 time = 100
* CHECK dout0_5 vdout0_5ck19 = 0 time = 100
* CHECK dout0_6 vdout0_6ck19 = 0 time = 100
* CHECK dout0_7 vdout0_7ck19 = 0 time = 100
* CHECK dout0_8 vdout0_8ck19 = 0 time = 100
* CHECK dout0_9 vdout0_9ck19 = 0 time = 100
* CHECK dout0_10 vdout0_10ck19 = 0 time = 100
* CHECK dout0_11 vdout0_11ck19 = 0 time = 100
* CHECK dout0_12 vdout0_12ck19 = 0 time = 100
* CHECK dout0_13 vdout0_13ck19 = 0.95 time = 100
* CHECK dout0_14 vdout0_14ck19 = 0 time = 100
* CHECK dout0_15 vdout0_15ck19 = 0.95 time = 100
* CHECK dout0_16 vdout0_16ck19 = 0 time = 100
* CHECK dout0_17 vdout0_17ck19 = 0.95 time = 100
* CHECK dout0_18 vdout0_18ck19 = 0 time = 100
* CHECK dout0_19 vdout0_19ck19 = 0.95 time = 100
* CHECK dout0_20 vdout0_20ck19 = 0 time = 100
* CHECK dout0_0 vdout0_0ck21 = 0.95 time = 110
* CHECK dout0_1 vdout0_1ck21 = 0.95 time = 110
* CHECK dout0_2 vdout0_2ck21 = 0.95 time = 110
* CHECK dout0_3 vdout0_3ck21 = 0.95 time = 110
* CHECK dout0_4 vdout0_4ck21 = 0.95 time = 110
* CHECK dout0_5 vdout0_5ck21 = 0 time = 110
* CHECK dout0_6 vdout0_6ck21 = 0 time = 110
* CHECK dout0_7 vdout0_7ck21 = 0 time = 110
* CHECK dout0_8 vdout0_8ck21 = 0 time = 110
* CHECK dout0_9 vdout0_9ck21 = 0 time = 110
* CHECK dout0_10 vdout0_10ck21 = 0 time = 110
* CHECK dout0_11 vdout0_11ck21 = 0 time = 110
* CHECK dout0_12 vdout0_12ck21 = 0 time = 110
* CHECK dout0_13 vdout0_13ck21 = 0.95 time = 110
* CHECK dout0_14 vdout0_14ck21 = 0 time = 110
* CHECK dout0_15 vdout0_15ck21 = 0.95 time = 110
* CHECK dout0_16 vdout0_16ck21 = 0 time = 110
* CHECK dout0_17 vdout0_17ck21 = 0.95 time = 110
* CHECK dout0_18 vdout0_18ck21 = 0 time = 110
* CHECK dout0_19 vdout0_19ck21 = 0.95 time = 110
* CHECK dout0_20 vdout0_20ck21 = 0 time = 110
* CHECK dout0_0 vdout0_0ck23 = 0.95 time = 120
* CHECK dout0_1 vdout0_1ck23 = 0.95 time = 120
* CHECK dout0_2 vdout0_2ck23 = 0.95 time = 120
* CHECK dout0_3 vdout0_3ck23 = 0.95 time = 120
* CHECK dout0_4 vdout0_4ck23 = 0.95 time = 120
* CHECK dout0_5 vdout0_5ck23 = 0 time = 120
* CHECK dout0_6 vdout0_6ck23 = 0 time = 120
* CHECK dout0_7 vdout0_7ck23 = 0 time = 120
* CHECK dout0_8 vdout0_8ck23 = 0 time = 120
* CHECK dout0_9 vdout0_9ck23 = 0 time = 120
* CHECK dout0_10 vdout0_10ck23 = 0 time = 120
* CHECK dout0_11 vdout0_11ck23 = 0 time = 120
* CHECK dout0_12 vdout0_12ck23 = 0 time = 120
* CHECK dout0_13 vdout0_13ck23 = 0.95 time = 120
* CHECK dout0_14 vdout0_14ck23 = 0 time = 120
* CHECK dout0_15 vdout0_15ck23 = 0.95 time = 120
* CHECK dout0_16 vdout0_16ck23 = 0 time = 120
* CHECK dout0_17 vdout0_17ck23 = 0.95 time = 120
* CHECK dout0_18 vdout0_18ck23 = 0 time = 120
* CHECK dout0_19 vdout0_19ck23 = 0.95 time = 120
* CHECK dout0_20 vdout0_20ck23 = 0 time = 120
* CHECK dout0_0 vdout0_0ck24 = 0.95 time = 125
* CHECK dout0_1 vdout0_1ck24 = 0.95 time = 125
* CHECK dout0_2 vdout0_2ck24 = 0.95 time = 125
* CHECK dout0_3 vdout0_3ck24 = 0.95 time = 125
* CHECK dout0_4 vdout0_4ck24 = 0.95 time = 125
* CHECK dout0_5 vdout0_5ck24 = 0 time = 125
* CHECK dout0_6 vdout0_6ck24 = 0 time = 125
* CHECK dout0_7 vdout0_7ck24 = 0 time = 125
* CHECK dout0_8 vdout0_8ck24 = 0 time = 125
* CHECK dout0_9 vdout0_9ck24 = 0 time = 125
* CHECK dout0_10 vdout0_10ck24 = 0 time = 125
* CHECK dout0_11 vdout0_11ck24 = 0 time = 125
* CHECK dout0_12 vdout0_12ck24 = 0 time = 125
* CHECK dout0_13 vdout0_13ck24 = 0.95 time = 125
* CHECK dout0_14 vdout0_14ck24 = 0 time = 125
* CHECK dout0_15 vdout0_15ck24 = 0.95 time = 125
* CHECK dout0_16 vdout0_16ck24 = 0 time = 125
* CHECK dout0_17 vdout0_17ck24 = 0.95 time = 125
* CHECK dout0_18 vdout0_18ck24 = 0 time = 125
* CHECK dout0_19 vdout0_19ck24 = 0.95 time = 125
* CHECK dout0_20 vdout0_20ck24 = 0 time = 125
* CHECK dout0_0 vdout0_0ck26 = 0.95 time = 135
* CHECK dout0_1 vdout0_1ck26 = 0.95 time = 135
* CHECK dout0_2 vdout0_2ck26 = 0.95 time = 135
* CHECK dout0_3 vdout0_3ck26 = 0.95 time = 135
* CHECK dout0_4 vdout0_4ck26 = 0.95 time = 135
* CHECK dout0_5 vdout0_5ck26 = 0 time = 135
* CHECK dout0_6 vdout0_6ck26 = 0 time = 135
* CHECK dout0_7 vdout0_7ck26 = 0 time = 135
* CHECK dout0_8 vdout0_8ck26 = 0 time = 135
* CHECK dout0_9 vdout0_9ck26 = 0 time = 135
* CHECK dout0_10 vdout0_10ck26 = 0 time = 135
* CHECK dout0_11 vdout0_11ck26 = 0 time = 135
* CHECK dout0_12 vdout0_12ck26 = 0 time = 135
* CHECK dout0_13 vdout0_13ck26 = 0.95 time = 135
* CHECK dout0_14 vdout0_14ck26 = 0 time = 135
* CHECK dout0_15 vdout0_15ck26 = 0.95 time = 135
* CHECK dout0_16 vdout0_16ck26 = 0 time = 135
* CHECK dout0_17 vdout0_17ck26 = 0.95 time = 135
* CHECK dout0_18 vdout0_18ck26 = 0 time = 135
* CHECK dout0_19 vdout0_19ck26 = 0.95 time = 135
* CHECK dout0_20 vdout0_20ck26 = 0 time = 135
* CHECK dout0_0 vdout0_0ck27 = 0.95 time = 140
* CHECK dout0_1 vdout0_1ck27 = 0.95 time = 140
* CHECK dout0_2 vdout0_2ck27 = 0.95 time = 140
* CHECK dout0_3 vdout0_3ck27 = 0.95 time = 140
* CHECK dout0_4 vdout0_4ck27 = 0.95 time = 140
* CHECK dout0_5 vdout0_5ck27 = 0 time = 140
* CHECK dout0_6 vdout0_6ck27 = 0 time = 140
* CHECK dout0_7 vdout0_7ck27 = 0 time = 140
* CHECK dout0_8 vdout0_8ck27 = 0 time = 140
* CHECK dout0_9 vdout0_9ck27 = 0 time = 140
* CHECK dout0_10 vdout0_10ck27 = 0 time = 140
* CHECK dout0_11 vdout0_11ck27 = 0 time = 140
* CHECK dout0_12 vdout0_12ck27 = 0 time = 140
* CHECK dout0_13 vdout0_13ck27 = 0.95 time = 140
* CHECK dout0_14 vdout0_14ck27 = 0 time = 140
* CHECK dout0_15 vdout0_15ck27 = 0.95 time = 140
* CHECK dout0_16 vdout0_16ck27 = 0 time = 140
* CHECK dout0_17 vdout0_17ck27 = 0.95 time = 140
* CHECK dout0_18 vdout0_18ck27 = 0 time = 140
* CHECK dout0_19 vdout0_19ck27 = 0.95 time = 140
* CHECK dout0_20 vdout0_20ck27 = 0 time = 140
* CHECK dout0_0 vdout0_0ck29 = 0.95 time = 150
* CHECK dout0_1 vdout0_1ck29 = 0.95 time = 150
* CHECK dout0_2 vdout0_2ck29 = 0 time = 150
* CHECK dout0_3 vdout0_3ck29 = 0.95 time = 150
* CHECK dout0_4 vdout0_4ck29 = 0.95 time = 150
* CHECK dout0_5 vdout0_5ck29 = 0.95 time = 150
* CHECK dout0_6 vdout0_6ck29 = 0 time = 150
* CHECK dout0_7 vdout0_7ck29 = 0 time = 150
* CHECK dout0_8 vdout0_8ck29 = 0 time = 150
* CHECK dout0_9 vdout0_9ck29 = 0 time = 150
* CHECK dout0_10 vdout0_10ck29 = 0.95 time = 150
* CHECK dout0_11 vdout0_11ck29 = 0 time = 150
* CHECK dout0_12 vdout0_12ck29 = 0 time = 150
* CHECK dout0_13 vdout0_13ck29 = 0 time = 150
* CHECK dout0_14 vdout0_14ck29 = 0 time = 150
* CHECK dout0_15 vdout0_15ck29 = 0 time = 150
* CHECK dout0_16 vdout0_16ck29 = 0.95 time = 150
* CHECK dout0_17 vdout0_17ck29 = 0.95 time = 150
* CHECK dout0_18 vdout0_18ck29 = 0 time = 150
* CHECK dout0_19 vdout0_19ck29 = 0.95 time = 150
* CHECK dout0_20 vdout0_20ck29 = 0.95 time = 150
* CHECK dout0_0 vdout0_0ck30 = 0.95 time = 155
* CHECK dout0_1 vdout0_1ck30 = 0.95 time = 155
* CHECK dout0_2 vdout0_2ck30 = 0 time = 155
* CHECK dout0_3 vdout0_3ck30 = 0.95 time = 155
* CHECK dout0_4 vdout0_4ck30 = 0.95 time = 155
* CHECK dout0_5 vdout0_5ck30 = 0.95 time = 155
* CHECK dout0_6 vdout0_6ck30 = 0 time = 155
* CHECK dout0_7 vdout0_7ck30 = 0 time = 155
* CHECK dout0_8 vdout0_8ck30 = 0 time = 155
* CHECK dout0_9 vdout0_9ck30 = 0 time = 155
* CHECK dout0_10 vdout0_10ck30 = 0.95 time = 155
* CHECK dout0_11 vdout0_11ck30 = 0 time = 155
* CHECK dout0_12 vdout0_12ck30 = 0 time = 155
* CHECK dout0_13 vdout0_13ck30 = 0 time = 155
* CHECK dout0_14 vdout0_14ck30 = 0 time = 155
* CHECK dout0_15 vdout0_15ck30 = 0 time = 155
* CHECK dout0_16 vdout0_16ck30 = 0.95 time = 155
* CHECK dout0_17 vdout0_17ck30 = 0.95 time = 155
* CHECK dout0_18 vdout0_18ck30 = 0 time = 155
* CHECK dout0_19 vdout0_19ck30 = 0.95 time = 155
* CHECK dout0_20 vdout0_20ck30 = 0.95 time = 155
* CHECK dout0_0 vdout0_0ck33 = 0.95 time = 170
* CHECK dout0_1 vdout0_1ck33 = 0.95 time = 170
* CHECK dout0_2 vdout0_2ck33 = 0 time = 170
* CHECK dout0_3 vdout0_3ck33 = 0.95 time = 170
* CHECK dout0_4 vdout0_4ck33 = 0.95 time = 170
* CHECK dout0_5 vdout0_5ck33 = 0.95 time = 170
* CHECK dout0_6 vdout0_6ck33 = 0 time = 170
* CHECK dout0_7 vdout0_7ck33 = 0 time = 170
* CHECK dout0_8 vdout0_8ck33 = 0 time = 170
* CHECK dout0_9 vdout0_9ck33 = 0 time = 170
* CHECK dout0_10 vdout0_10ck33 = 0.95 time = 170
* CHECK dout0_11 vdout0_11ck33 = 0 time = 170
* CHECK dout0_12 vdout0_12ck33 = 0 time = 170
* CHECK dout0_13 vdout0_13ck33 = 0 time = 170
* CHECK dout0_14 vdout0_14ck33 = 0 time = 170
* CHECK dout0_15 vdout0_15ck33 = 0 time = 170
* CHECK dout0_16 vdout0_16ck33 = 0.95 time = 170
* CHECK dout0_17 vdout0_17ck33 = 0.95 time = 170
* CHECK dout0_18 vdout0_18ck33 = 0 time = 170
* CHECK dout0_19 vdout0_19ck33 = 0.95 time = 170
* CHECK dout0_20 vdout0_20ck33 = 0.95 time = 170
* CHECK dout0_0 vdout0_0ck35 = 0.95 time = 180
* CHECK dout0_1 vdout0_1ck35 = 0.95 time = 180
* CHECK dout0_2 vdout0_2ck35 = 0 time = 180
* CHECK dout0_3 vdout0_3ck35 = 0.95 time = 180
* CHECK dout0_4 vdout0_4ck35 = 0.95 time = 180
* CHECK dout0_5 vdout0_5ck35 = 0.95 time = 180
* CHECK dout0_6 vdout0_6ck35 = 0 time = 180
* CHECK dout0_7 vdout0_7ck35 = 0 time = 180
* CHECK dout0_8 vdout0_8ck35 = 0 time = 180
* CHECK dout0_9 vdout0_9ck35 = 0 time = 180
* CHECK dout0_10 vdout0_10ck35 = 0.95 time = 180
* CHECK dout0_11 vdout0_11ck35 = 0 time = 180
* CHECK dout0_12 vdout0_12ck35 = 0 time = 180
* CHECK dout0_13 vdout0_13ck35 = 0 time = 180
* CHECK dout0_14 vdout0_14ck35 = 0 time = 180
* CHECK dout0_15 vdout0_15ck35 = 0 time = 180
* CHECK dout0_16 vdout0_16ck35 = 0.95 time = 180
* CHECK dout0_17 vdout0_17ck35 = 0.95 time = 180
* CHECK dout0_18 vdout0_18ck35 = 0 time = 180
* CHECK dout0_19 vdout0_19ck35 = 0.95 time = 180
* CHECK dout0_20 vdout0_20ck35 = 0.95 time = 180
* CHECK dout0_0 vdout0_0ck36 = 0.95 time = 185
* CHECK dout0_1 vdout0_1ck36 = 0 time = 185
* CHECK dout0_2 vdout0_2ck36 = 0 time = 185
* CHECK dout0_3 vdout0_3ck36 = 0 time = 185
* CHECK dout0_4 vdout0_4ck36 = 0.95 time = 185
* CHECK dout0_5 vdout0_5ck36 = 0.95 time = 185
* CHECK dout0_6 vdout0_6ck36 = 0 time = 185
* CHECK dout0_7 vdout0_7ck36 = 0.95 time = 185
* CHECK dout0_8 vdout0_8ck36 = 0.95 time = 185
* CHECK dout0_9 vdout0_9ck36 = 0 time = 185
* CHECK dout0_10 vdout0_10ck36 = 0 time = 185
* CHECK dout0_11 vdout0_11ck36 = 0.95 time = 185
* CHECK dout0_12 vdout0_12ck36 = 0 time = 185
* CHECK dout0_13 vdout0_13ck36 = 0 time = 185
* CHECK dout0_14 vdout0_14ck36 = 0 time = 185
* CHECK dout0_15 vdout0_15ck36 = 0 time = 185
* CHECK dout0_16 vdout0_16ck36 = 0 time = 185
* CHECK dout0_17 vdout0_17ck36 = 0.95 time = 185
* CHECK dout0_18 vdout0_18ck36 = 0.95 time = 185
* CHECK dout0_19 vdout0_19ck36 = 0 time = 185
* CHECK dout0_20 vdout0_20ck36 = 0 time = 185
* CHECK dout0_0 vdout0_0ck40 = 0.95 time = 205
* CHECK dout0_1 vdout0_1ck40 = 0.95 time = 205
* CHECK dout0_2 vdout0_2ck40 = 0 time = 205
* CHECK dout0_3 vdout0_3ck40 = 0.95 time = 205
* CHECK dout0_4 vdout0_4ck40 = 0.95 time = 205
* CHECK dout0_5 vdout0_5ck40 = 0.95 time = 205
* CHECK dout0_6 vdout0_6ck40 = 0 time = 205
* CHECK dout0_7 vdout0_7ck40 = 0 time = 205
* CHECK dout0_8 vdout0_8ck40 = 0 time = 205
* CHECK dout0_9 vdout0_9ck40 = 0 time = 205
* CHECK dout0_10 vdout0_10ck40 = 0.95 time = 205
* CHECK dout0_11 vdout0_11ck40 = 0 time = 205
* CHECK dout0_12 vdout0_12ck40 = 0 time = 205
* CHECK dout0_13 vdout0_13ck40 = 0 time = 205
* CHECK dout0_14 vdout0_14ck40 = 0 time = 205
* CHECK dout0_15 vdout0_15ck40 = 0 time = 205
* CHECK dout0_16 vdout0_16ck40 = 0.95 time = 205
* CHECK dout0_17 vdout0_17ck40 = 0.95 time = 205
* CHECK dout0_18 vdout0_18ck40 = 0 time = 205
* CHECK dout0_19 vdout0_19ck40 = 0.95 time = 205
* CHECK dout0_20 vdout0_20ck40 = 0.95 time = 205
* CHECK dout0_0 vdout0_0ck41 = 0.95 time = 210
* CHECK dout0_1 vdout0_1ck41 = 0 time = 210
* CHECK dout0_2 vdout0_2ck41 = 0.95 time = 210
* CHECK dout0_3 vdout0_3ck41 = 0.95 time = 210
* CHECK dout0_4 vdout0_4ck41 = 0.95 time = 210
* CHECK dout0_5 vdout0_5ck41 = 0.95 time = 210
* CHECK dout0_6 vdout0_6ck41 = 0 time = 210
* CHECK dout0_7 vdout0_7ck41 = 0.95 time = 210
* CHECK dout0_8 vdout0_8ck41 = 0 time = 210
* CHECK dout0_9 vdout0_9ck41 = 0 time = 210
* CHECK dout0_10 vdout0_10ck41 = 0 time = 210
* CHECK dout0_11 vdout0_11ck41 = 0.95 time = 210
* CHECK dout0_12 vdout0_12ck41 = 0.95 time = 210
* CHECK dout0_13 vdout0_13ck41 = 0 time = 210
* CHECK dout0_14 vdout0_14ck41 = 0.95 time = 210
* CHECK dout0_15 vdout0_15ck41 = 0 time = 210
* CHECK dout0_16 vdout0_16ck41 = 0 time = 210
* CHECK dout0_17 vdout0_17ck41 = 0 time = 210
* CHECK dout0_18 vdout0_18ck41 = 0 time = 210
* CHECK dout0_19 vdout0_19ck41 = 0 time = 210
* CHECK dout0_20 vdout0_20ck41 = 0 time = 210
* CHECK dout0_0 vdout0_0ck42 = 0.95 time = 215
* CHECK dout0_1 vdout0_1ck42 = 0.95 time = 215
* CHECK dout0_2 vdout0_2ck42 = 0 time = 215
* CHECK dout0_3 vdout0_3ck42 = 0.95 time = 215
* CHECK dout0_4 vdout0_4ck42 = 0.95 time = 215
* CHECK dout0_5 vdout0_5ck42 = 0.95 time = 215
* CHECK dout0_6 vdout0_6ck42 = 0 time = 215
* CHECK dout0_7 vdout0_7ck42 = 0 time = 215
* CHECK dout0_8 vdout0_8ck42 = 0 time = 215
* CHECK dout0_9 vdout0_9ck42 = 0 time = 215
* CHECK dout0_10 vdout0_10ck42 = 0.95 time = 215
* CHECK dout0_11 vdout0_11ck42 = 0 time = 215
* CHECK dout0_12 vdout0_12ck42 = 0 time = 215
* CHECK dout0_13 vdout0_13ck42 = 0 time = 215
* CHECK dout0_14 vdout0_14ck42 = 0 time = 215
* CHECK dout0_15 vdout0_15ck42 = 0 time = 215
* CHECK dout0_16 vdout0_16ck42 = 0.95 time = 215
* CHECK dout0_17 vdout0_17ck42 = 0.95 time = 215
* CHECK dout0_18 vdout0_18ck42 = 0 time = 215
* CHECK dout0_19 vdout0_19ck42 = 0.95 time = 215
* CHECK dout0_20 vdout0_20ck42 = 0.95 time = 215
* CHECK dout0_0 vdout0_0ck47 = 0.95 time = 240
* CHECK dout0_1 vdout0_1ck47 = 0.95 time = 240
* CHECK dout0_2 vdout0_2ck47 = 0 time = 240
* CHECK dout0_3 vdout0_3ck47 = 0.95 time = 240
* CHECK dout0_4 vdout0_4ck47 = 0.95 time = 240
* CHECK dout0_5 vdout0_5ck47 = 0.95 time = 240
* CHECK dout0_6 vdout0_6ck47 = 0 time = 240
* CHECK dout0_7 vdout0_7ck47 = 0 time = 240
* CHECK dout0_8 vdout0_8ck47 = 0 time = 240
* CHECK dout0_9 vdout0_9ck47 = 0 time = 240
* CHECK dout0_10 vdout0_10ck47 = 0.95 time = 240
* CHECK dout0_11 vdout0_11ck47 = 0 time = 240
* CHECK dout0_12 vdout0_12ck47 = 0 time = 240
* CHECK dout0_13 vdout0_13ck47 = 0 time = 240
* CHECK dout0_14 vdout0_14ck47 = 0 time = 240
* CHECK dout0_15 vdout0_15ck47 = 0 time = 240
* CHECK dout0_16 vdout0_16ck47 = 0.95 time = 240
* CHECK dout0_17 vdout0_17ck47 = 0.95 time = 240
* CHECK dout0_18 vdout0_18ck47 = 0 time = 240
* CHECK dout0_19 vdout0_19ck47 = 0.95 time = 240
* CHECK dout0_20 vdout0_20ck47 = 0.95 time = 240
* CHECK dout0_0 vdout0_0ck50 = 0 time = 255
* CHECK dout0_1 vdout0_1ck50 = 0.95 time = 255
* CHECK dout0_2 vdout0_2ck50 = 0.95 time = 255
* CHECK dout0_3 vdout0_3ck50 = 0 time = 255
* CHECK dout0_4 vdout0_4ck50 = 0.95 time = 255
* CHECK dout0_5 vdout0_5ck50 = 0.95 time = 255
* CHECK dout0_6 vdout0_6ck50 = 0 time = 255
* CHECK dout0_7 vdout0_7ck50 = 0 time = 255
* CHECK dout0_8 vdout0_8ck50 = 0.95 time = 255
* CHECK dout0_9 vdout0_9ck50 = 0 time = 255
* CHECK dout0_10 vdout0_10ck50 = 0 time = 255
* CHECK dout0_11 vdout0_11ck50 = 0 time = 255
* CHECK dout0_12 vdout0_12ck50 = 0.95 time = 255
* CHECK dout0_13 vdout0_13ck50 = 0 time = 255
* CHECK dout0_14 vdout0_14ck50 = 0 time = 255
* CHECK dout0_15 vdout0_15ck50 = 0.95 time = 255
* CHECK dout0_16 vdout0_16ck50 = 0.95 time = 255
* CHECK dout0_17 vdout0_17ck50 = 0 time = 255
* CHECK dout0_18 vdout0_18ck50 = 0 time = 255
* CHECK dout0_19 vdout0_19ck50 = 0.95 time = 255
* CHECK dout0_20 vdout0_20ck50 = 0 time = 255
* CHECK dout0_0 vdout0_0ck58 = 0 time = 295
* CHECK dout0_1 vdout0_1ck58 = 0 time = 295
* CHECK dout0_2 vdout0_2ck58 = 0.95 time = 295
* CHECK dout0_3 vdout0_3ck58 = 0.95 time = 295
* CHECK dout0_4 vdout0_4ck58 = 0.95 time = 295
* CHECK dout0_5 vdout0_5ck58 = 0 time = 295
* CHECK dout0_6 vdout0_6ck58 = 0 time = 295
* CHECK dout0_7 vdout0_7ck58 = 0.95 time = 295
* CHECK dout0_8 vdout0_8ck58 = 0 time = 295
* CHECK dout0_9 vdout0_9ck58 = 0.95 time = 295
* CHECK dout0_10 vdout0_10ck58 = 0.95 time = 295
* CHECK dout0_11 vdout0_11ck58 = 0 time = 295
* CHECK dout0_12 vdout0_12ck58 = 0 time = 295
* CHECK dout0_13 vdout0_13ck58 = 0.95 time = 295
* CHECK dout0_14 vdout0_14ck58 = 0 time = 295
* CHECK dout0_15 vdout0_15ck58 = 0 time = 295
* CHECK dout0_16 vdout0_16ck58 = 0 time = 295
* CHECK dout0_17 vdout0_17ck58 = 0 time = 295
* CHECK dout0_18 vdout0_18ck58 = 0 time = 295
* CHECK dout0_19 vdout0_19ck58 = 0.95 time = 295
* CHECK dout0_20 vdout0_20ck58 = 0.95 time = 295
* CHECK dout0_0 vdout0_0ck59 = 0 time = 300
* CHECK dout0_1 vdout0_1ck59 = 0 time = 300
* CHECK dout0_2 vdout0_2ck59 = 0.95 time = 300
* CHECK dout0_3 vdout0_3ck59 = 0.95 time = 300
* CHECK dout0_4 vdout0_4ck59 = 0.95 time = 300
* CHECK dout0_5 vdout0_5ck59 = 0 time = 300
* CHECK dout0_6 vdout0_6ck59 = 0 time = 300
* CHECK dout0_7 vdout0_7ck59 = 0.95 time = 300
* CHECK dout0_8 vdout0_8ck59 = 0 time = 300
* CHECK dout0_9 vdout0_9ck59 = 0.95 time = 300
* CHECK dout0_10 vdout0_10ck59 = 0.95 time = 300
* CHECK dout0_11 vdout0_11ck59 = 0 time = 300
* CHECK dout0_12 vdout0_12ck59 = 0 time = 300
* CHECK dout0_13 vdout0_13ck59 = 0.95 time = 300
* CHECK dout0_14 vdout0_14ck59 = 0 time = 300
* CHECK dout0_15 vdout0_15ck59 = 0 time = 300
* CHECK dout0_16 vdout0_16ck59 = 0 time = 300
* CHECK dout0_17 vdout0_17ck59 = 0 time = 300
* CHECK dout0_18 vdout0_18ck59 = 0 time = 300
* CHECK dout0_19 vdout0_19ck59 = 0.95 time = 300
* CHECK dout0_20 vdout0_20ck59 = 0.95 time = 300
* CHECK dout0_0 vdout0_0ck60 = 0 time = 305
* CHECK dout0_1 vdout0_1ck60 = 0.95 time = 305
* CHECK dout0_2 vdout0_2ck60 = 0.95 time = 305
* CHECK dout0_3 vdout0_3ck60 = 0 time = 305
* CHECK dout0_4 vdout0_4ck60 = 0.95 time = 305
* CHECK dout0_5 vdout0_5ck60 = 0.95 time = 305
* CHECK dout0_6 vdout0_6ck60 = 0 time = 305
* CHECK dout0_7 vdout0_7ck60 = 0 time = 305
* CHECK dout0_8 vdout0_8ck60 = 0.95 time = 305
* CHECK dout0_9 vdout0_9ck60 = 0 time = 305
* CHECK dout0_10 vdout0_10ck60 = 0 time = 305
* CHECK dout0_11 vdout0_11ck60 = 0 time = 305
* CHECK dout0_12 vdout0_12ck60 = 0.95 time = 305
* CHECK dout0_13 vdout0_13ck60 = 0 time = 305
* CHECK dout0_14 vdout0_14ck60 = 0 time = 305
* CHECK dout0_15 vdout0_15ck60 = 0.95 time = 305
* CHECK dout0_16 vdout0_16ck60 = 0.95 time = 305
* CHECK dout0_17 vdout0_17ck60 = 0 time = 305
* CHECK dout0_18 vdout0_18ck60 = 0 time = 305
* CHECK dout0_19 vdout0_19ck60 = 0.95 time = 305
* CHECK dout0_20 vdout0_20ck60 = 0 time = 305
* CHECK dout0_0 vdout0_0ck61 = 0 time = 310
* CHECK dout0_1 vdout0_1ck61 = 0 time = 310
* CHECK dout0_2 vdout0_2ck61 = 0.95 time = 310
* CHECK dout0_3 vdout0_3ck61 = 0.95 time = 310
* CHECK dout0_4 vdout0_4ck61 = 0.95 time = 310
* CHECK dout0_5 vdout0_5ck61 = 0 time = 310
* CHECK dout0_6 vdout0_6ck61 = 0 time = 310
* CHECK dout0_7 vdout0_7ck61 = 0.95 time = 310
* CHECK dout0_8 vdout0_8ck61 = 0 time = 310
* CHECK dout0_9 vdout0_9ck61 = 0.95 time = 310
* CHECK dout0_10 vdout0_10ck61 = 0.95 time = 310
* CHECK dout0_11 vdout0_11ck61 = 0 time = 310
* CHECK dout0_12 vdout0_12ck61 = 0 time = 310
* CHECK dout0_13 vdout0_13ck61 = 0.95 time = 310
* CHECK dout0_14 vdout0_14ck61 = 0 time = 310
* CHECK dout0_15 vdout0_15ck61 = 0 time = 310
* CHECK dout0_16 vdout0_16ck61 = 0 time = 310
* CHECK dout0_17 vdout0_17ck61 = 0 time = 310
* CHECK dout0_18 vdout0_18ck61 = 0 time = 310
* CHECK dout0_19 vdout0_19ck61 = 0.95 time = 310
* CHECK dout0_20 vdout0_20ck61 = 0.95 time = 310
* CHECK dout0_0 vdout0_0ck63 = 0 time = 320
* CHECK dout0_1 vdout0_1ck63 = 0.95 time = 320
* CHECK dout0_2 vdout0_2ck63 = 0.95 time = 320
* CHECK dout0_3 vdout0_3ck63 = 0 time = 320
* CHECK dout0_4 vdout0_4ck63 = 0.95 time = 320
* CHECK dout0_5 vdout0_5ck63 = 0.95 time = 320
* CHECK dout0_6 vdout0_6ck63 = 0 time = 320
* CHECK dout0_7 vdout0_7ck63 = 0 time = 320
* CHECK dout0_8 vdout0_8ck63 = 0.95 time = 320
* CHECK dout0_9 vdout0_9ck63 = 0 time = 320
* CHECK dout0_10 vdout0_10ck63 = 0 time = 320
* CHECK dout0_11 vdout0_11ck63 = 0 time = 320
* CHECK dout0_12 vdout0_12ck63 = 0.95 time = 320
* CHECK dout0_13 vdout0_13ck63 = 0 time = 320
* CHECK dout0_14 vdout0_14ck63 = 0 time = 320
* CHECK dout0_15 vdout0_15ck63 = 0.95 time = 320
* CHECK dout0_16 vdout0_16ck63 = 0.95 time = 320
* CHECK dout0_17 vdout0_17ck63 = 0 time = 320
* CHECK dout0_18 vdout0_18ck63 = 0 time = 320
* CHECK dout0_19 vdout0_19ck63 = 0.95 time = 320
* CHECK dout0_20 vdout0_20ck63 = 0 time = 320
* CHECK dout0_0 vdout0_0ck69 = 0 time = 350
* CHECK dout0_1 vdout0_1ck69 = 0.95 time = 350
* CHECK dout0_2 vdout0_2ck69 = 0 time = 350
* CHECK dout0_3 vdout0_3ck69 = 0.95 time = 350
* CHECK dout0_4 vdout0_4ck69 = 0.95 time = 350
* CHECK dout0_5 vdout0_5ck69 = 0.95 time = 350
* CHECK dout0_6 vdout0_6ck69 = 0 time = 350
* CHECK dout0_7 vdout0_7ck69 = 0.95 time = 350
* CHECK dout0_8 vdout0_8ck69 = 0 time = 350
* CHECK dout0_9 vdout0_9ck69 = 0 time = 350
* CHECK dout0_10 vdout0_10ck69 = 0 time = 350
* CHECK dout0_11 vdout0_11ck69 = 0.95 time = 350
* CHECK dout0_12 vdout0_12ck69 = 0.95 time = 350
* CHECK dout0_13 vdout0_13ck69 = 0.95 time = 350
* CHECK dout0_14 vdout0_14ck69 = 0 time = 350
* CHECK dout0_15 vdout0_15ck69 = 0 time = 350
* CHECK dout0_16 vdout0_16ck69 = 0.95 time = 350
* CHECK dout0_17 vdout0_17ck69 = 0 time = 350
* CHECK dout0_18 vdout0_18ck69 = 0 time = 350
* CHECK dout0_19 vdout0_19ck69 = 0.95 time = 350
* CHECK dout0_20 vdout0_20ck69 = 0.95 time = 350
* CHECK dout0_0 vdout0_0ck72 = 0.95 time = 365
* CHECK dout0_1 vdout0_1ck72 = 0.95 time = 365
* CHECK dout0_2 vdout0_2ck72 = 0.95 time = 365
* CHECK dout0_3 vdout0_3ck72 = 0 time = 365
* CHECK dout0_4 vdout0_4ck72 = 0 time = 365
* CHECK dout0_5 vdout0_5ck72 = 0 time = 365
* CHECK dout0_6 vdout0_6ck72 = 0.95 time = 365
* CHECK dout0_7 vdout0_7ck72 = 0 time = 365
* CHECK dout0_8 vdout0_8ck72 = 0 time = 365
* CHECK dout0_9 vdout0_9ck72 = 0 time = 365
* CHECK dout0_10 vdout0_10ck72 = 0.95 time = 365
* CHECK dout0_11 vdout0_11ck72 = 0 time = 365
* CHECK dout0_12 vdout0_12ck72 = 0.95 time = 365
* CHECK dout0_13 vdout0_13ck72 = 0 time = 365
* CHECK dout0_14 vdout0_14ck72 = 0.95 time = 365
* CHECK dout0_15 vdout0_15ck72 = 0.95 time = 365
* CHECK dout0_16 vdout0_16ck72 = 0.95 time = 365
* CHECK dout0_17 vdout0_17ck72 = 0.95 time = 365
* CHECK dout0_18 vdout0_18ck72 = 0 time = 365
* CHECK dout0_19 vdout0_19ck72 = 0.95 time = 365
* CHECK dout0_20 vdout0_20ck72 = 0.95 time = 365
* CHECK dout0_0 vdout0_0ck77 = 0 time = 390
* CHECK dout0_1 vdout0_1ck77 = 0.95 time = 390
* CHECK dout0_2 vdout0_2ck77 = 0.95 time = 390
* CHECK dout0_3 vdout0_3ck77 = 0.95 time = 390
* CHECK dout0_4 vdout0_4ck77 = 0.95 time = 390
* CHECK dout0_5 vdout0_5ck77 = 0 time = 390
* CHECK dout0_6 vdout0_6ck77 = 0 time = 390
* CHECK dout0_7 vdout0_7ck77 = 0 time = 390
* CHECK dout0_8 vdout0_8ck77 = 0 time = 390
* CHECK dout0_9 vdout0_9ck77 = 0 time = 390
* CHECK dout0_10 vdout0_10ck77 = 0.95 time = 390
* CHECK dout0_11 vdout0_11ck77 = 0.95 time = 390
* CHECK dout0_12 vdout0_12ck77 = 0 time = 390
* CHECK dout0_13 vdout0_13ck77 = 0.95 time = 390
* CHECK dout0_14 vdout0_14ck77 = 0 time = 390
* CHECK dout0_15 vdout0_15ck77 = 0 time = 390
* CHECK dout0_16 vdout0_16ck77 = 0.95 time = 390
* CHECK dout0_17 vdout0_17ck77 = 0 time = 390
* CHECK dout0_18 vdout0_18ck77 = 0 time = 390
* CHECK dout0_19 vdout0_19ck77 = 0.95 time = 390
* CHECK dout0_20 vdout0_20ck77 = 0.95 time = 390
* CHECK dout0_0 vdout0_0ck79 = 0.95 time = 400
* CHECK dout0_1 vdout0_1ck79 = 0.95 time = 400
* CHECK dout0_2 vdout0_2ck79 = 0 time = 400
* CHECK dout0_3 vdout0_3ck79 = 0.95 time = 400
* CHECK dout0_4 vdout0_4ck79 = 0.95 time = 400
* CHECK dout0_5 vdout0_5ck79 = 0 time = 400
* CHECK dout0_6 vdout0_6ck79 = 0.95 time = 400
* CHECK dout0_7 vdout0_7ck79 = 0 time = 400
* CHECK dout0_8 vdout0_8ck79 = 0.95 time = 400
* CHECK dout0_9 vdout0_9ck79 = 0.95 time = 400
* CHECK dout0_10 vdout0_10ck79 = 0 time = 400
* CHECK dout0_11 vdout0_11ck79 = 0 time = 400
* CHECK dout0_12 vdout0_12ck79 = 0.95 time = 400
* CHECK dout0_13 vdout0_13ck79 = 0.95 time = 400
* CHECK dout0_14 vdout0_14ck79 = 0 time = 400
* CHECK dout0_15 vdout0_15ck79 = 0 time = 400
* CHECK dout0_16 vdout0_16ck79 = 0.95 time = 400
* CHECK dout0_17 vdout0_17ck79 = 0 time = 400
* CHECK dout0_18 vdout0_18ck79 = 0.95 time = 400
* CHECK dout0_19 vdout0_19ck79 = 0.95 time = 400
* CHECK dout0_20 vdout0_20ck79 = 0 time = 400
* CHECK dout0_0 vdout0_0ck80 = 0 time = 405
* CHECK dout0_1 vdout0_1ck80 = 0.95 time = 405
* CHECK dout0_2 vdout0_2ck80 = 0.95 time = 405
* CHECK dout0_3 vdout0_3ck80 = 0.95 time = 405
* CHECK dout0_4 vdout0_4ck80 = 0.95 time = 405
* CHECK dout0_5 vdout0_5ck80 = 0 time = 405
* CHECK dout0_6 vdout0_6ck80 = 0 time = 405
* CHECK dout0_7 vdout0_7ck80 = 0 time = 405
* CHECK dout0_8 vdout0_8ck80 = 0 time = 405
* CHECK dout0_9 vdout0_9ck80 = 0 time = 405
* CHECK dout0_10 vdout0_10ck80 = 0.95 time = 405
* CHECK dout0_11 vdout0_11ck80 = 0.95 time = 405
* CHECK dout0_12 vdout0_12ck80 = 0 time = 405
* CHECK dout0_13 vdout0_13ck80 = 0.95 time = 405
* CHECK dout0_14 vdout0_14ck80 = 0 time = 405
* CHECK dout0_15 vdout0_15ck80 = 0 time = 405
* CHECK dout0_16 vdout0_16ck80 = 0.95 time = 405
* CHECK dout0_17 vdout0_17ck80 = 0 time = 405
* CHECK dout0_18 vdout0_18ck80 = 0 time = 405
* CHECK dout0_19 vdout0_19ck80 = 0.95 time = 405
* CHECK dout0_20 vdout0_20ck80 = 0.95 time = 405
* CHECK dout0_0 vdout0_0ck84 = 0.95 time = 425
* CHECK dout0_1 vdout0_1ck84 = 0 time = 425
* CHECK dout0_2 vdout0_2ck84 = 0.95 time = 425
* CHECK dout0_3 vdout0_3ck84 = 0 time = 425
* CHECK dout0_4 vdout0_4ck84 = 0.95 time = 425
* CHECK dout0_5 vdout0_5ck84 = 0 time = 425
* CHECK dout0_6 vdout0_6ck84 = 0.95 time = 425
* CHECK dout0_7 vdout0_7ck84 = 0 time = 425
* CHECK dout0_8 vdout0_8ck84 = 0 time = 425
* CHECK dout0_9 vdout0_9ck84 = 0 time = 425
* CHECK dout0_10 vdout0_10ck84 = 0 time = 425
* CHECK dout0_11 vdout0_11ck84 = 0.95 time = 425
* CHECK dout0_12 vdout0_12ck84 = 0 time = 425
* CHECK dout0_13 vdout0_13ck84 = 0.95 time = 425
* CHECK dout0_14 vdout0_14ck84 = 0 time = 425
* CHECK dout0_15 vdout0_15ck84 = 0 time = 425
* CHECK dout0_16 vdout0_16ck84 = 0.95 time = 425
* CHECK dout0_17 vdout0_17ck84 = 0.95 time = 425
* CHECK dout0_18 vdout0_18ck84 = 0 time = 425
* CHECK dout0_19 vdout0_19ck84 = 0 time = 425
* CHECK dout0_20 vdout0_20ck84 = 0.95 time = 425
* CHECK dout0_0 vdout0_0ck85 = 0.95 time = 430
* CHECK dout0_1 vdout0_1ck85 = 0 time = 430
* CHECK dout0_2 vdout0_2ck85 = 0.95 time = 430
* CHECK dout0_3 vdout0_3ck85 = 0 time = 430
* CHECK dout0_4 vdout0_4ck85 = 0 time = 430
* CHECK dout0_5 vdout0_5ck85 = 0.95 time = 430
* CHECK dout0_6 vdout0_6ck85 = 0 time = 430
* CHECK dout0_7 vdout0_7ck85 = 0 time = 430
* CHECK dout0_8 vdout0_8ck85 = 0 time = 430
* CHECK dout0_9 vdout0_9ck85 = 0 time = 430
* CHECK dout0_10 vdout0_10ck85 = 0 time = 430
* CHECK dout0_11 vdout0_11ck85 = 0.95 time = 430
* CHECK dout0_12 vdout0_12ck85 = 0.95 time = 430
* CHECK dout0_13 vdout0_13ck85 = 0.95 time = 430
* CHECK dout0_14 vdout0_14ck85 = 0 time = 430
* CHECK dout0_15 vdout0_15ck85 = 0.95 time = 430
* CHECK dout0_16 vdout0_16ck85 = 0.95 time = 430
* CHECK dout0_17 vdout0_17ck85 = 0 time = 430
* CHECK dout0_18 vdout0_18ck85 = 0.95 time = 430
* CHECK dout0_19 vdout0_19ck85 = 0.95 time = 430
* CHECK dout0_20 vdout0_20ck85 = 0.95 time = 430
* CHECK dout0_0 vdout0_0ck87 = 0.95 time = 440
* CHECK dout0_1 vdout0_1ck87 = 0 time = 440
* CHECK dout0_2 vdout0_2ck87 = 0 time = 440
* CHECK dout0_3 vdout0_3ck87 = 0 time = 440
* CHECK dout0_4 vdout0_4ck87 = 0.95 time = 440
* CHECK dout0_5 vdout0_5ck87 = 0.95 time = 440
* CHECK dout0_6 vdout0_6ck87 = 0 time = 440
* CHECK dout0_7 vdout0_7ck87 = 0 time = 440
* CHECK dout0_8 vdout0_8ck87 = 0 time = 440
* CHECK dout0_9 vdout0_9ck87 = 0.95 time = 440
* CHECK dout0_10 vdout0_10ck87 = 0 time = 440
* CHECK dout0_11 vdout0_11ck87 = 0 time = 440
* CHECK dout0_12 vdout0_12ck87 = 0 time = 440
* CHECK dout0_13 vdout0_13ck87 = 0 time = 440
* CHECK dout0_14 vdout0_14ck87 = 0.95 time = 440
* CHECK dout0_15 vdout0_15ck87 = 0 time = 440
* CHECK dout0_16 vdout0_16ck87 = 0.95 time = 440
* CHECK dout0_17 vdout0_17ck87 = 0.95 time = 440
* CHECK dout0_18 vdout0_18ck87 = 0 time = 440
* CHECK dout0_19 vdout0_19ck87 = 0.95 time = 440
* CHECK dout0_20 vdout0_20ck87 = 0 time = 440
* CHECK dout0_0 vdout0_0ck92 = 0.95 time = 465
* CHECK dout0_1 vdout0_1ck92 = 0 time = 465
* CHECK dout0_2 vdout0_2ck92 = 0.95 time = 465
* CHECK dout0_3 vdout0_3ck92 = 0.95 time = 465
* CHECK dout0_4 vdout0_4ck92 = 0 time = 465
* CHECK dout0_5 vdout0_5ck92 = 0.95 time = 465
* CHECK dout0_6 vdout0_6ck92 = 0.95 time = 465
* CHECK dout0_7 vdout0_7ck92 = 0.95 time = 465
* CHECK dout0_8 vdout0_8ck92 = 0 time = 465
* CHECK dout0_9 vdout0_9ck92 = 0 time = 465
* CHECK dout0_10 vdout0_10ck92 = 0 time = 465
* CHECK dout0_11 vdout0_11ck92 = 0.95 time = 465
* CHECK dout0_12 vdout0_12ck92 = 0 time = 465
* CHECK dout0_13 vdout0_13ck92 = 0 time = 465
* CHECK dout0_14 vdout0_14ck92 = 0 time = 465
* CHECK dout0_15 vdout0_15ck92 = 0.95 time = 465
* CHECK dout0_16 vdout0_16ck92 = 0 time = 465
* CHECK dout0_17 vdout0_17ck92 = 0.95 time = 465
* CHECK dout0_18 vdout0_18ck92 = 0.95 time = 465
* CHECK dout0_19 vdout0_19ck92 = 0 time = 465
* CHECK dout0_20 vdout0_20ck92 = 0.95 time = 465
* CHECK dout0_0 vdout0_0ck93 = 0.95 time = 470
* CHECK dout0_1 vdout0_1ck93 = 0 time = 470
* CHECK dout0_2 vdout0_2ck93 = 0.95 time = 470
* CHECK dout0_3 vdout0_3ck93 = 0.95 time = 470
* CHECK dout0_4 vdout0_4ck93 = 0 time = 470
* CHECK dout0_5 vdout0_5ck93 = 0.95 time = 470
* CHECK dout0_6 vdout0_6ck93 = 0.95 time = 470
* CHECK dout0_7 vdout0_7ck93 = 0.95 time = 470
* CHECK dout0_8 vdout0_8ck93 = 0 time = 470
* CHECK dout0_9 vdout0_9ck93 = 0 time = 470
* CHECK dout0_10 vdout0_10ck93 = 0 time = 470
* CHECK dout0_11 vdout0_11ck93 = 0.95 time = 470
* CHECK dout0_12 vdout0_12ck93 = 0 time = 470
* CHECK dout0_13 vdout0_13ck93 = 0 time = 470
* CHECK dout0_14 vdout0_14ck93 = 0 time = 470
* CHECK dout0_15 vdout0_15ck93 = 0.95 time = 470
* CHECK dout0_16 vdout0_16ck93 = 0 time = 470
* CHECK dout0_17 vdout0_17ck93 = 0.95 time = 470
* CHECK dout0_18 vdout0_18ck93 = 0.95 time = 470
* CHECK dout0_19 vdout0_19ck93 = 0 time = 470
* CHECK dout0_20 vdout0_20ck93 = 0.95 time = 470
* CHECK dout0_0 vdout0_0ck96 = 0 time = 485
* CHECK dout0_1 vdout0_1ck96 = 0.95 time = 485
* CHECK dout0_2 vdout0_2ck96 = 0.95 time = 485
* CHECK dout0_3 vdout0_3ck96 = 0.95 time = 485
* CHECK dout0_4 vdout0_4ck96 = 0.95 time = 485
* CHECK dout0_5 vdout0_5ck96 = 0 time = 485
* CHECK dout0_6 vdout0_6ck96 = 0 time = 485
* CHECK dout0_7 vdout0_7ck96 = 0 time = 485
* CHECK dout0_8 vdout0_8ck96 = 0 time = 485
* CHECK dout0_9 vdout0_9ck96 = 0 time = 485
* CHECK dout0_10 vdout0_10ck96 = 0.95 time = 485
* CHECK dout0_11 vdout0_11ck96 = 0.95 time = 485
* CHECK dout0_12 vdout0_12ck96 = 0 time = 485
* CHECK dout0_13 vdout0_13ck96 = 0.95 time = 485
* CHECK dout0_14 vdout0_14ck96 = 0 time = 485
* CHECK dout0_15 vdout0_15ck96 = 0 time = 485
* CHECK dout0_16 vdout0_16ck96 = 0.95 time = 485
* CHECK dout0_17 vdout0_17ck96 = 0 time = 485
* CHECK dout0_18 vdout0_18ck96 = 0 time = 485
* CHECK dout0_19 vdout0_19ck96 = 0.95 time = 485
* CHECK dout0_20 vdout0_20ck96 = 0.95 time = 485
* CHECK dout0_0 vdout0_0ck99 = 0.95 time = 500
* CHECK dout0_1 vdout0_1ck99 = 0 time = 500
* CHECK dout0_2 vdout0_2ck99 = 0.95 time = 500
* CHECK dout0_3 vdout0_3ck99 = 0.95 time = 500
* CHECK dout0_4 vdout0_4ck99 = 0 time = 500
* CHECK dout0_5 vdout0_5ck99 = 0.95 time = 500
* CHECK dout0_6 vdout0_6ck99 = 0.95 time = 500
* CHECK dout0_7 vdout0_7ck99 = 0.95 time = 500
* CHECK dout0_8 vdout0_8ck99 = 0 time = 500
* CHECK dout0_9 vdout0_9ck99 = 0 time = 500
* CHECK dout0_10 vdout0_10ck99 = 0 time = 500
* CHECK dout0_11 vdout0_11ck99 = 0.95 time = 500
* CHECK dout0_12 vdout0_12ck99 = 0 time = 500
* CHECK dout0_13 vdout0_13ck99 = 0 time = 500
* CHECK dout0_14 vdout0_14ck99 = 0 time = 500
* CHECK dout0_15 vdout0_15ck99 = 0.95 time = 500
* CHECK dout0_16 vdout0_16ck99 = 0 time = 500
* CHECK dout0_17 vdout0_17ck99 = 0.95 time = 500
* CHECK dout0_18 vdout0_18ck99 = 0.95 time = 500
* CHECK dout0_19 vdout0_19ck99 = 0 time = 500
* CHECK dout0_20 vdout0_20ck99 = 0.95 time = 500
* CHECK dout0_0 vdout0_0ck100 = 0.95 time = 505
* CHECK dout0_1 vdout0_1ck100 = 0.95 time = 505
* CHECK dout0_2 vdout0_2ck100 = 0.95 time = 505
* CHECK dout0_3 vdout0_3ck100 = 0 time = 505
* CHECK dout0_4 vdout0_4ck100 = 0.95 time = 505
* CHECK dout0_5 vdout0_5ck100 = 0 time = 505
* CHECK dout0_6 vdout0_6ck100 = 0 time = 505
* CHECK dout0_7 vdout0_7ck100 = 0.95 time = 505
* CHECK dout0_8 vdout0_8ck100 = 0 time = 505
* CHECK dout0_9 vdout0_9ck100 = 0 time = 505
* CHECK dout0_10 vdout0_10ck100 = 0 time = 505
* CHECK dout0_11 vdout0_11ck100 = 0.95 time = 505
* CHECK dout0_12 vdout0_12ck100 = 0.95 time = 505
* CHECK dout0_13 vdout0_13ck100 = 0 time = 505
* CHECK dout0_14 vdout0_14ck100 = 0 time = 505
* CHECK dout0_15 vdout0_15ck100 = 0 time = 505
* CHECK dout0_16 vdout0_16ck100 = 0 time = 505
* CHECK dout0_17 vdout0_17ck100 = 0.95 time = 505
* CHECK dout0_18 vdout0_18ck100 = 0.95 time = 505
* CHECK dout0_19 vdout0_19ck100 = 0.95 time = 505
* CHECK dout0_20 vdout0_20ck100 = 0.95 time = 505
* CHECK dout0_0 vdout0_0ck101 = 0.95 time = 510
* CHECK dout0_1 vdout0_1ck101 = 0 time = 510
* CHECK dout0_2 vdout0_2ck101 = 0.95 time = 510
* CHECK dout0_3 vdout0_3ck101 = 0.95 time = 510
* CHECK dout0_4 vdout0_4ck101 = 0 time = 510
* CHECK dout0_5 vdout0_5ck101 = 0.95 time = 510
* CHECK dout0_6 vdout0_6ck101 = 0.95 time = 510
* CHECK dout0_7 vdout0_7ck101 = 0.95 time = 510
* CHECK dout0_8 vdout0_8ck101 = 0 time = 510
* CHECK dout0_9 vdout0_9ck101 = 0.95 time = 510
* CHECK dout0_10 vdout0_10ck101 = 0 time = 510
* CHECK dout0_11 vdout0_11ck101 = 0.95 time = 510
* CHECK dout0_12 vdout0_12ck101 = 0 time = 510
* CHECK dout0_13 vdout0_13ck101 = 0.95 time = 510
* CHECK dout0_14 vdout0_14ck101 = 0 time = 510
* CHECK dout0_15 vdout0_15ck101 = 0.95 time = 510
* CHECK dout0_16 vdout0_16ck101 = 0 time = 510
* CHECK dout0_17 vdout0_17ck101 = 0 time = 510
* CHECK dout0_18 vdout0_18ck101 = 0.95 time = 510
* CHECK dout0_19 vdout0_19ck101 = 0.95 time = 510
* CHECK dout0_20 vdout0_20ck101 = 0 time = 510
* CHECK dout0_0 vdout0_0ck103 = 0.95 time = 520
* CHECK dout0_1 vdout0_1ck103 = 0.95 time = 520
* CHECK dout0_2 vdout0_2ck103 = 0.95 time = 520
* CHECK dout0_3 vdout0_3ck103 = 0 time = 520
* CHECK dout0_4 vdout0_4ck103 = 0.95 time = 520
* CHECK dout0_5 vdout0_5ck103 = 0 time = 520
* CHECK dout0_6 vdout0_6ck103 = 0 time = 520
* CHECK dout0_7 vdout0_7ck103 = 0.95 time = 520
* CHECK dout0_8 vdout0_8ck103 = 0 time = 520
* CHECK dout0_9 vdout0_9ck103 = 0 time = 520
* CHECK dout0_10 vdout0_10ck103 = 0 time = 520
* CHECK dout0_11 vdout0_11ck103 = 0.95 time = 520
* CHECK dout0_12 vdout0_12ck103 = 0.95 time = 520
* CHECK dout0_13 vdout0_13ck103 = 0 time = 520
* CHECK dout0_14 vdout0_14ck103 = 0 time = 520
* CHECK dout0_15 vdout0_15ck103 = 0 time = 520
* CHECK dout0_16 vdout0_16ck103 = 0 time = 520
* CHECK dout0_17 vdout0_17ck103 = 0.95 time = 520
* CHECK dout0_18 vdout0_18ck103 = 0.95 time = 520
* CHECK dout0_19 vdout0_19ck103 = 0.95 time = 520
* CHECK dout0_20 vdout0_20ck103 = 0.95 time = 520
* CHECK dout0_0 vdout0_0ck105 = 0.95 time = 530
* CHECK dout0_1 vdout0_1ck105 = 0.95 time = 530
* CHECK dout0_2 vdout0_2ck105 = 0.95 time = 530
* CHECK dout0_3 vdout0_3ck105 = 0 time = 530
* CHECK dout0_4 vdout0_4ck105 = 0.95 time = 530
* CHECK dout0_5 vdout0_5ck105 = 0 time = 530
* CHECK dout0_6 vdout0_6ck105 = 0 time = 530
* CHECK dout0_7 vdout0_7ck105 = 0.95 time = 530
* CHECK dout0_8 vdout0_8ck105 = 0 time = 530
* CHECK dout0_9 vdout0_9ck105 = 0 time = 530
* CHECK dout0_10 vdout0_10ck105 = 0 time = 530
* CHECK dout0_11 vdout0_11ck105 = 0.95 time = 530
* CHECK dout0_12 vdout0_12ck105 = 0.95 time = 530
* CHECK dout0_13 vdout0_13ck105 = 0 time = 530
* CHECK dout0_14 vdout0_14ck105 = 0 time = 530
* CHECK dout0_15 vdout0_15ck105 = 0 time = 530
* CHECK dout0_16 vdout0_16ck105 = 0 time = 530
* CHECK dout0_17 vdout0_17ck105 = 0.95 time = 530
* CHECK dout0_18 vdout0_18ck105 = 0.95 time = 530
* CHECK dout0_19 vdout0_19ck105 = 0.95 time = 530
* CHECK dout0_20 vdout0_20ck105 = 0.95 time = 530
* CHECK dout0_0 vdout0_0ck106 = 0.95 time = 535
* CHECK dout0_1 vdout0_1ck106 = 0 time = 535
* CHECK dout0_2 vdout0_2ck106 = 0.95 time = 535
* CHECK dout0_3 vdout0_3ck106 = 0.95 time = 535
* CHECK dout0_4 vdout0_4ck106 = 0 time = 535
* CHECK dout0_5 vdout0_5ck106 = 0.95 time = 535
* CHECK dout0_6 vdout0_6ck106 = 0.95 time = 535
* CHECK dout0_7 vdout0_7ck106 = 0.95 time = 535
* CHECK dout0_8 vdout0_8ck106 = 0 time = 535
* CHECK dout0_9 vdout0_9ck106 = 0 time = 535
* CHECK dout0_10 vdout0_10ck106 = 0 time = 535
* CHECK dout0_11 vdout0_11ck106 = 0.95 time = 535
* CHECK dout0_12 vdout0_12ck106 = 0 time = 535
* CHECK dout0_13 vdout0_13ck106 = 0 time = 535
* CHECK dout0_14 vdout0_14ck106 = 0 time = 535
* CHECK dout0_15 vdout0_15ck106 = 0.95 time = 535
* CHECK dout0_16 vdout0_16ck106 = 0 time = 535
* CHECK dout0_17 vdout0_17ck106 = 0.95 time = 535
* CHECK dout0_18 vdout0_18ck106 = 0.95 time = 535
* CHECK dout0_19 vdout0_19ck106 = 0 time = 535
* CHECK dout0_20 vdout0_20ck106 = 0.95 time = 535
* CHECK dout0_0 vdout0_0ck107 = 0.95 time = 540
* CHECK dout0_1 vdout0_1ck107 = 0 time = 540
* CHECK dout0_2 vdout0_2ck107 = 0.95 time = 540
* CHECK dout0_3 vdout0_3ck107 = 0.95 time = 540
* CHECK dout0_4 vdout0_4ck107 = 0 time = 540
* CHECK dout0_5 vdout0_5ck107 = 0.95 time = 540
* CHECK dout0_6 vdout0_6ck107 = 0.95 time = 540
* CHECK dout0_7 vdout0_7ck107 = 0.95 time = 540
* CHECK dout0_8 vdout0_8ck107 = 0 time = 540
* CHECK dout0_9 vdout0_9ck107 = 0 time = 540
* CHECK dout0_10 vdout0_10ck107 = 0 time = 540
* CHECK dout0_11 vdout0_11ck107 = 0.95 time = 540
* CHECK dout0_12 vdout0_12ck107 = 0 time = 540
* CHECK dout0_13 vdout0_13ck107 = 0 time = 540
* CHECK dout0_14 vdout0_14ck107 = 0 time = 540
* CHECK dout0_15 vdout0_15ck107 = 0.95 time = 540
* CHECK dout0_16 vdout0_16ck107 = 0 time = 540
* CHECK dout0_17 vdout0_17ck107 = 0.95 time = 540
* CHECK dout0_18 vdout0_18ck107 = 0.95 time = 540
* CHECK dout0_19 vdout0_19ck107 = 0 time = 540
* CHECK dout0_20 vdout0_20ck107 = 0.95 time = 540
* CHECK dout0_0 vdout0_0ck108 = 0 time = 545
* CHECK dout0_1 vdout0_1ck108 = 0.95 time = 545
* CHECK dout0_2 vdout0_2ck108 = 0.95 time = 545
* CHECK dout0_3 vdout0_3ck108 = 0.95 time = 545
* CHECK dout0_4 vdout0_4ck108 = 0.95 time = 545
* CHECK dout0_5 vdout0_5ck108 = 0 time = 545
* CHECK dout0_6 vdout0_6ck108 = 0 time = 545
* CHECK dout0_7 vdout0_7ck108 = 0 time = 545
* CHECK dout0_8 vdout0_8ck108 = 0 time = 545
* CHECK dout0_9 vdout0_9ck108 = 0 time = 545
* CHECK dout0_10 vdout0_10ck108 = 0.95 time = 545
* CHECK dout0_11 vdout0_11ck108 = 0.95 time = 545
* CHECK dout0_12 vdout0_12ck108 = 0 time = 545
* CHECK dout0_13 vdout0_13ck108 = 0.95 time = 545
* CHECK dout0_14 vdout0_14ck108 = 0 time = 545
* CHECK dout0_15 vdout0_15ck108 = 0 time = 545
* CHECK dout0_16 vdout0_16ck108 = 0.95 time = 545
* CHECK dout0_17 vdout0_17ck108 = 0 time = 545
* CHECK dout0_18 vdout0_18ck108 = 0 time = 545
* CHECK dout0_19 vdout0_19ck108 = 0.95 time = 545
* CHECK dout0_20 vdout0_20ck108 = 0.95 time = 545
* CHECK dout0_0 vdout0_0ck109 = 0.95 time = 550
* CHECK dout0_1 vdout0_1ck109 = 0 time = 550
* CHECK dout0_2 vdout0_2ck109 = 0.95 time = 550
* CHECK dout0_3 vdout0_3ck109 = 0.95 time = 550
* CHECK dout0_4 vdout0_4ck109 = 0 time = 550
* CHECK dout0_5 vdout0_5ck109 = 0.95 time = 550
* CHECK dout0_6 vdout0_6ck109 = 0.95 time = 550
* CHECK dout0_7 vdout0_7ck109 = 0.95 time = 550
* CHECK dout0_8 vdout0_8ck109 = 0 time = 550
* CHECK dout0_9 vdout0_9ck109 = 0 time = 550
* CHECK dout0_10 vdout0_10ck109 = 0 time = 550
* CHECK dout0_11 vdout0_11ck109 = 0.95 time = 550
* CHECK dout0_12 vdout0_12ck109 = 0 time = 550
* CHECK dout0_13 vdout0_13ck109 = 0 time = 550
* CHECK dout0_14 vdout0_14ck109 = 0 time = 550
* CHECK dout0_15 vdout0_15ck109 = 0.95 time = 550
* CHECK dout0_16 vdout0_16ck109 = 0 time = 550
* CHECK dout0_17 vdout0_17ck109 = 0.95 time = 550
* CHECK dout0_18 vdout0_18ck109 = 0.95 time = 550
* CHECK dout0_19 vdout0_19ck109 = 0 time = 550
* CHECK dout0_20 vdout0_20ck109 = 0.95 time = 550
* CHECK dout0_0 vdout0_0ck111 = 0 time = 560
* CHECK dout0_1 vdout0_1ck111 = 0.95 time = 560
* CHECK dout0_2 vdout0_2ck111 = 0.95 time = 560
* CHECK dout0_3 vdout0_3ck111 = 0.95 time = 560
* CHECK dout0_4 vdout0_4ck111 = 0.95 time = 560
* CHECK dout0_5 vdout0_5ck111 = 0 time = 560
* CHECK dout0_6 vdout0_6ck111 = 0 time = 560
* CHECK dout0_7 vdout0_7ck111 = 0 time = 560
* CHECK dout0_8 vdout0_8ck111 = 0 time = 560
* CHECK dout0_9 vdout0_9ck111 = 0 time = 560
* CHECK dout0_10 vdout0_10ck111 = 0.95 time = 560
* CHECK dout0_11 vdout0_11ck111 = 0.95 time = 560
* CHECK dout0_12 vdout0_12ck111 = 0 time = 560
* CHECK dout0_13 vdout0_13ck111 = 0.95 time = 560
* CHECK dout0_14 vdout0_14ck111 = 0 time = 560
* CHECK dout0_15 vdout0_15ck111 = 0 time = 560
* CHECK dout0_16 vdout0_16ck111 = 0.95 time = 560
* CHECK dout0_17 vdout0_17ck111 = 0 time = 560
* CHECK dout0_18 vdout0_18ck111 = 0 time = 560
* CHECK dout0_19 vdout0_19ck111 = 0.95 time = 560
* CHECK dout0_20 vdout0_20ck111 = 0.95 time = 560
* CHECK dout0_0 vdout0_0ck113 = 0.95 time = 570
* CHECK dout0_1 vdout0_1ck113 = 0 time = 570
* CHECK dout0_2 vdout0_2ck113 = 0.95 time = 570
* CHECK dout0_3 vdout0_3ck113 = 0.95 time = 570
* CHECK dout0_4 vdout0_4ck113 = 0 time = 570
* CHECK dout0_5 vdout0_5ck113 = 0.95 time = 570
* CHECK dout0_6 vdout0_6ck113 = 0.95 time = 570
* CHECK dout0_7 vdout0_7ck113 = 0.95 time = 570
* CHECK dout0_8 vdout0_8ck113 = 0 time = 570
* CHECK dout0_9 vdout0_9ck113 = 0.95 time = 570
* CHECK dout0_10 vdout0_10ck113 = 0 time = 570
* CHECK dout0_11 vdout0_11ck113 = 0.95 time = 570
* CHECK dout0_12 vdout0_12ck113 = 0 time = 570
* CHECK dout0_13 vdout0_13ck113 = 0.95 time = 570
* CHECK dout0_14 vdout0_14ck113 = 0 time = 570
* CHECK dout0_15 vdout0_15ck113 = 0.95 time = 570
* CHECK dout0_16 vdout0_16ck113 = 0 time = 570
* CHECK dout0_17 vdout0_17ck113 = 0 time = 570
* CHECK dout0_18 vdout0_18ck113 = 0.95 time = 570
* CHECK dout0_19 vdout0_19ck113 = 0.95 time = 570
* CHECK dout0_20 vdout0_20ck113 = 0 time = 570
* CHECK dout0_0 vdout0_0ck117 = 0 time = 590
* CHECK dout0_1 vdout0_1ck117 = 0.95 time = 590
* CHECK dout0_2 vdout0_2ck117 = 0.95 time = 590
* CHECK dout0_3 vdout0_3ck117 = 0.95 time = 590
* CHECK dout0_4 vdout0_4ck117 = 0.95 time = 590
* CHECK dout0_5 vdout0_5ck117 = 0 time = 590
* CHECK dout0_6 vdout0_6ck117 = 0 time = 590
* CHECK dout0_7 vdout0_7ck117 = 0 time = 590
* CHECK dout0_8 vdout0_8ck117 = 0 time = 590
* CHECK dout0_9 vdout0_9ck117 = 0 time = 590
* CHECK dout0_10 vdout0_10ck117 = 0.95 time = 590
* CHECK dout0_11 vdout0_11ck117 = 0.95 time = 590
* CHECK dout0_12 vdout0_12ck117 = 0 time = 590
* CHECK dout0_13 vdout0_13ck117 = 0.95 time = 590
* CHECK dout0_14 vdout0_14ck117 = 0 time = 590
* CHECK dout0_15 vdout0_15ck117 = 0 time = 590
* CHECK dout0_16 vdout0_16ck117 = 0.95 time = 590
* CHECK dout0_17 vdout0_17ck117 = 0 time = 590
* CHECK dout0_18 vdout0_18ck117 = 0 time = 590
* CHECK dout0_19 vdout0_19ck117 = 0.95 time = 590
* CHECK dout0_20 vdout0_20ck117 = 0.95 time = 590
* CHECK dout0_0 vdout0_0ck121 = 0.95 time = 610
* CHECK dout0_1 vdout0_1ck121 = 0.95 time = 610
* CHECK dout0_2 vdout0_2ck121 = 0.95 time = 610
* CHECK dout0_3 vdout0_3ck121 = 0.95 time = 610
* CHECK dout0_4 vdout0_4ck121 = 0.95 time = 610
* CHECK dout0_5 vdout0_5ck121 = 0 time = 610
* CHECK dout0_6 vdout0_6ck121 = 0.95 time = 610
* CHECK dout0_7 vdout0_7ck121 = 0 time = 610
* CHECK dout0_8 vdout0_8ck121 = 0 time = 610
* CHECK dout0_9 vdout0_9ck121 = 0 time = 610
* CHECK dout0_10 vdout0_10ck121 = 0 time = 610
* CHECK dout0_11 vdout0_11ck121 = 0 time = 610
* CHECK dout0_12 vdout0_12ck121 = 0 time = 610
* CHECK dout0_13 vdout0_13ck121 = 0 time = 610
* CHECK dout0_14 vdout0_14ck121 = 0.95 time = 610
* CHECK dout0_15 vdout0_15ck121 = 0.95 time = 610
* CHECK dout0_16 vdout0_16ck121 = 0.95 time = 610
* CHECK dout0_17 vdout0_17ck121 = 0 time = 610
* CHECK dout0_18 vdout0_18ck121 = 0.95 time = 610
* CHECK dout0_19 vdout0_19ck121 = 0.95 time = 610
* CHECK dout0_20 vdout0_20ck121 = 0.95 time = 610
* CHECK dout0_0 vdout0_0ck125 = 0 time = 630
* CHECK dout0_1 vdout0_1ck125 = 0 time = 630
* CHECK dout0_2 vdout0_2ck125 = 0.95 time = 630
* CHECK dout0_3 vdout0_3ck125 = 0.95 time = 630
* CHECK dout0_4 vdout0_4ck125 = 0.95 time = 630
* CHECK dout0_5 vdout0_5ck125 = 0.95 time = 630
* CHECK dout0_6 vdout0_6ck125 = 0 time = 630
* CHECK dout0_7 vdout0_7ck125 = 0.95 time = 630
* CHECK dout0_8 vdout0_8ck125 = 0.95 time = 630
* CHECK dout0_9 vdout0_9ck125 = 0 time = 630
* CHECK dout0_10 vdout0_10ck125 = 0.95 time = 630
* CHECK dout0_11 vdout0_11ck125 = 0.95 time = 630
* CHECK dout0_12 vdout0_12ck125 = 0 time = 630
* CHECK dout0_13 vdout0_13ck125 = 0.95 time = 630
* CHECK dout0_14 vdout0_14ck125 = 0 time = 630
* CHECK dout0_15 vdout0_15ck125 = 0.95 time = 630
* CHECK dout0_16 vdout0_16ck125 = 0.95 time = 630
* CHECK dout0_17 vdout0_17ck125 = 0.95 time = 630
* CHECK dout0_18 vdout0_18ck125 = 0.95 time = 630
* CHECK dout0_19 vdout0_19ck125 = 0.95 time = 630
* CHECK dout0_20 vdout0_20ck125 = 0 time = 630
* CHECK dout0_0 vdout0_0ck126 = 0 time = 635
* CHECK dout0_1 vdout0_1ck126 = 0.95 time = 635
* CHECK dout0_2 vdout0_2ck126 = 0.95 time = 635
* CHECK dout0_3 vdout0_3ck126 = 0.95 time = 635
* CHECK dout0_4 vdout0_4ck126 = 0.95 time = 635
* CHECK dout0_5 vdout0_5ck126 = 0 time = 635
* CHECK dout0_6 vdout0_6ck126 = 0 time = 635
* CHECK dout0_7 vdout0_7ck126 = 0 time = 635
* CHECK dout0_8 vdout0_8ck126 = 0 time = 635
* CHECK dout0_9 vdout0_9ck126 = 0 time = 635
* CHECK dout0_10 vdout0_10ck126 = 0.95 time = 635
* CHECK dout0_11 vdout0_11ck126 = 0.95 time = 635
* CHECK dout0_12 vdout0_12ck126 = 0 time = 635
* CHECK dout0_13 vdout0_13ck126 = 0.95 time = 635
* CHECK dout0_14 vdout0_14ck126 = 0 time = 635
* CHECK dout0_15 vdout0_15ck126 = 0 time = 635
* CHECK dout0_16 vdout0_16ck126 = 0.95 time = 635
* CHECK dout0_17 vdout0_17ck126 = 0 time = 635
* CHECK dout0_18 vdout0_18ck126 = 0 time = 635
* CHECK dout0_19 vdout0_19ck126 = 0.95 time = 635
* CHECK dout0_20 vdout0_20ck126 = 0.95 time = 635
* CHECK dout0_0 vdout0_0ck127 = 0 time = 640
* CHECK dout0_1 vdout0_1ck127 = 0 time = 640
* CHECK dout0_2 vdout0_2ck127 = 0 time = 640
* CHECK dout0_3 vdout0_3ck127 = 0 time = 640
* CHECK dout0_4 vdout0_4ck127 = 0.95 time = 640
* CHECK dout0_5 vdout0_5ck127 = 0.95 time = 640
* CHECK dout0_6 vdout0_6ck127 = 0.95 time = 640
* CHECK dout0_7 vdout0_7ck127 = 0 time = 640
* CHECK dout0_8 vdout0_8ck127 = 0.95 time = 640
* CHECK dout0_9 vdout0_9ck127 = 0.95 time = 640
* CHECK dout0_10 vdout0_10ck127 = 0.95 time = 640
* CHECK dout0_11 vdout0_11ck127 = 0 time = 640
* CHECK dout0_12 vdout0_12ck127 = 0 time = 640
* CHECK dout0_13 vdout0_13ck127 = 0.95 time = 640
* CHECK dout0_14 vdout0_14ck127 = 0 time = 640
* CHECK dout0_15 vdout0_15ck127 = 0.95 time = 640
* CHECK dout0_16 vdout0_16ck127 = 0.95 time = 640
* CHECK dout0_17 vdout0_17ck127 = 0 time = 640
* CHECK dout0_18 vdout0_18ck127 = 0 time = 640
* CHECK dout0_19 vdout0_19ck127 = 0.95 time = 640
* CHECK dout0_20 vdout0_20ck127 = 0.95 time = 640
* CHECK dout0_0 vdout0_0ck128 = 0 time = 645
* CHECK dout0_1 vdout0_1ck128 = 0.95 time = 645
* CHECK dout0_2 vdout0_2ck128 = 0.95 time = 645
* CHECK dout0_3 vdout0_3ck128 = 0.95 time = 645
* CHECK dout0_4 vdout0_4ck128 = 0.95 time = 645
* CHECK dout0_5 vdout0_5ck128 = 0 time = 645
* CHECK dout0_6 vdout0_6ck128 = 0 time = 645
* CHECK dout0_7 vdout0_7ck128 = 0 time = 645
* CHECK dout0_8 vdout0_8ck128 = 0 time = 645
* CHECK dout0_9 vdout0_9ck128 = 0 time = 645
* CHECK dout0_10 vdout0_10ck128 = 0.95 time = 645
* CHECK dout0_11 vdout0_11ck128 = 0.95 time = 645
* CHECK dout0_12 vdout0_12ck128 = 0 time = 645
* CHECK dout0_13 vdout0_13ck128 = 0.95 time = 645
* CHECK dout0_14 vdout0_14ck128 = 0 time = 645
* CHECK dout0_15 vdout0_15ck128 = 0 time = 645
* CHECK dout0_16 vdout0_16ck128 = 0.95 time = 645
* CHECK dout0_17 vdout0_17ck128 = 0 time = 645
* CHECK dout0_18 vdout0_18ck128 = 0 time = 645
* CHECK dout0_19 vdout0_19ck128 = 0.95 time = 645
* CHECK dout0_20 vdout0_20ck128 = 0.95 time = 645
* CHECK dout0_0 vdout0_0ck129 = 0 time = 650
* CHECK dout0_1 vdout0_1ck129 = 0 time = 650
* CHECK dout0_2 vdout0_2ck129 = 0.95 time = 650
* CHECK dout0_3 vdout0_3ck129 = 0.95 time = 650
* CHECK dout0_4 vdout0_4ck129 = 0.95 time = 650
* CHECK dout0_5 vdout0_5ck129 = 0.95 time = 650
* CHECK dout0_6 vdout0_6ck129 = 0 time = 650
* CHECK dout0_7 vdout0_7ck129 = 0.95 time = 650
* CHECK dout0_8 vdout0_8ck129 = 0.95 time = 650
* CHECK dout0_9 vdout0_9ck129 = 0 time = 650
* CHECK dout0_10 vdout0_10ck129 = 0.95 time = 650
* CHECK dout0_11 vdout0_11ck129 = 0.95 time = 650
* CHECK dout0_12 vdout0_12ck129 = 0 time = 650
* CHECK dout0_13 vdout0_13ck129 = 0.95 time = 650
* CHECK dout0_14 vdout0_14ck129 = 0 time = 650
* CHECK dout0_15 vdout0_15ck129 = 0.95 time = 650
* CHECK dout0_16 vdout0_16ck129 = 0.95 time = 650
* CHECK dout0_17 vdout0_17ck129 = 0.95 time = 650
* CHECK dout0_18 vdout0_18ck129 = 0.95 time = 650
* CHECK dout0_19 vdout0_19ck129 = 0.95 time = 650
* CHECK dout0_20 vdout0_20ck129 = 0 time = 650
* CHECK dout0_0 vdout0_0ck130 = 0 time = 655
* CHECK dout0_1 vdout0_1ck130 = 0 time = 655
* CHECK dout0_2 vdout0_2ck130 = 0.95 time = 655
* CHECK dout0_3 vdout0_3ck130 = 0 time = 655
* CHECK dout0_4 vdout0_4ck130 = 0.95 time = 655
* CHECK dout0_5 vdout0_5ck130 = 0 time = 655
* CHECK dout0_6 vdout0_6ck130 = 0 time = 655
* CHECK dout0_7 vdout0_7ck130 = 0 time = 655
* CHECK dout0_8 vdout0_8ck130 = 0.95 time = 655
* CHECK dout0_9 vdout0_9ck130 = 0.95 time = 655
* CHECK dout0_10 vdout0_10ck130 = 0.95 time = 655
* CHECK dout0_11 vdout0_11ck130 = 0 time = 655
* CHECK dout0_12 vdout0_12ck130 = 0.95 time = 655
* CHECK dout0_13 vdout0_13ck130 = 0.95 time = 655
* CHECK dout0_14 vdout0_14ck130 = 0.95 time = 655
* CHECK dout0_15 vdout0_15ck130 = 0 time = 655
* CHECK dout0_16 vdout0_16ck130 = 0.95 time = 655
* CHECK dout0_17 vdout0_17ck130 = 0 time = 655
* CHECK dout0_18 vdout0_18ck130 = 0 time = 655
* CHECK dout0_19 vdout0_19ck130 = 0 time = 655
* CHECK dout0_20 vdout0_20ck130 = 0.95 time = 655
* CHECK dout0_0 vdout0_0ck131 = 0 time = 660
* CHECK dout0_1 vdout0_1ck131 = 0.95 time = 660
* CHECK dout0_2 vdout0_2ck131 = 0.95 time = 660
* CHECK dout0_3 vdout0_3ck131 = 0.95 time = 660
* CHECK dout0_4 vdout0_4ck131 = 0.95 time = 660
* CHECK dout0_5 vdout0_5ck131 = 0 time = 660
* CHECK dout0_6 vdout0_6ck131 = 0 time = 660
* CHECK dout0_7 vdout0_7ck131 = 0 time = 660
* CHECK dout0_8 vdout0_8ck131 = 0 time = 660
* CHECK dout0_9 vdout0_9ck131 = 0 time = 660
* CHECK dout0_10 vdout0_10ck131 = 0.95 time = 660
* CHECK dout0_11 vdout0_11ck131 = 0.95 time = 660
* CHECK dout0_12 vdout0_12ck131 = 0 time = 660
* CHECK dout0_13 vdout0_13ck131 = 0.95 time = 660
* CHECK dout0_14 vdout0_14ck131 = 0 time = 660
* CHECK dout0_15 vdout0_15ck131 = 0 time = 660
* CHECK dout0_16 vdout0_16ck131 = 0.95 time = 660
* CHECK dout0_17 vdout0_17ck131 = 0 time = 660
* CHECK dout0_18 vdout0_18ck131 = 0 time = 660
* CHECK dout0_19 vdout0_19ck131 = 0.95 time = 660
* CHECK dout0_20 vdout0_20ck131 = 0.95 time = 660
* CHECK dout0_0 vdout0_0ck134 = 0 time = 675
* CHECK dout0_1 vdout0_1ck134 = 0 time = 675
* CHECK dout0_2 vdout0_2ck134 = 0.95 time = 675
* CHECK dout0_3 vdout0_3ck134 = 0.95 time = 675
* CHECK dout0_4 vdout0_4ck134 = 0.95 time = 675
* CHECK dout0_5 vdout0_5ck134 = 0.95 time = 675
* CHECK dout0_6 vdout0_6ck134 = 0 time = 675
* CHECK dout0_7 vdout0_7ck134 = 0.95 time = 675
* CHECK dout0_8 vdout0_8ck134 = 0.95 time = 675
* CHECK dout0_9 vdout0_9ck134 = 0 time = 675
* CHECK dout0_10 vdout0_10ck134 = 0.95 time = 675
* CHECK dout0_11 vdout0_11ck134 = 0.95 time = 675
* CHECK dout0_12 vdout0_12ck134 = 0 time = 675
* CHECK dout0_13 vdout0_13ck134 = 0.95 time = 675
* CHECK dout0_14 vdout0_14ck134 = 0 time = 675
* CHECK dout0_15 vdout0_15ck134 = 0.95 time = 675
* CHECK dout0_16 vdout0_16ck134 = 0.95 time = 675
* CHECK dout0_17 vdout0_17ck134 = 0.95 time = 675
* CHECK dout0_18 vdout0_18ck134 = 0.95 time = 675
* CHECK dout0_19 vdout0_19ck134 = 0.95 time = 675
* CHECK dout0_20 vdout0_20ck134 = 0 time = 675
* CHECK dout0_0 vdout0_0ck136 = 0.95 time = 685
* CHECK dout0_1 vdout0_1ck136 = 0 time = 685
* CHECK dout0_2 vdout0_2ck136 = 0.95 time = 685
* CHECK dout0_3 vdout0_3ck136 = 0.95 time = 685
* CHECK dout0_4 vdout0_4ck136 = 0 time = 685
* CHECK dout0_5 vdout0_5ck136 = 0 time = 685
* CHECK dout0_6 vdout0_6ck136 = 0 time = 685
* CHECK dout0_7 vdout0_7ck136 = 0.95 time = 685
* CHECK dout0_8 vdout0_8ck136 = 0.95 time = 685
* CHECK dout0_9 vdout0_9ck136 = 0.95 time = 685
* CHECK dout0_10 vdout0_10ck136 = 0.95 time = 685
* CHECK dout0_11 vdout0_11ck136 = 0.95 time = 685
* CHECK dout0_12 vdout0_12ck136 = 0 time = 685
* CHECK dout0_13 vdout0_13ck136 = 0 time = 685
* CHECK dout0_14 vdout0_14ck136 = 0.95 time = 685
* CHECK dout0_15 vdout0_15ck136 = 0 time = 685
* CHECK dout0_16 vdout0_16ck136 = 0 time = 685
* CHECK dout0_17 vdout0_17ck136 = 0.95 time = 685
* CHECK dout0_18 vdout0_18ck136 = 0 time = 685
* CHECK dout0_19 vdout0_19ck136 = 0.95 time = 685
* CHECK dout0_20 vdout0_20ck136 = 0.95 time = 685
* CHECK dout0_0 vdout0_0ck140 = 0.95 time = 705
* CHECK dout0_1 vdout0_1ck140 = 0 time = 705
* CHECK dout0_2 vdout0_2ck140 = 0 time = 705
* CHECK dout0_3 vdout0_3ck140 = 0.95 time = 705
* CHECK dout0_4 vdout0_4ck140 = 0 time = 705
* CHECK dout0_5 vdout0_5ck140 = 0 time = 705
* CHECK dout0_6 vdout0_6ck140 = 0 time = 705
* CHECK dout0_7 vdout0_7ck140 = 0.95 time = 705
* CHECK dout0_8 vdout0_8ck140 = 0 time = 705
* CHECK dout0_9 vdout0_9ck140 = 0 time = 705
* CHECK dout0_10 vdout0_10ck140 = 0 time = 705
* CHECK dout0_11 vdout0_11ck140 = 0 time = 705
* CHECK dout0_12 vdout0_12ck140 = 0.95 time = 705
* CHECK dout0_13 vdout0_13ck140 = 0.95 time = 705
* CHECK dout0_14 vdout0_14ck140 = 0.95 time = 705
* CHECK dout0_15 vdout0_15ck140 = 0.95 time = 705
* CHECK dout0_16 vdout0_16ck140 = 0.95 time = 705
* CHECK dout0_17 vdout0_17ck140 = 0 time = 705
* CHECK dout0_18 vdout0_18ck140 = 0.95 time = 705
* CHECK dout0_19 vdout0_19ck140 = 0.95 time = 705
* CHECK dout0_20 vdout0_20ck140 = 0 time = 705
* CHECK dout0_0 vdout0_0ck143 = 0 time = 720
* CHECK dout0_1 vdout0_1ck143 = 0 time = 720
* CHECK dout0_2 vdout0_2ck143 = 0 time = 720
* CHECK dout0_3 vdout0_3ck143 = 0 time = 720
* CHECK dout0_4 vdout0_4ck143 = 0.95 time = 720
* CHECK dout0_5 vdout0_5ck143 = 0.95 time = 720
* CHECK dout0_6 vdout0_6ck143 = 0.95 time = 720
* CHECK dout0_7 vdout0_7ck143 = 0 time = 720
* CHECK dout0_8 vdout0_8ck143 = 0.95 time = 720
* CHECK dout0_9 vdout0_9ck143 = 0.95 time = 720
* CHECK dout0_10 vdout0_10ck143 = 0.95 time = 720
* CHECK dout0_11 vdout0_11ck143 = 0 time = 720
* CHECK dout0_12 vdout0_12ck143 = 0 time = 720
* CHECK dout0_13 vdout0_13ck143 = 0.95 time = 720
* CHECK dout0_14 vdout0_14ck143 = 0 time = 720
* CHECK dout0_15 vdout0_15ck143 = 0.95 time = 720
* CHECK dout0_16 vdout0_16ck143 = 0.95 time = 720
* CHECK dout0_17 vdout0_17ck143 = 0 time = 720
* CHECK dout0_18 vdout0_18ck143 = 0 time = 720
* CHECK dout0_19 vdout0_19ck143 = 0.95 time = 720
* CHECK dout0_20 vdout0_20ck143 = 0.95 time = 720
* CHECK dout0_0 vdout0_0ck145 = 0.95 time = 730
* CHECK dout0_1 vdout0_1ck145 = 0 time = 730
* CHECK dout0_2 vdout0_2ck145 = 0 time = 730
* CHECK dout0_3 vdout0_3ck145 = 0.95 time = 730
* CHECK dout0_4 vdout0_4ck145 = 0 time = 730
* CHECK dout0_5 vdout0_5ck145 = 0 time = 730
* CHECK dout0_6 vdout0_6ck145 = 0 time = 730
* CHECK dout0_7 vdout0_7ck145 = 0.95 time = 730
* CHECK dout0_8 vdout0_8ck145 = 0 time = 730
* CHECK dout0_9 vdout0_9ck145 = 0 time = 730
* CHECK dout0_10 vdout0_10ck145 = 0 time = 730
* CHECK dout0_11 vdout0_11ck145 = 0 time = 730
* CHECK dout0_12 vdout0_12ck145 = 0.95 time = 730
* CHECK dout0_13 vdout0_13ck145 = 0.95 time = 730
* CHECK dout0_14 vdout0_14ck145 = 0.95 time = 730
* CHECK dout0_15 vdout0_15ck145 = 0.95 time = 730
* CHECK dout0_16 vdout0_16ck145 = 0.95 time = 730
* CHECK dout0_17 vdout0_17ck145 = 0 time = 730
* CHECK dout0_18 vdout0_18ck145 = 0.95 time = 730
* CHECK dout0_19 vdout0_19ck145 = 0.95 time = 730
* CHECK dout0_20 vdout0_20ck145 = 0 time = 730
* CHECK dout0_0 vdout0_0ck149 = 0.95 time = 750
* CHECK dout0_1 vdout0_1ck149 = 0.95 time = 750
* CHECK dout0_2 vdout0_2ck149 = 0 time = 750
* CHECK dout0_3 vdout0_3ck149 = 0.95 time = 750
* CHECK dout0_4 vdout0_4ck149 = 0.95 time = 750
* CHECK dout0_5 vdout0_5ck149 = 0 time = 750
* CHECK dout0_6 vdout0_6ck149 = 0 time = 750
* CHECK dout0_7 vdout0_7ck149 = 0.95 time = 750
* CHECK dout0_8 vdout0_8ck149 = 0 time = 750
* CHECK dout0_9 vdout0_9ck149 = 0 time = 750
* CHECK dout0_10 vdout0_10ck149 = 0 time = 750
* CHECK dout0_11 vdout0_11ck149 = 0.95 time = 750
* CHECK dout0_12 vdout0_12ck149 = 0.95 time = 750
* CHECK dout0_13 vdout0_13ck149 = 0.95 time = 750
* CHECK dout0_14 vdout0_14ck149 = 0.95 time = 750
* CHECK dout0_15 vdout0_15ck149 = 0 time = 750
* CHECK dout0_16 vdout0_16ck149 = 0 time = 750
* CHECK dout0_17 vdout0_17ck149 = 0.95 time = 750
* CHECK dout0_18 vdout0_18ck149 = 0 time = 750
* CHECK dout0_19 vdout0_19ck149 = 0.95 time = 750
* CHECK dout0_20 vdout0_20ck149 = 0.95 time = 750
* CHECK dout0_0 vdout0_0ck150 = 0 time = 755
* CHECK dout0_1 vdout0_1ck150 = 0.95 time = 755
* CHECK dout0_2 vdout0_2ck150 = 0 time = 755
* CHECK dout0_3 vdout0_3ck150 = 0 time = 755
* CHECK dout0_4 vdout0_4ck150 = 0 time = 755
* CHECK dout0_5 vdout0_5ck150 = 0 time = 755
* CHECK dout0_6 vdout0_6ck150 = 0 time = 755
* CHECK dout0_7 vdout0_7ck150 = 0 time = 755
* CHECK dout0_8 vdout0_8ck150 = 0 time = 755
* CHECK dout0_9 vdout0_9ck150 = 0.95 time = 755
* CHECK dout0_10 vdout0_10ck150 = 0.95 time = 755
* CHECK dout0_11 vdout0_11ck150 = 0 time = 755
* CHECK dout0_12 vdout0_12ck150 = 0.95 time = 755
* CHECK dout0_13 vdout0_13ck150 = 0.95 time = 755
* CHECK dout0_14 vdout0_14ck150 = 0 time = 755
* CHECK dout0_15 vdout0_15ck150 = 0 time = 755
* CHECK dout0_16 vdout0_16ck150 = 0.95 time = 755
* CHECK dout0_17 vdout0_17ck150 = 0 time = 755
* CHECK dout0_18 vdout0_18ck150 = 0 time = 755
* CHECK dout0_19 vdout0_19ck150 = 0.95 time = 755
* CHECK dout0_20 vdout0_20ck150 = 0 time = 755
* CHECK dout0_0 vdout0_0ck152 = 0 time = 765
* CHECK dout0_1 vdout0_1ck152 = 0.95 time = 765
* CHECK dout0_2 vdout0_2ck152 = 0 time = 765
* CHECK dout0_3 vdout0_3ck152 = 0.95 time = 765
* CHECK dout0_4 vdout0_4ck152 = 0 time = 765
* CHECK dout0_5 vdout0_5ck152 = 0.95 time = 765
* CHECK dout0_6 vdout0_6ck152 = 0 time = 765
* CHECK dout0_7 vdout0_7ck152 = 0 time = 765
* CHECK dout0_8 vdout0_8ck152 = 0 time = 765
* CHECK dout0_9 vdout0_9ck152 = 0.95 time = 765
* CHECK dout0_10 vdout0_10ck152 = 0.95 time = 765
* CHECK dout0_11 vdout0_11ck152 = 0.95 time = 765
* CHECK dout0_12 vdout0_12ck152 = 0 time = 765
* CHECK dout0_13 vdout0_13ck152 = 0.95 time = 765
* CHECK dout0_14 vdout0_14ck152 = 0 time = 765
* CHECK dout0_15 vdout0_15ck152 = 0.95 time = 765
* CHECK dout0_16 vdout0_16ck152 = 0.95 time = 765
* CHECK dout0_17 vdout0_17ck152 = 0 time = 765
* CHECK dout0_18 vdout0_18ck152 = 0.95 time = 765
* CHECK dout0_19 vdout0_19ck152 = 0.95 time = 765
* CHECK dout0_20 vdout0_20ck152 = 0 time = 765
* CHECK dout0_0 vdout0_0ck154 = 0 time = 775
* CHECK dout0_1 vdout0_1ck154 = 0 time = 775
* CHECK dout0_2 vdout0_2ck154 = 0.95 time = 775
* CHECK dout0_3 vdout0_3ck154 = 0.95 time = 775
* CHECK dout0_4 vdout0_4ck154 = 0.95 time = 775
* CHECK dout0_5 vdout0_5ck154 = 0.95 time = 775
* CHECK dout0_6 vdout0_6ck154 = 0 time = 775
* CHECK dout0_7 vdout0_7ck154 = 0.95 time = 775
* CHECK dout0_8 vdout0_8ck154 = 0.95 time = 775
* CHECK dout0_9 vdout0_9ck154 = 0 time = 775
* CHECK dout0_10 vdout0_10ck154 = 0.95 time = 775
* CHECK dout0_11 vdout0_11ck154 = 0.95 time = 775
* CHECK dout0_12 vdout0_12ck154 = 0 time = 775
* CHECK dout0_13 vdout0_13ck154 = 0.95 time = 775
* CHECK dout0_14 vdout0_14ck154 = 0 time = 775
* CHECK dout0_15 vdout0_15ck154 = 0.95 time = 775
* CHECK dout0_16 vdout0_16ck154 = 0.95 time = 775
* CHECK dout0_17 vdout0_17ck154 = 0.95 time = 775
* CHECK dout0_18 vdout0_18ck154 = 0.95 time = 775
* CHECK dout0_19 vdout0_19ck154 = 0.95 time = 775
* CHECK dout0_20 vdout0_20ck154 = 0 time = 775
* CHECK dout0_0 vdout0_0ck157 = 0.95 time = 790
* CHECK dout0_1 vdout0_1ck157 = 0 time = 790
* CHECK dout0_2 vdout0_2ck157 = 0.95 time = 790
* CHECK dout0_3 vdout0_3ck157 = 0.95 time = 790
* CHECK dout0_4 vdout0_4ck157 = 0 time = 790
* CHECK dout0_5 vdout0_5ck157 = 0.95 time = 790
* CHECK dout0_6 vdout0_6ck157 = 0.95 time = 790
* CHECK dout0_7 vdout0_7ck157 = 0.95 time = 790
* CHECK dout0_8 vdout0_8ck157 = 0 time = 790
* CHECK dout0_9 vdout0_9ck157 = 0.95 time = 790
* CHECK dout0_10 vdout0_10ck157 = 0.95 time = 790
* CHECK dout0_11 vdout0_11ck157 = 0 time = 790
* CHECK dout0_12 vdout0_12ck157 = 0.95 time = 790
* CHECK dout0_13 vdout0_13ck157 = 0 time = 790
* CHECK dout0_14 vdout0_14ck157 = 0.95 time = 790
* CHECK dout0_15 vdout0_15ck157 = 0.95 time = 790
* CHECK dout0_16 vdout0_16ck157 = 0.95 time = 790
* CHECK dout0_17 vdout0_17ck157 = 0.95 time = 790
* CHECK dout0_18 vdout0_18ck157 = 0 time = 790
* CHECK dout0_19 vdout0_19ck157 = 0 time = 790
* CHECK dout0_20 vdout0_20ck157 = 0 time = 790
* CHECK dout0_0 vdout0_0ck158 = 0.95 time = 795
* CHECK dout0_1 vdout0_1ck158 = 0.95 time = 795
* CHECK dout0_2 vdout0_2ck158 = 0 time = 795
* CHECK dout0_3 vdout0_3ck158 = 0.95 time = 795
* CHECK dout0_4 vdout0_4ck158 = 0.95 time = 795
* CHECK dout0_5 vdout0_5ck158 = 0 time = 795
* CHECK dout0_6 vdout0_6ck158 = 0 time = 795
* CHECK dout0_7 vdout0_7ck158 = 0.95 time = 795
* CHECK dout0_8 vdout0_8ck158 = 0 time = 795
* CHECK dout0_9 vdout0_9ck158 = 0 time = 795
* CHECK dout0_10 vdout0_10ck158 = 0 time = 795
* CHECK dout0_11 vdout0_11ck158 = 0.95 time = 795
* CHECK dout0_12 vdout0_12ck158 = 0.95 time = 795
* CHECK dout0_13 vdout0_13ck158 = 0.95 time = 795
* CHECK dout0_14 vdout0_14ck158 = 0.95 time = 795
* CHECK dout0_15 vdout0_15ck158 = 0 time = 795
* CHECK dout0_16 vdout0_16ck158 = 0 time = 795
* CHECK dout0_17 vdout0_17ck158 = 0.95 time = 795
* CHECK dout0_18 vdout0_18ck158 = 0 time = 795
* CHECK dout0_19 vdout0_19ck158 = 0.95 time = 795
* CHECK dout0_20 vdout0_20ck158 = 0.95 time = 795
* CHECK dout0_0 vdout0_0ck159 = 0 time = 800
* CHECK dout0_1 vdout0_1ck159 = 0.95 time = 800
* CHECK dout0_2 vdout0_2ck159 = 0 time = 800
* CHECK dout0_3 vdout0_3ck159 = 0 time = 800
* CHECK dout0_4 vdout0_4ck159 = 0 time = 800
* CHECK dout0_5 vdout0_5ck159 = 0 time = 800
* CHECK dout0_6 vdout0_6ck159 = 0 time = 800
* CHECK dout0_7 vdout0_7ck159 = 0 time = 800
* CHECK dout0_8 vdout0_8ck159 = 0 time = 800
* CHECK dout0_9 vdout0_9ck159 = 0.95 time = 800
* CHECK dout0_10 vdout0_10ck159 = 0.95 time = 800
* CHECK dout0_11 vdout0_11ck159 = 0 time = 800
* CHECK dout0_12 vdout0_12ck159 = 0.95 time = 800
* CHECK dout0_13 vdout0_13ck159 = 0.95 time = 800
* CHECK dout0_14 vdout0_14ck159 = 0 time = 800
* CHECK dout0_15 vdout0_15ck159 = 0 time = 800
* CHECK dout0_16 vdout0_16ck159 = 0.95 time = 800
* CHECK dout0_17 vdout0_17ck159 = 0 time = 800
* CHECK dout0_18 vdout0_18ck159 = 0 time = 800
* CHECK dout0_19 vdout0_19ck159 = 0.95 time = 800
* CHECK dout0_20 vdout0_20ck159 = 0 time = 800
* CHECK dout0_0 vdout0_0ck162 = 0.95 time = 815
* CHECK dout0_1 vdout0_1ck162 = 0 time = 815
* CHECK dout0_2 vdout0_2ck162 = 0.95 time = 815
* CHECK dout0_3 vdout0_3ck162 = 0.95 time = 815
* CHECK dout0_4 vdout0_4ck162 = 0 time = 815
* CHECK dout0_5 vdout0_5ck162 = 0.95 time = 815
* CHECK dout0_6 vdout0_6ck162 = 0.95 time = 815
* CHECK dout0_7 vdout0_7ck162 = 0.95 time = 815
* CHECK dout0_8 vdout0_8ck162 = 0 time = 815
* CHECK dout0_9 vdout0_9ck162 = 0.95 time = 815
* CHECK dout0_10 vdout0_10ck162 = 0.95 time = 815
* CHECK dout0_11 vdout0_11ck162 = 0 time = 815
* CHECK dout0_12 vdout0_12ck162 = 0.95 time = 815
* CHECK dout0_13 vdout0_13ck162 = 0 time = 815
* CHECK dout0_14 vdout0_14ck162 = 0.95 time = 815
* CHECK dout0_15 vdout0_15ck162 = 0.95 time = 815
* CHECK dout0_16 vdout0_16ck162 = 0.95 time = 815
* CHECK dout0_17 vdout0_17ck162 = 0.95 time = 815
* CHECK dout0_18 vdout0_18ck162 = 0 time = 815
* CHECK dout0_19 vdout0_19ck162 = 0 time = 815
* CHECK dout0_20 vdout0_20ck162 = 0 time = 815
* CHECK dout0_0 vdout0_0ck163 = 0 time = 820
* CHECK dout0_1 vdout0_1ck163 = 0.95 time = 820
* CHECK dout0_2 vdout0_2ck163 = 0 time = 820
* CHECK dout0_3 vdout0_3ck163 = 0.95 time = 820
* CHECK dout0_4 vdout0_4ck163 = 0 time = 820
* CHECK dout0_5 vdout0_5ck163 = 0.95 time = 820
* CHECK dout0_6 vdout0_6ck163 = 0 time = 820
* CHECK dout0_7 vdout0_7ck163 = 0 time = 820
* CHECK dout0_8 vdout0_8ck163 = 0 time = 820
* CHECK dout0_9 vdout0_9ck163 = 0.95 time = 820
* CHECK dout0_10 vdout0_10ck163 = 0.95 time = 820
* CHECK dout0_11 vdout0_11ck163 = 0.95 time = 820
* CHECK dout0_12 vdout0_12ck163 = 0 time = 820
* CHECK dout0_13 vdout0_13ck163 = 0.95 time = 820
* CHECK dout0_14 vdout0_14ck163 = 0 time = 820
* CHECK dout0_15 vdout0_15ck163 = 0.95 time = 820
* CHECK dout0_16 vdout0_16ck163 = 0.95 time = 820
* CHECK dout0_17 vdout0_17ck163 = 0 time = 820
* CHECK dout0_18 vdout0_18ck163 = 0.95 time = 820
* CHECK dout0_19 vdout0_19ck163 = 0.95 time = 820
* CHECK dout0_20 vdout0_20ck163 = 0 time = 820
* CHECK dout0_0 vdout0_0ck165 = 0.95 time = 830
* CHECK dout0_1 vdout0_1ck165 = 0 time = 830
* CHECK dout0_2 vdout0_2ck165 = 0.95 time = 830
* CHECK dout0_3 vdout0_3ck165 = 0.95 time = 830
* CHECK dout0_4 vdout0_4ck165 = 0 time = 830
* CHECK dout0_5 vdout0_5ck165 = 0.95 time = 830
* CHECK dout0_6 vdout0_6ck165 = 0.95 time = 830
* CHECK dout0_7 vdout0_7ck165 = 0.95 time = 830
* CHECK dout0_8 vdout0_8ck165 = 0 time = 830
* CHECK dout0_9 vdout0_9ck165 = 0.95 time = 830
* CHECK dout0_10 vdout0_10ck165 = 0.95 time = 830
* CHECK dout0_11 vdout0_11ck165 = 0 time = 830
* CHECK dout0_12 vdout0_12ck165 = 0.95 time = 830
* CHECK dout0_13 vdout0_13ck165 = 0 time = 830
* CHECK dout0_14 vdout0_14ck165 = 0.95 time = 830
* CHECK dout0_15 vdout0_15ck165 = 0.95 time = 830
* CHECK dout0_16 vdout0_16ck165 = 0.95 time = 830
* CHECK dout0_17 vdout0_17ck165 = 0.95 time = 830
* CHECK dout0_18 vdout0_18ck165 = 0 time = 830
* CHECK dout0_19 vdout0_19ck165 = 0 time = 830
* CHECK dout0_20 vdout0_20ck165 = 0 time = 830
* CHECK dout0_0 vdout0_0ck169 = 0 time = 850
* CHECK dout0_1 vdout0_1ck169 = 0.95 time = 850
* CHECK dout0_2 vdout0_2ck169 = 0 time = 850
* CHECK dout0_3 vdout0_3ck169 = 0.95 time = 850
* CHECK dout0_4 vdout0_4ck169 = 0 time = 850
* CHECK dout0_5 vdout0_5ck169 = 0.95 time = 850
* CHECK dout0_6 vdout0_6ck169 = 0 time = 850
* CHECK dout0_7 vdout0_7ck169 = 0 time = 850
* CHECK dout0_8 vdout0_8ck169 = 0 time = 850
* CHECK dout0_9 vdout0_9ck169 = 0.95 time = 850
* CHECK dout0_10 vdout0_10ck169 = 0.95 time = 850
* CHECK dout0_11 vdout0_11ck169 = 0.95 time = 850
* CHECK dout0_12 vdout0_12ck169 = 0 time = 850
* CHECK dout0_13 vdout0_13ck169 = 0.95 time = 850
* CHECK dout0_14 vdout0_14ck169 = 0 time = 850
* CHECK dout0_15 vdout0_15ck169 = 0.95 time = 850
* CHECK dout0_16 vdout0_16ck169 = 0.95 time = 850
* CHECK dout0_17 vdout0_17ck169 = 0 time = 850
* CHECK dout0_18 vdout0_18ck169 = 0.95 time = 850
* CHECK dout0_19 vdout0_19ck169 = 0.95 time = 850
* CHECK dout0_20 vdout0_20ck169 = 0 time = 850
* CHECK dout0_0 vdout0_0ck170 = 0 time = 855
* CHECK dout0_1 vdout0_1ck170 = 0.95 time = 855
* CHECK dout0_2 vdout0_2ck170 = 0 time = 855
* CHECK dout0_3 vdout0_3ck170 = 0.95 time = 855
* CHECK dout0_4 vdout0_4ck170 = 0 time = 855
* CHECK dout0_5 vdout0_5ck170 = 0.95 time = 855
* CHECK dout0_6 vdout0_6ck170 = 0 time = 855
* CHECK dout0_7 vdout0_7ck170 = 0 time = 855
* CHECK dout0_8 vdout0_8ck170 = 0 time = 855
* CHECK dout0_9 vdout0_9ck170 = 0.95 time = 855
* CHECK dout0_10 vdout0_10ck170 = 0.95 time = 855
* CHECK dout0_11 vdout0_11ck170 = 0.95 time = 855
* CHECK dout0_12 vdout0_12ck170 = 0 time = 855
* CHECK dout0_13 vdout0_13ck170 = 0.95 time = 855
* CHECK dout0_14 vdout0_14ck170 = 0 time = 855
* CHECK dout0_15 vdout0_15ck170 = 0.95 time = 855
* CHECK dout0_16 vdout0_16ck170 = 0.95 time = 855
* CHECK dout0_17 vdout0_17ck170 = 0 time = 855
* CHECK dout0_18 vdout0_18ck170 = 0.95 time = 855
* CHECK dout0_19 vdout0_19ck170 = 0.95 time = 855
* CHECK dout0_20 vdout0_20ck170 = 0 time = 855
* CHECK dout0_0 vdout0_0ck172 = 0 time = 865
* CHECK dout0_1 vdout0_1ck172 = 0.95 time = 865
* CHECK dout0_2 vdout0_2ck172 = 0 time = 865
* CHECK dout0_3 vdout0_3ck172 = 0 time = 865
* CHECK dout0_4 vdout0_4ck172 = 0 time = 865
* CHECK dout0_5 vdout0_5ck172 = 0 time = 865
* CHECK dout0_6 vdout0_6ck172 = 0 time = 865
* CHECK dout0_7 vdout0_7ck172 = 0 time = 865
* CHECK dout0_8 vdout0_8ck172 = 0 time = 865
* CHECK dout0_9 vdout0_9ck172 = 0.95 time = 865
* CHECK dout0_10 vdout0_10ck172 = 0.95 time = 865
* CHECK dout0_11 vdout0_11ck172 = 0 time = 865
* CHECK dout0_12 vdout0_12ck172 = 0.95 time = 865
* CHECK dout0_13 vdout0_13ck172 = 0.95 time = 865
* CHECK dout0_14 vdout0_14ck172 = 0 time = 865
* CHECK dout0_15 vdout0_15ck172 = 0 time = 865
* CHECK dout0_16 vdout0_16ck172 = 0.95 time = 865
* CHECK dout0_17 vdout0_17ck172 = 0 time = 865
* CHECK dout0_18 vdout0_18ck172 = 0 time = 865
* CHECK dout0_19 vdout0_19ck172 = 0.95 time = 865
* CHECK dout0_20 vdout0_20ck172 = 0 time = 865
* CHECK dout0_0 vdout0_0ck174 = 0.95 time = 875
* CHECK dout0_1 vdout0_1ck174 = 0.95 time = 875
* CHECK dout0_2 vdout0_2ck174 = 0.95 time = 875
* CHECK dout0_3 vdout0_3ck174 = 0 time = 875
* CHECK dout0_4 vdout0_4ck174 = 0 time = 875
* CHECK dout0_5 vdout0_5ck174 = 0.95 time = 875
* CHECK dout0_6 vdout0_6ck174 = 0.95 time = 875
* CHECK dout0_7 vdout0_7ck174 = 0.95 time = 875
* CHECK dout0_8 vdout0_8ck174 = 0 time = 875
* CHECK dout0_9 vdout0_9ck174 = 0.95 time = 875
* CHECK dout0_10 vdout0_10ck174 = 0 time = 875
* CHECK dout0_11 vdout0_11ck174 = 0 time = 875
* CHECK dout0_12 vdout0_12ck174 = 0 time = 875
* CHECK dout0_13 vdout0_13ck174 = 0.95 time = 875
* CHECK dout0_14 vdout0_14ck174 = 0.95 time = 875
* CHECK dout0_15 vdout0_15ck174 = 0.95 time = 875
* CHECK dout0_16 vdout0_16ck174 = 0.95 time = 875
* CHECK dout0_17 vdout0_17ck174 = 0 time = 875
* CHECK dout0_18 vdout0_18ck174 = 0.95 time = 875
* CHECK dout0_19 vdout0_19ck174 = 0.95 time = 875
* CHECK dout0_20 vdout0_20ck174 = 0 time = 875
* CHECK dout0_0 vdout0_0ck175 = 0.95 time = 880
* CHECK dout0_1 vdout0_1ck175 = 0 time = 880
* CHECK dout0_2 vdout0_2ck175 = 0.95 time = 880
* CHECK dout0_3 vdout0_3ck175 = 0 time = 880
* CHECK dout0_4 vdout0_4ck175 = 0 time = 880
* CHECK dout0_5 vdout0_5ck175 = 0 time = 880
* CHECK dout0_6 vdout0_6ck175 = 0 time = 880
* CHECK dout0_7 vdout0_7ck175 = 0 time = 880
* CHECK dout0_8 vdout0_8ck175 = 0.95 time = 880
* CHECK dout0_9 vdout0_9ck175 = 0.95 time = 880
* CHECK dout0_10 vdout0_10ck175 = 0 time = 880
* CHECK dout0_11 vdout0_11ck175 = 0.95 time = 880
* CHECK dout0_12 vdout0_12ck175 = 0.95 time = 880
* CHECK dout0_13 vdout0_13ck175 = 0 time = 880
* CHECK dout0_14 vdout0_14ck175 = 0 time = 880
* CHECK dout0_15 vdout0_15ck175 = 0.95 time = 880
* CHECK dout0_16 vdout0_16ck175 = 0 time = 880
* CHECK dout0_17 vdout0_17ck175 = 0 time = 880
* CHECK dout0_18 vdout0_18ck175 = 0 time = 880
* CHECK dout0_19 vdout0_19ck175 = 0 time = 880
* CHECK dout0_20 vdout0_20ck175 = 0.95 time = 880
* CHECK dout0_0 vdout0_0ck179 = 0 time = 900
* CHECK dout0_1 vdout0_1ck179 = 0.95 time = 900
* CHECK dout0_2 vdout0_2ck179 = 0 time = 900
* CHECK dout0_3 vdout0_3ck179 = 0 time = 900
* CHECK dout0_4 vdout0_4ck179 = 0 time = 900
* CHECK dout0_5 vdout0_5ck179 = 0 time = 900
* CHECK dout0_6 vdout0_6ck179 = 0 time = 900
* CHECK dout0_7 vdout0_7ck179 = 0 time = 900
* CHECK dout0_8 vdout0_8ck179 = 0 time = 900
* CHECK dout0_9 vdout0_9ck179 = 0.95 time = 900
* CHECK dout0_10 vdout0_10ck179 = 0.95 time = 900
* CHECK dout0_11 vdout0_11ck179 = 0 time = 900
* CHECK dout0_12 vdout0_12ck179 = 0.95 time = 900
* CHECK dout0_13 vdout0_13ck179 = 0.95 time = 900
* CHECK dout0_14 vdout0_14ck179 = 0 time = 900
* CHECK dout0_15 vdout0_15ck179 = 0 time = 900
* CHECK dout0_16 vdout0_16ck179 = 0.95 time = 900
* CHECK dout0_17 vdout0_17ck179 = 0 time = 900
* CHECK dout0_18 vdout0_18ck179 = 0 time = 900
* CHECK dout0_19 vdout0_19ck179 = 0.95 time = 900
* CHECK dout0_20 vdout0_20ck179 = 0 time = 900
* CHECK dout0_0 vdout0_0ck180 = 0.95 time = 905
* CHECK dout0_1 vdout0_1ck180 = 0.95 time = 905
* CHECK dout0_2 vdout0_2ck180 = 0.95 time = 905
* CHECK dout0_3 vdout0_3ck180 = 0.95 time = 905
* CHECK dout0_4 vdout0_4ck180 = 0 time = 905
* CHECK dout0_5 vdout0_5ck180 = 0.95 time = 905
* CHECK dout0_6 vdout0_6ck180 = 0.95 time = 905
* CHECK dout0_7 vdout0_7ck180 = 0.95 time = 905
* CHECK dout0_8 vdout0_8ck180 = 0.95 time = 905
* CHECK dout0_9 vdout0_9ck180 = 0.95 time = 905
* CHECK dout0_10 vdout0_10ck180 = 0.95 time = 905
* CHECK dout0_11 vdout0_11ck180 = 0 time = 905
* CHECK dout0_12 vdout0_12ck180 = 0 time = 905
* CHECK dout0_13 vdout0_13ck180 = 0.95 time = 905
* CHECK dout0_14 vdout0_14ck180 = 0.95 time = 905
* CHECK dout0_15 vdout0_15ck180 = 0.95 time = 905
* CHECK dout0_16 vdout0_16ck180 = 0 time = 905
* CHECK dout0_17 vdout0_17ck180 = 0.95 time = 905
* CHECK dout0_18 vdout0_18ck180 = 0 time = 905
* CHECK dout0_19 vdout0_19ck180 = 0 time = 905
* CHECK dout0_20 vdout0_20ck180 = 0 time = 905
* CHECK dout0_0 vdout0_0ck181 = 0.95 time = 910
* CHECK dout0_1 vdout0_1ck181 = 0.95 time = 910
* CHECK dout0_2 vdout0_2ck181 = 0 time = 910
* CHECK dout0_3 vdout0_3ck181 = 0 time = 910
* CHECK dout0_4 vdout0_4ck181 = 0 time = 910
* CHECK dout0_5 vdout0_5ck181 = 0.95 time = 910
* CHECK dout0_6 vdout0_6ck181 = 0 time = 910
* CHECK dout0_7 vdout0_7ck181 = 0 time = 910
* CHECK dout0_8 vdout0_8ck181 = 0 time = 910
* CHECK dout0_9 vdout0_9ck181 = 0.95 time = 910
* CHECK dout0_10 vdout0_10ck181 = 0 time = 910
* CHECK dout0_11 vdout0_11ck181 = 0.95 time = 910
* CHECK dout0_12 vdout0_12ck181 = 0 time = 910
* CHECK dout0_13 vdout0_13ck181 = 0 time = 910
* CHECK dout0_14 vdout0_14ck181 = 0 time = 910
* CHECK dout0_15 vdout0_15ck181 = 0 time = 910
* CHECK dout0_16 vdout0_16ck181 = 0 time = 910
* CHECK dout0_17 vdout0_17ck181 = 0.95 time = 910
* CHECK dout0_18 vdout0_18ck181 = 0 time = 910
* CHECK dout0_19 vdout0_19ck181 = 0.95 time = 910
* CHECK dout0_20 vdout0_20ck181 = 0.95 time = 910
* CHECK dout0_0 vdout0_0ck183 = 0.95 time = 920
* CHECK dout0_1 vdout0_1ck183 = 0.95 time = 920
* CHECK dout0_2 vdout0_2ck183 = 0.95 time = 920
* CHECK dout0_3 vdout0_3ck183 = 0 time = 920
* CHECK dout0_4 vdout0_4ck183 = 0 time = 920
* CHECK dout0_5 vdout0_5ck183 = 0.95 time = 920
* CHECK dout0_6 vdout0_6ck183 = 0.95 time = 920
* CHECK dout0_7 vdout0_7ck183 = 0.95 time = 920
* CHECK dout0_8 vdout0_8ck183 = 0 time = 920
* CHECK dout0_9 vdout0_9ck183 = 0.95 time = 920
* CHECK dout0_10 vdout0_10ck183 = 0 time = 920
* CHECK dout0_11 vdout0_11ck183 = 0 time = 920
* CHECK dout0_12 vdout0_12ck183 = 0 time = 920
* CHECK dout0_13 vdout0_13ck183 = 0.95 time = 920
* CHECK dout0_14 vdout0_14ck183 = 0.95 time = 920
* CHECK dout0_15 vdout0_15ck183 = 0.95 time = 920
* CHECK dout0_16 vdout0_16ck183 = 0.95 time = 920
* CHECK dout0_17 vdout0_17ck183 = 0 time = 920
* CHECK dout0_18 vdout0_18ck183 = 0.95 time = 920
* CHECK dout0_19 vdout0_19ck183 = 0.95 time = 920
* CHECK dout0_20 vdout0_20ck183 = 0 time = 920
* CHECK dout0_0 vdout0_0ck185 = 0.95 time = 930
* CHECK dout0_1 vdout0_1ck185 = 0.95 time = 930
* CHECK dout0_2 vdout0_2ck185 = 0.95 time = 930
* CHECK dout0_3 vdout0_3ck185 = 0 time = 930
* CHECK dout0_4 vdout0_4ck185 = 0 time = 930
* CHECK dout0_5 vdout0_5ck185 = 0.95 time = 930
* CHECK dout0_6 vdout0_6ck185 = 0.95 time = 930
* CHECK dout0_7 vdout0_7ck185 = 0.95 time = 930
* CHECK dout0_8 vdout0_8ck185 = 0 time = 930
* CHECK dout0_9 vdout0_9ck185 = 0.95 time = 930
* CHECK dout0_10 vdout0_10ck185 = 0 time = 930
* CHECK dout0_11 vdout0_11ck185 = 0 time = 930
* CHECK dout0_12 vdout0_12ck185 = 0 time = 930
* CHECK dout0_13 vdout0_13ck185 = 0.95 time = 930
* CHECK dout0_14 vdout0_14ck185 = 0.95 time = 930
* CHECK dout0_15 vdout0_15ck185 = 0.95 time = 930
* CHECK dout0_16 vdout0_16ck185 = 0.95 time = 930
* CHECK dout0_17 vdout0_17ck185 = 0 time = 930
* CHECK dout0_18 vdout0_18ck185 = 0.95 time = 930
* CHECK dout0_19 vdout0_19ck185 = 0.95 time = 930
* CHECK dout0_20 vdout0_20ck185 = 0 time = 930
* CHECK dout0_0 vdout0_0ck188 = 0.95 time = 945
* CHECK dout0_1 vdout0_1ck188 = 0.95 time = 945
* CHECK dout0_2 vdout0_2ck188 = 0.95 time = 945
* CHECK dout0_3 vdout0_3ck188 = 0.95 time = 945
* CHECK dout0_4 vdout0_4ck188 = 0 time = 945
* CHECK dout0_5 vdout0_5ck188 = 0.95 time = 945
* CHECK dout0_6 vdout0_6ck188 = 0.95 time = 945
* CHECK dout0_7 vdout0_7ck188 = 0.95 time = 945
* CHECK dout0_8 vdout0_8ck188 = 0.95 time = 945
* CHECK dout0_9 vdout0_9ck188 = 0.95 time = 945
* CHECK dout0_10 vdout0_10ck188 = 0.95 time = 945
* CHECK dout0_11 vdout0_11ck188 = 0 time = 945
* CHECK dout0_12 vdout0_12ck188 = 0 time = 945
* CHECK dout0_13 vdout0_13ck188 = 0.95 time = 945
* CHECK dout0_14 vdout0_14ck188 = 0.95 time = 945
* CHECK dout0_15 vdout0_15ck188 = 0.95 time = 945
* CHECK dout0_16 vdout0_16ck188 = 0 time = 945
* CHECK dout0_17 vdout0_17ck188 = 0.95 time = 945
* CHECK dout0_18 vdout0_18ck188 = 0 time = 945
* CHECK dout0_19 vdout0_19ck188 = 0 time = 945
* CHECK dout0_20 vdout0_20ck188 = 0 time = 945
* CHECK dout0_0 vdout0_0ck191 = 0 time = 960
* CHECK dout0_1 vdout0_1ck191 = 0 time = 960
* CHECK dout0_2 vdout0_2ck191 = 0 time = 960
* CHECK dout0_3 vdout0_3ck191 = 0 time = 960
* CHECK dout0_4 vdout0_4ck191 = 0 time = 960
* CHECK dout0_5 vdout0_5ck191 = 0 time = 960
* CHECK dout0_6 vdout0_6ck191 = 0 time = 960
* CHECK dout0_7 vdout0_7ck191 = 0 time = 960
* CHECK dout0_8 vdout0_8ck191 = 0 time = 960
* CHECK dout0_9 vdout0_9ck191 = 0 time = 960
* CHECK dout0_10 vdout0_10ck191 = 0 time = 960
* CHECK dout0_11 vdout0_11ck191 = 0 time = 960
* CHECK dout0_12 vdout0_12ck191 = 0 time = 960
* CHECK dout0_13 vdout0_13ck191 = 0 time = 960
* CHECK dout0_14 vdout0_14ck191 = 0 time = 960
* CHECK dout0_15 vdout0_15ck191 = 0 time = 960
* CHECK dout0_16 vdout0_16ck191 = 0.95 time = 960
* CHECK dout0_17 vdout0_17ck191 = 0.95 time = 960
* CHECK dout0_18 vdout0_18ck191 = 0 time = 960
* CHECK dout0_19 vdout0_19ck191 = 0 time = 960
* CHECK dout0_20 vdout0_20ck191 = 0 time = 960
* CHECK dout0_0 vdout0_0ck193 = 0 time = 970
* CHECK dout0_1 vdout0_1ck193 = 0.95 time = 970
* CHECK dout0_2 vdout0_2ck193 = 0.95 time = 970
* CHECK dout0_3 vdout0_3ck193 = 0.95 time = 970
* CHECK dout0_4 vdout0_4ck193 = 0 time = 970
* CHECK dout0_5 vdout0_5ck193 = 0 time = 970
* CHECK dout0_6 vdout0_6ck193 = 0.95 time = 970
* CHECK dout0_7 vdout0_7ck193 = 0 time = 970
* CHECK dout0_8 vdout0_8ck193 = 0 time = 970
* CHECK dout0_9 vdout0_9ck193 = 0 time = 970
* CHECK dout0_10 vdout0_10ck193 = 0 time = 970
* CHECK dout0_11 vdout0_11ck193 = 0 time = 970
* CHECK dout0_12 vdout0_12ck193 = 0.95 time = 970
* CHECK dout0_13 vdout0_13ck193 = 0.95 time = 970
* CHECK dout0_14 vdout0_14ck193 = 0 time = 970
* CHECK dout0_15 vdout0_15ck193 = 0 time = 970
* CHECK dout0_16 vdout0_16ck193 = 0.95 time = 970
* CHECK dout0_17 vdout0_17ck193 = 0.95 time = 970
* CHECK dout0_18 vdout0_18ck193 = 0.95 time = 970
* CHECK dout0_19 vdout0_19ck193 = 0.95 time = 970
* CHECK dout0_20 vdout0_20ck193 = 0.95 time = 970
* CHECK dout0_0 vdout0_0ck194 = 0 time = 975
* CHECK dout0_1 vdout0_1ck194 = 0.95 time = 975
* CHECK dout0_2 vdout0_2ck194 = 0.95 time = 975
* CHECK dout0_3 vdout0_3ck194 = 0.95 time = 975
* CHECK dout0_4 vdout0_4ck194 = 0 time = 975
* CHECK dout0_5 vdout0_5ck194 = 0 time = 975
* CHECK dout0_6 vdout0_6ck194 = 0.95 time = 975
* CHECK dout0_7 vdout0_7ck194 = 0 time = 975
* CHECK dout0_8 vdout0_8ck194 = 0 time = 975
* CHECK dout0_9 vdout0_9ck194 = 0 time = 975
* CHECK dout0_10 vdout0_10ck194 = 0 time = 975
* CHECK dout0_11 vdout0_11ck194 = 0 time = 975
* CHECK dout0_12 vdout0_12ck194 = 0.95 time = 975
* CHECK dout0_13 vdout0_13ck194 = 0.95 time = 975
* CHECK dout0_14 vdout0_14ck194 = 0 time = 975
* CHECK dout0_15 vdout0_15ck194 = 0 time = 975
* CHECK dout0_16 vdout0_16ck194 = 0.95 time = 975
* CHECK dout0_17 vdout0_17ck194 = 0.95 time = 975
* CHECK dout0_18 vdout0_18ck194 = 0.95 time = 975
* CHECK dout0_19 vdout0_19ck194 = 0.95 time = 975
* CHECK dout0_20 vdout0_20ck194 = 0.95 time = 975
* CHECK dout0_0 vdout0_0ck195 = 0 time = 980
* CHECK dout0_1 vdout0_1ck195 = 0 time = 980
* CHECK dout0_2 vdout0_2ck195 = 0 time = 980
* CHECK dout0_3 vdout0_3ck195 = 0 time = 980
* CHECK dout0_4 vdout0_4ck195 = 0 time = 980
* CHECK dout0_5 vdout0_5ck195 = 0 time = 980
* CHECK dout0_6 vdout0_6ck195 = 0 time = 980
* CHECK dout0_7 vdout0_7ck195 = 0 time = 980
* CHECK dout0_8 vdout0_8ck195 = 0 time = 980
* CHECK dout0_9 vdout0_9ck195 = 0 time = 980
* CHECK dout0_10 vdout0_10ck195 = 0 time = 980
* CHECK dout0_11 vdout0_11ck195 = 0 time = 980
* CHECK dout0_12 vdout0_12ck195 = 0 time = 980
* CHECK dout0_13 vdout0_13ck195 = 0 time = 980
* CHECK dout0_14 vdout0_14ck195 = 0 time = 980
* CHECK dout0_15 vdout0_15ck195 = 0 time = 980
* CHECK dout0_16 vdout0_16ck195 = 0.95 time = 980
* CHECK dout0_17 vdout0_17ck195 = 0.95 time = 980
* CHECK dout0_18 vdout0_18ck195 = 0 time = 980
* CHECK dout0_19 vdout0_19ck195 = 0 time = 980
* CHECK dout0_20 vdout0_20ck195 = 0 time = 980
* CHECK dout0_0 vdout0_0ck199 = 0.95 time = 1000
* CHECK dout0_1 vdout0_1ck199 = 0.95 time = 1000
* CHECK dout0_2 vdout0_2ck199 = 0 time = 1000
* CHECK dout0_3 vdout0_3ck199 = 0 time = 1000
* CHECK dout0_4 vdout0_4ck199 = 0 time = 1000
* CHECK dout0_5 vdout0_5ck199 = 0.95 time = 1000
* CHECK dout0_6 vdout0_6ck199 = 0 time = 1000
* CHECK dout0_7 vdout0_7ck199 = 0 time = 1000
* CHECK dout0_8 vdout0_8ck199 = 0 time = 1000
* CHECK dout0_9 vdout0_9ck199 = 0.95 time = 1000
* CHECK dout0_10 vdout0_10ck199 = 0 time = 1000
* CHECK dout0_11 vdout0_11ck199 = 0.95 time = 1000
* CHECK dout0_12 vdout0_12ck199 = 0 time = 1000
* CHECK dout0_13 vdout0_13ck199 = 0 time = 1000
* CHECK dout0_14 vdout0_14ck199 = 0 time = 1000
* CHECK dout0_15 vdout0_15ck199 = 0 time = 1000
* CHECK dout0_16 vdout0_16ck199 = 0 time = 1000
* CHECK dout0_17 vdout0_17ck199 = 0.95 time = 1000
* CHECK dout0_18 vdout0_18ck199 = 0 time = 1000
* CHECK dout0_19 vdout0_19ck199 = 0.95 time = 1000
* CHECK dout0_20 vdout0_20ck199 = 0.95 time = 1000
* CHECK dout0_0 vdout0_0ck200 = 0.95 time = 1005
* CHECK dout0_1 vdout0_1ck200 = 0.95 time = 1005
* CHECK dout0_2 vdout0_2ck200 = 0.95 time = 1005
* CHECK dout0_3 vdout0_3ck200 = 0.95 time = 1005
* CHECK dout0_4 vdout0_4ck200 = 0 time = 1005
* CHECK dout0_5 vdout0_5ck200 = 0.95 time = 1005
* CHECK dout0_6 vdout0_6ck200 = 0.95 time = 1005
* CHECK dout0_7 vdout0_7ck200 = 0.95 time = 1005
* CHECK dout0_8 vdout0_8ck200 = 0.95 time = 1005
* CHECK dout0_9 vdout0_9ck200 = 0.95 time = 1005
* CHECK dout0_10 vdout0_10ck200 = 0.95 time = 1005
* CHECK dout0_11 vdout0_11ck200 = 0 time = 1005
* CHECK dout0_12 vdout0_12ck200 = 0 time = 1005
* CHECK dout0_13 vdout0_13ck200 = 0.95 time = 1005
* CHECK dout0_14 vdout0_14ck200 = 0.95 time = 1005
* CHECK dout0_15 vdout0_15ck200 = 0.95 time = 1005
* CHECK dout0_16 vdout0_16ck200 = 0 time = 1005
* CHECK dout0_17 vdout0_17ck200 = 0.95 time = 1005
* CHECK dout0_18 vdout0_18ck200 = 0 time = 1005
* CHECK dout0_19 vdout0_19ck200 = 0 time = 1005
* CHECK dout0_20 vdout0_20ck200 = 0 time = 1005
* CHECK dout0_0 vdout0_0ck204 = 0.95 time = 1025
* CHECK dout0_1 vdout0_1ck204 = 0.95 time = 1025
* CHECK dout0_2 vdout0_2ck204 = 0.95 time = 1025
* CHECK dout0_3 vdout0_3ck204 = 0.95 time = 1025
* CHECK dout0_4 vdout0_4ck204 = 0 time = 1025
* CHECK dout0_5 vdout0_5ck204 = 0.95 time = 1025
* CHECK dout0_6 vdout0_6ck204 = 0.95 time = 1025
* CHECK dout0_7 vdout0_7ck204 = 0.95 time = 1025
* CHECK dout0_8 vdout0_8ck204 = 0.95 time = 1025
* CHECK dout0_9 vdout0_9ck204 = 0.95 time = 1025
* CHECK dout0_10 vdout0_10ck204 = 0.95 time = 1025
* CHECK dout0_11 vdout0_11ck204 = 0 time = 1025
* CHECK dout0_12 vdout0_12ck204 = 0 time = 1025
* CHECK dout0_13 vdout0_13ck204 = 0.95 time = 1025
* CHECK dout0_14 vdout0_14ck204 = 0.95 time = 1025
* CHECK dout0_15 vdout0_15ck204 = 0.95 time = 1025
* CHECK dout0_16 vdout0_16ck204 = 0 time = 1025
* CHECK dout0_17 vdout0_17ck204 = 0.95 time = 1025
* CHECK dout0_18 vdout0_18ck204 = 0 time = 1025
* CHECK dout0_19 vdout0_19ck204 = 0 time = 1025
* CHECK dout0_20 vdout0_20ck204 = 0 time = 1025
.include /home/discontentBoron/Projects/OpenRAM/../orion-rv/sram/dcache_tag_sram_1rw0r0w_21_64_freepdk45/functional_meas.sp
.OPTIONS DEVICE TEMP=125
.OPTIONS MEASURE MEASFAIL=1
.OPTIONS LINSOL type=klu
.OPTIONS TIMEINT RELTOL=1e-3 ABSTOL=1e-6 method=gear minorder=2
.TRAN 10p 1030n 0n 10p
* probe is used for hspice/xa, while plot is used in ngspice
.end
