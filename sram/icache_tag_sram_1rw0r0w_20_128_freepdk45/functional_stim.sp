* Functional test stimulus file for 5ns period

* SS process corner
.include "/home/discontentBoron/Projects/OpenRAM/technology/freepdk45/models/tran_models/models_ss/PMOS_VTG.inc"
.include "/home/discontentBoron/Projects/OpenRAM/technology/freepdk45/models/tran_models/models_ss/NMOS_VTG.inc"
.include "/tmp/openram_discontentBoron_10401_temp/sram.sp"

* Global Power Supplies
Vvdd vdd 0 0.95

*Nodes gnd and 0 are the same global ground node in ngspice/hspice/xa. Otherwise, this source may be needed.
Vgnd gnd 0 0.0

* Instantiation of the SRAM
Xicache_tag_sram_1rw0r0w_20_128_freepdk45 din0_0 din0_1 din0_2 din0_3 din0_4 din0_5 din0_6 din0_7 din0_8 din0_9 din0_10 din0_11 din0_12 din0_13 din0_14 din0_15 din0_16 din0_17 din0_18 din0_19 a0_0 a0_1 a0_2 a0_3 a0_4 a0_5 a0_6 CSB0 WEB0 clk0 dout0_0 dout0_1 dout0_2 dout0_3 dout0_4 dout0_5 dout0_6 dout0_7 dout0_8 dout0_9 dout0_10 dout0_11 dout0_12 dout0_13 dout0_14 dout0_15 dout0_16 dout0_17 dout0_18 dout0_19 vdd gnd icache_tag_sram_1rw0r0w_20_128_freepdk45

* SRAM output loads
CD00 dout0_0  0 0.8364f
CD01 dout0_1  0 0.8364f
CD02 dout0_2  0 0.8364f
CD03 dout0_3  0 0.8364f
CD04 dout0_4  0 0.8364f
CD05 dout0_5  0 0.8364f
CD06 dout0_6  0 0.8364f
CD07 dout0_7  0 0.8364f
CD08 dout0_8  0 0.8364f
CD09 dout0_9  0 0.8364f
CD010 dout0_10  0 0.8364f
CD011 dout0_11  0 0.8364f
CD012 dout0_12  0 0.8364f
CD013 dout0_13  0 0.8364f
CD014 dout0_14  0 0.8364f
CD015 dout0_15  0 0.8364f
CD016 dout0_16  0 0.8364f
CD017 dout0_17  0 0.8364f
CD018 dout0_18  0 0.8364f
CD019 dout0_19  0 0.8364f

* Important signals for debug
* bl:	xsram:xbank0:bl_0_0
* br:	xsram:xbank0:br_0_0
* s_en:	xsram:s_en
* q:	xsram:xbank0:xbitcell_array:xbitcell_array:xbit_r0_c0:Q
* qbar:	xsram:xbank0:xbitcell_array:xbitcell_array:xbit_r0_c0:Q_bar

* Sequence of operations
*	Idle during cycle 0 (0ns - 5ns)
*	Writing 11001000001100001011  to  address 1111101 (from port 0) during cycle 1 (5ns - 10ns)
*	Writing 10010010010110011000  to  address 0000010 (from port 0) during cycle 2 (10ns - 15ns)
*	Writing 11111011001011101000  to  address 0000011 (from port 0) during cycle 3 (15ns - 20ns)
*	Reading 11111011001011101000 from address 0000011 (from port 0) during cycle 4 (20ns - 25ns)
*	Writing 11001111001010011011  to  address 1111110 (from port 0) during cycle 5 (25ns - 30ns)
*	Writing 11000011000101111110  to  address 1111101 (from port 0) during cycle 6 (30ns - 35ns)
*	Reading 11000011000101111110 from address 1111101 (from port 0) during cycle 7 (35ns - 40ns)
*	Writing 00010000000111000011  to  address 1111100 (from port 0) during cycle 8 (40ns - 45ns)
*	Writing 11011000010010111101  to  address 1111100 (from port 0) during cycle 9 (45ns - 50ns)
*	Writing 01111000111101000001  to  address 0000011 (from port 0) during cycle 12 (60ns - 65ns)
*	Writing 01110100011001111100  to  address 1111011 (from port 0) during cycle 13 (65ns - 70ns)
*	Reading 11001111001010011011 from address 1111110 (from port 0) during cycle 14 (70ns - 75ns)
*	Writing 10111101011111010001  to  address 1111101 (from port 0) during cycle 15 (75ns - 80ns)
*	Reading 01110100011001111100 from address 1111011 (from port 0) during cycle 16 (80ns - 85ns)
*	Reading 11011000010010111101 from address 1111100 (from port 0) during cycle 18 (90ns - 95ns)
*	Writing 01100000001100110010  to  address 0000011 (from port 0) during cycle 19 (95ns - 100ns)
*	Reading 01100000001100110010 from address 0000011 (from port 0) during cycle 23 (115ns - 120ns)
*	Reading 01100000001100110010 from address 0000011 (from port 0) during cycle 25 (125ns - 130ns)
*	Writing 11101010111011011000  to  address 1111101 (from port 0) during cycle 27 (135ns - 140ns)
*	Writing 01101001110111100100  to  address 1111110 (from port 0) during cycle 28 (140ns - 145ns)
*	Writing 00001110101010000010  to  address 1111100 (from port 0) during cycle 29 (145ns - 150ns)
*	Writing 00011001011110100111  to  address 1111011 (from port 0) during cycle 30 (150ns - 155ns)
*	Reading 01100000001100110010 from address 0000011 (from port 0) during cycle 31 (155ns - 160ns)
*	Reading 01101001110111100100 from address 1111110 (from port 0) during cycle 32 (160ns - 165ns)
*	Writing 00011111110011101000  to  address 1111101 (from port 0) during cycle 33 (165ns - 170ns)
*	Reading 00011111110011101000 from address 1111101 (from port 0) during cycle 34 (170ns - 175ns)
*	Reading 01100000001100110010 from address 0000011 (from port 0) during cycle 35 (175ns - 180ns)
*	Writing 00111000000101010011  to  address 1111110 (from port 0) during cycle 37 (185ns - 190ns)
*	Reading 00111000000101010011 from address 1111110 (from port 0) during cycle 38 (190ns - 195ns)
*	Reading 00001110101010000010 from address 1111100 (from port 0) during cycle 39 (195ns - 200ns)
*	Reading 00111000000101010011 from address 1111110 (from port 0) during cycle 40 (200ns - 205ns)
*	Reading 01100000001100110010 from address 0000011 (from port 0) during cycle 41 (205ns - 210ns)
*	Writing 11111000111010110110  to  address 1111100 (from port 0) during cycle 42 (210ns - 215ns)
*	Reading 11111000111010110110 from address 1111100 (from port 0) during cycle 43 (215ns - 220ns)
*	Writing 11101110011101000000  to  address 1111101 (from port 0) during cycle 44 (220ns - 225ns)
*	Writing 00001111001100001111  to  address 1111011 (from port 0) during cycle 45 (225ns - 230ns)
*	Writing 10010011010001001100  to  address 1111110 (from port 0) during cycle 46 (230ns - 235ns)
*	Writing 00001010000111010000  to  address 0000001 (from port 0) during cycle 49 (245ns - 250ns)
*	Reading 01100000001100110010 from address 0000011 (from port 0) during cycle 52 (260ns - 265ns)
*	Writing 00011110010001011000  to  address 1111011 (from port 0) during cycle 54 (270ns - 275ns)
*	Reading 11101110011101000000 from address 1111101 (from port 0) during cycle 55 (275ns - 280ns)
*	Reading 11111000111010110110 from address 1111100 (from port 0) during cycle 59 (295ns - 300ns)
*	Reading 10010011010001001100 from address 1111110 (from port 0) during cycle 60 (300ns - 305ns)
*	Writing 10000001010100110001  to  address 0000001 (from port 0) during cycle 61 (305ns - 310ns)
*	Reading 11101110011101000000 from address 1111101 (from port 0) during cycle 62 (310ns - 315ns)
*	Reading 11111000111010110110 from address 1111100 (from port 0) during cycle 63 (315ns - 320ns)
*	Writing 11100101000001011000  to  address 1111100 (from port 0) during cycle 64 (320ns - 325ns)
*	Reading 10010011010001001100 from address 1111110 (from port 0) during cycle 65 (325ns - 330ns)
*	Reading 00011110010001011000 from address 1111011 (from port 0) during cycle 67 (335ns - 340ns)
*	Reading 11101110011101000000 from address 1111101 (from port 0) during cycle 68 (340ns - 345ns)
*	Reading 10010011010001001100 from address 1111110 (from port 0) during cycle 69 (345ns - 350ns)
*	Reading 01100000001100110010 from address 0000011 (from port 0) during cycle 70 (350ns - 355ns)
*	Reading 01100000001100110010 from address 0000011 (from port 0) during cycle 71 (355ns - 360ns)
*	Reading 00011110010001011000 from address 1111011 (from port 0) during cycle 72 (360ns - 365ns)
*	Writing 01101010000111001011  to  address 0000000 (from port 0) during cycle 73 (365ns - 370ns)
*	Writing 11101100011100011001  to  address 1111101 (from port 0) during cycle 75 (375ns - 380ns)
*	Writing 01011010110100010101  to  address 0000000 (from port 0) during cycle 76 (380ns - 385ns)
*	Reading 01011010110100010101 from address 0000000 (from port 0) during cycle 77 (385ns - 390ns)
*	Reading 00011110010001011000 from address 1111011 (from port 0) during cycle 78 (390ns - 395ns)
*	Reading 01100000001100110010 from address 0000011 (from port 0) during cycle 79 (395ns - 400ns)
*	Writing 01101101001001100100  to  address 0000000 (from port 0) during cycle 80 (400ns - 405ns)
*	Reading 10010010010110011000 from address 0000010 (from port 0) during cycle 81 (405ns - 410ns)
*	Reading 01100000001100110010 from address 0000011 (from port 0) during cycle 83 (415ns - 420ns)
*	Writing 10110010000000101111  to  address 1111110 (from port 0) during cycle 84 (420ns - 425ns)
*	Reading 10110010000000101111 from address 1111110 (from port 0) during cycle 85 (425ns - 430ns)
*	Reading 01100000001100110010 from address 0000011 (from port 0) during cycle 86 (430ns - 435ns)
*	Writing 10101101100010110001  to  address 0000010 (from port 0) during cycle 88 (440ns - 445ns)
*	Writing 00011101000111000000  to  address 1111100 (from port 0) during cycle 89 (445ns - 450ns)
*	Writing 00010101101110001000  to  address 0000010 (from port 0) during cycle 90 (450ns - 455ns)
*	Reading 01101101001001100100 from address 0000000 (from port 0) during cycle 91 (455ns - 460ns)
*	Writing 00000011010011100100  to  address 1111110 (from port 0) during cycle 93 (465ns - 470ns)
*	Reading 00011101000111000000 from address 1111100 (from port 0) during cycle 94 (470ns - 475ns)
*	Reading 11101100011100011001 from address 1111101 (from port 0) during cycle 95 (475ns - 480ns)
*	Reading 01100000001100110010 from address 0000011 (from port 0) during cycle 97 (485ns - 490ns)
*	Reading 10000001010100110001 from address 0000001 (from port 0) during cycle 98 (490ns - 495ns)
*	Reading 00000011010011100100 from address 1111110 (from port 0) during cycle 99 (495ns - 500ns)
*	Reading 01100000001100110010 from address 0000011 (from port 0) during cycle 100 (500ns - 505ns)
*	Writing 00011111111101001100  to  address 0000000 (from port 0) during cycle 101 (505ns - 510ns)
*	Writing 10010101100011011011  to  address 0000000 (from port 0) during cycle 102 (510ns - 515ns)
*	Writing 11001110000010110000  to  address 0000010 (from port 0) during cycle 103 (515ns - 520ns)
*	Reading 00011101000111000000 from address 1111100 (from port 0) during cycle 104 (520ns - 525ns)
*	Reading 00011101000111000000 from address 1111100 (from port 0) during cycle 105 (525ns - 530ns)
*	Reading 00000011010011100100 from address 1111110 (from port 0) during cycle 106 (530ns - 535ns)
*	Writing 11100001010110111110  to  address 1111100 (from port 0) during cycle 107 (535ns - 540ns)
*	Reading 11001110000010110000 from address 0000010 (from port 0) during cycle 109 (545ns - 550ns)
*	Writing 10110110110010100010  to  address 0000010 (from port 0) during cycle 110 (550ns - 555ns)
*	Reading 01100000001100110010 from address 0000011 (from port 0) during cycle 111 (555ns - 560ns)
*	Writing 10111101101010010011  to  address 0000011 (from port 0) during cycle 112 (560ns - 565ns)
*	Writing 11110100000001001000  to  address 0000010 (from port 0) during cycle 113 (565ns - 570ns)
*	Reading 10111101101010010011 from address 0000011 (from port 0) during cycle 114 (570ns - 575ns)
*	Writing 11100100100101010010  to  address 1111100 (from port 0) during cycle 115 (575ns - 580ns)
*	Writing 10110001101011001101  to  address 0000000 (from port 0) during cycle 116 (580ns - 585ns)
*	Reading 10110001101011001101 from address 0000000 (from port 0) during cycle 117 (585ns - 590ns)
*	Reading 00011110010001011000 from address 1111011 (from port 0) during cycle 120 (600ns - 605ns)
*	Writing 01010110000010000010  to  address 0000001 (from port 0) during cycle 121 (605ns - 610ns)
*	Reading 01010110000010000010 from address 0000001 (from port 0) during cycle 122 (610ns - 615ns)
*	Writing 01110101101000111001  to  address 0000011 (from port 0) during cycle 123 (615ns - 620ns)
*	Reading 01110101101000111001 from address 0000011 (from port 0) during cycle 124 (620ns - 625ns)
*	Writing 00101110101100110011  to  address 1111101 (from port 0) during cycle 126 (630ns - 635ns)
*	Writing 01110000101001111101  to  address 0000011 (from port 0) during cycle 127 (635ns - 640ns)
*	Writing 00001001101000001011  to  address 1111101 (from port 0) during cycle 128 (640ns - 645ns)
*	Reading 01110000101001111101 from address 0000011 (from port 0) during cycle 129 (645ns - 650ns)
*	Writing 10101001010011100011  to  address 0000001 (from port 0) during cycle 131 (655ns - 660ns)
*	Reading 10101001010011100011 from address 0000001 (from port 0) during cycle 132 (660ns - 665ns)
*	Reading 01110000101001111101 from address 0000011 (from port 0) during cycle 133 (665ns - 670ns)
*	Writing 00101101010110110111  to  address 0000010 (from port 0) during cycle 134 (670ns - 675ns)
*	Writing 10000100000100110001  to  address 1111110 (from port 0) during cycle 135 (675ns - 680ns)
*	Reading 01110000101001111101 from address 0000011 (from port 0) during cycle 136 (680ns - 685ns)
*	Writing 00010100001111000100  to  address 1111110 (from port 0) during cycle 140 (700ns - 705ns)
*	Writing 10110101101100010110  to  address 0000001 (from port 0) during cycle 141 (705ns - 710ns)
*	Reading 00101101010110110111 from address 0000010 (from port 0) during cycle 143 (715ns - 720ns)
*	Reading 00010100001111000100 from address 1111110 (from port 0) during cycle 144 (720ns - 725ns)
*	Reading 00101101010110110111 from address 0000010 (from port 0) during cycle 145 (725ns - 730ns)
*	Writing 00001101111010000011  to  address 1111011 (from port 0) during cycle 147 (735ns - 740ns)
*	Reading 10110001101011001101 from address 0000000 (from port 0) during cycle 148 (740ns - 745ns)
*	Writing 00101110001101011111  to  address 1111101 (from port 0) during cycle 149 (745ns - 750ns)
*	Reading 00001101111010000011 from address 1111011 (from port 0) during cycle 150 (750ns - 755ns)
*	Reading 00001101111010000011 from address 1111011 (from port 0) during cycle 151 (755ns - 760ns)
*	Reading 00101110001101011111 from address 1111101 (from port 0) during cycle 152 (760ns - 765ns)
*	Writing 00000101101011010011  to  address 1111101 (from port 0) during cycle 154 (770ns - 775ns)
*	Reading 00010100001111000100 from address 1111110 (from port 0) during cycle 155 (775ns - 780ns)
*	Reading 00000101101011010011 from address 1111101 (from port 0) during cycle 156 (780ns - 785ns)
*	Reading 11100100100101010010 from address 1111100 (from port 0) during cycle 157 (785ns - 790ns)
*	Reading 01110000101001111101 from address 0000011 (from port 0) during cycle 158 (790ns - 795ns)
*	Reading 01110000101001111101 from address 0000011 (from port 0) during cycle 159 (795ns - 800ns)
*	Writing 01001001000111011110  to  address 0000011 (from port 0) during cycle 162 (810ns - 815ns)
*	Writing 10001000101000011101  to  address 1111110 (from port 0) during cycle 163 (815ns - 820ns)
*	Reading 01001001000111011110 from address 0000011 (from port 0) during cycle 164 (820ns - 825ns)
*	Reading 01001001000111011110 from address 0000011 (from port 0) during cycle 165 (825ns - 830ns)
*	Reading 00001101111010000011 from address 1111011 (from port 0) during cycle 166 (830ns - 835ns)
*	Reading 00101101010110110111 from address 0000010 (from port 0) during cycle 167 (835ns - 840ns)
*	Reading 10001000101000011101 from address 1111110 (from port 0) during cycle 168 (840ns - 845ns)
*	Reading 10110001101011001101 from address 0000000 (from port 0) during cycle 169 (845ns - 850ns)
*	Reading 10001000101000011101 from address 1111110 (from port 0) during cycle 170 (850ns - 855ns)
*	Reading 10001000101000011101 from address 1111110 (from port 0) during cycle 172 (860ns - 865ns)
*	Reading 11100100100101010010 from address 1111100 (from port 0) during cycle 173 (865ns - 870ns)
*	Writing 11000011100011100000  to  address 0000000 (from port 0) during cycle 174 (870ns - 875ns)
*	Reading 00000101101011010011 from address 1111101 (from port 0) during cycle 175 (875ns - 880ns)
*	Writing 10110010110101000010  to  address 1111100 (from port 0) during cycle 176 (880ns - 885ns)
*	Writing 00010001101110010000  to  address 0000001 (from port 0) during cycle 177 (885ns - 890ns)
*	Writing 01101011101000010111  to  address 0000011 (from port 0) during cycle 178 (890ns - 895ns)
*	Writing 00101000110011000111  to  address 1111110 (from port 0) during cycle 179 (895ns - 900ns)
*	Writing 11001010010110011111  to  address 0000000 (from port 0) during cycle 180 (900ns - 905ns)
*	Reading 00101101010110110111 from address 0000010 (from port 0) during cycle 181 (905ns - 910ns)
*	Reading 01101011101000010111 from address 0000011 (from port 0) during cycle 182 (910ns - 915ns)
*	Writing 11101001101101011010  to  address 1111100 (from port 0) during cycle 183 (915ns - 920ns)
*	Reading 01101011101000010111 from address 0000011 (from port 0) during cycle 184 (920ns - 925ns)
*	Reading 00101101010110110111 from address 0000010 (from port 0) during cycle 187 (935ns - 940ns)
*	Writing 01010011110011100101  to  address 0000010 (from port 0) during cycle 188 (940ns - 945ns)
*	Reading 11001010010110011111 from address 0000000 (from port 0) during cycle 189 (945ns - 950ns)
*	Reading 00101000110011000111 from address 1111110 (from port 0) during cycle 190 (950ns - 955ns)
*	Writing 11110011010110111010  to  address 0000010 (from port 0) during cycle 191 (955ns - 960ns)
*	Reading 00000101101011010011 from address 1111101 (from port 0) during cycle 192 (960ns - 965ns)
*	Writing 10011000101011001110  to  address 0000001 (from port 0) during cycle 193 (965ns - 970ns)
*	Reading 10011000101011001110 from address 0000001 (from port 0) during cycle 194 (970ns - 975ns)
*	Reading 11001010010110011111 from address 0000000 (from port 0) during cycle 200 (1000ns - 1005ns)
*	Writing 00011000000110000101  to  address 0000000 (from port 0) during cycle 202 (1010ns - 1015ns)
*	Reading 11110011010110111010 from address 0000010 (from port 0) during cycle 203 (1015ns - 1020ns)
*	Reading 00001101111010000011 from address 1111011 (from port 0) during cycle 204 (1020ns - 1025ns)
*	Idle during cycle 205 (1025ns - 1030ns)

* Generation of data and address signals
* (time, data): [(0, 0), (5, 1), (10, 0), (15, 0), (20, 0), (25, 1), (30, 0), (35, 0), (40, 1), (45, 1), (50, 1), (55, 1), (60, 1), (65, 0), (70, 0), (75, 1), (80, 1), (85, 1), (90, 1), (95, 0), (100, 0), (105, 0), (110, 0), (115, 0), (120, 0), (125, 0), (130, 0), (135, 0), (140, 0), (145, 0), (150, 1), (155, 1), (160, 1), (165, 0), (170, 0), (175, 0), (180, 0), (185, 1), (190, 1), (195, 1), (200, 1), (205, 1), (210, 0), (215, 0), (220, 0), (225, 1), (230, 0), (235, 0), (240, 0), (245, 0), (250, 0), (255, 0), (260, 0), (265, 0), (270, 0), (275, 0), (280, 0), (285, 0), (290, 0), (295, 0), (300, 0), (305, 1), (310, 1), (315, 1), (320, 0), (325, 0), (330, 0), (335, 0), (340, 0), (345, 0), (350, 0), (355, 0), (360, 0), (365, 1), (370, 1), (375, 1), (380, 1), (385, 1), (390, 1), (395, 1), (400, 0), (405, 0), (410, 0), (415, 0), (420, 1), (425, 1), (430, 1), (435, 1), (440, 1), (445, 0), (450, 0), (455, 0), (460, 0), (465, 0), (470, 0), (475, 0), (480, 0), (485, 0), (490, 0), (495, 0), (500, 0), (505, 0), (510, 1), (515, 0), (520, 0), (525, 0), (530, 0), (535, 0), (540, 0), (545, 0), (550, 0), (555, 0), (560, 1), (565, 0), (570, 0), (575, 0), (580, 1), (585, 1), (590, 1), (595, 1), (600, 1), (605, 0), (610, 0), (615, 1), (620, 1), (625, 1), (630, 1), (635, 1), (640, 1), (645, 1), (650, 1), (655, 1), (660, 1), (665, 1), (670, 1), (675, 1), (680, 1), (685, 1), (690, 1), (695, 1), (700, 0), (705, 0), (710, 0), (715, 0), (720, 0), (725, 0), (730, 0), (735, 1), (740, 1), (745, 1), (750, 1), (755, 1), (760, 1), (765, 1), (770, 1), (775, 1), (780, 1), (785, 1), (790, 1), (795, 1), (800, 1), (805, 1), (810, 0), (815, 1), (820, 1), (825, 1), (830, 1), (835, 1), (840, 1), (845, 1), (850, 1), (855, 1), (860, 1), (865, 1), (870, 0), (875, 0), (880, 0), (885, 0), (890, 1), (895, 1), (900, 1), (905, 1), (910, 1), (915, 0), (920, 0), (925, 0), (930, 0), (935, 0), (940, 1), (945, 1), (950, 1), (955, 0), (960, 0), (965, 0), (970, 0), (975, 0), (980, 0), (985, 0), (990, 0), (995, 0), (1000, 0), (1005, 0), (1010, 1), (1015, 1), (1020, 1), (1025, 1)]
Vdin0_0  din0_0  0 PWL (0n 0.0v 4.745n 0.0v 4.755n 0.95v 9.745n 0.95v 9.755n 0.0v 14.745n 0.0v 14.755n 0.0v 19.745n 0.0v 19.755n 0.0v 24.745n 0.0v 24.755n 0.95v 29.745n 0.95v 29.755n 0.0v 34.745n 0.0v 34.755n 0.0v 39.745n 0.0v 39.755n 0.95v 44.745n 0.95v 44.755n 0.95v 49.745n 0.95v 49.755n 0.95v 54.745n 0.95v 54.755n 0.95v 59.745n 0.95v 59.755n 0.95v 64.745n 0.95v 64.755n 0.0v 69.745n 0.0v 69.755n 0.0v 74.745n 0.0v 74.755n 0.95v 79.745n 0.95v 79.755n 0.95v 84.745n 0.95v 84.755n 0.95v 89.745n 0.95v 89.755n 0.95v 94.745n 0.95v 94.755n 0.0v 99.745n 0.0v 99.755n 0.0v 104.745n 0.0v 104.755n 0.0v 109.745n 0.0v 109.755n 0.0v 114.745n 0.0v 114.755n 0.0v 119.745n 0.0v 119.755n 0.0v 124.745n 0.0v 124.755n 0.0v 129.745n 0.0v 129.755n 0.0v 134.745n 0.0v 134.755n 0.0v 139.745n 0.0v 139.755n 0.0v 144.745n 0.0v 144.755n 0.0v 149.745n 0.0v 149.755n 0.95v 154.745n 0.95v 154.755n 0.95v 159.745n 0.95v 159.755n 0.95v 164.745n 0.95v 164.755n 0.0v 169.745n 0.0v 169.755n 0.0v 174.745n 0.0v 174.755n 0.0v 179.745n 0.0v 179.755n 0.0v 184.745n 0.0v 184.755n 0.95v 189.745n 0.95v 189.755n 0.95v 194.745n 0.95v 194.755n 0.95v 199.745n 0.95v 199.755n 0.95v 204.745n 0.95v 204.755n 0.95v 209.745n 0.95v 209.755n 0.0v 214.745n 0.0v 214.755n 0.0v 219.745n 0.0v 219.755n 0.0v 224.745n 0.0v 224.755n 0.95v 229.745n 0.95v 229.755n 0.0v 234.745n 0.0v 234.755n 0.0v 239.745n 0.0v 239.755n 0.0v 244.745n 0.0v 244.755n 0.0v 249.745n 0.0v 249.755n 0.0v 254.745n 0.0v 254.755n 0.0v 259.745n 0.0v 259.755n 0.0v 264.745n 0.0v 264.755n 0.0v 269.745n 0.0v 269.755n 0.0v 274.745n 0.0v 274.755n 0.0v 279.745n 0.0v 279.755n 0.0v 284.745n 0.0v 284.755n 0.0v 289.745n 0.0v 289.755n 0.0v 294.745n 0.0v 294.755n 0.0v 299.745n 0.0v 299.755n 0.0v 304.745n 0.0v 304.755n 0.95v 309.745n 0.95v 309.755n 0.95v 314.745n 0.95v 314.755n 0.95v 319.745n 0.95v 319.755n 0.0v 324.745n 0.0v 324.755n 0.0v 329.745n 0.0v 329.755n 0.0v 334.745n 0.0v 334.755n 0.0v 339.745n 0.0v 339.755n 0.0v 344.745n 0.0v 344.755n 0.0v 349.745n 0.0v 349.755n 0.0v 354.745n 0.0v 354.755n 0.0v 359.745n 0.0v 359.755n 0.0v 364.745n 0.0v 364.755n 0.95v 369.745n 0.95v 369.755n 0.95v 374.745n 0.95v 374.755n 0.95v 379.745n 0.95v 379.755n 0.95v 384.745n 0.95v 384.755n 0.95v 389.745n 0.95v 389.755n 0.95v 394.745n 0.95v 394.755n 0.95v 399.745n 0.95v 399.755n 0.0v 404.745n 0.0v 404.755n 0.0v 409.745n 0.0v 409.755n 0.0v 414.745n 0.0v 414.755n 0.0v 419.745n 0.0v 419.755n 0.95v 424.745n 0.95v 424.755n 0.95v 429.745n 0.95v 429.755n 0.95v 434.745n 0.95v 434.755n 0.95v 439.745n 0.95v 439.755n 0.95v 444.745n 0.95v 444.755n 0.0v 449.745n 0.0v 449.755n 0.0v 454.745n 0.0v 454.755n 0.0v 459.745n 0.0v 459.755n 0.0v 464.745n 0.0v 464.755n 0.0v 469.745n 0.0v 469.755n 0.0v 474.745n 0.0v 474.755n 0.0v 479.745n 0.0v 479.755n 0.0v 484.745n 0.0v 484.755n 0.0v 489.745n 0.0v 489.755n 0.0v 494.745n 0.0v 494.755n 0.0v 499.745n 0.0v 499.755n 0.0v 504.745n 0.0v 504.755n 0.0v 509.745n 0.0v 509.755n 0.95v 514.745n 0.95v 514.755n 0.0v 519.745n 0.0v 519.755n 0.0v 524.745n 0.0v 524.755n 0.0v 529.745n 0.0v 529.755n 0.0v 534.745n 0.0v 534.755n 0.0v 539.745n 0.0v 539.755n 0.0v 544.745n 0.0v 544.755n 0.0v 549.745n 0.0v 549.755n 0.0v 554.745n 0.0v 554.755n 0.0v 559.745n 0.0v 559.755n 0.95v 564.745n 0.95v 564.755n 0.0v 569.745n 0.0v 569.755n 0.0v 574.745n 0.0v 574.755n 0.0v 579.745n 0.0v 579.755n 0.95v 584.745n 0.95v 584.755n 0.95v 589.745n 0.95v 589.755n 0.95v 594.745n 0.95v 594.755n 0.95v 599.745n 0.95v 599.755n 0.95v 604.745n 0.95v 604.755n 0.0v 609.745n 0.0v 609.755n 0.0v 614.745n 0.0v 614.755n 0.95v 619.745n 0.95v 619.755n 0.95v 624.745n 0.95v 624.755n 0.95v 629.745n 0.95v 629.755n 0.95v 634.745n 0.95v 634.755n 0.95v 639.745n 0.95v 639.755n 0.95v 644.745n 0.95v 644.755n 0.95v 649.745n 0.95v 649.755n 0.95v 654.745n 0.95v 654.755n 0.95v 659.745n 0.95v 659.755n 0.95v 664.745n 0.95v 664.755n 0.95v 669.745n 0.95v 669.755n 0.95v 674.745n 0.95v 674.755n 0.95v 679.745n 0.95v 679.755n 0.95v 684.745n 0.95v 684.755n 0.95v 689.745n 0.95v 689.755n 0.95v 694.745n 0.95v 694.755n 0.95v 699.745n 0.95v 699.755n 0.0v 704.745n 0.0v 704.755n 0.0v 709.745n 0.0v 709.755n 0.0v 714.745n 0.0v 714.755n 0.0v 719.745n 0.0v 719.755n 0.0v 724.745n 0.0v 724.755n 0.0v 729.745n 0.0v 729.755n 0.0v 734.745n 0.0v 734.755n 0.95v 739.745n 0.95v 739.755n 0.95v 744.745n 0.95v 744.755n 0.95v 749.745n 0.95v 749.755n 0.95v 754.745n 0.95v 754.755n 0.95v 759.745n 0.95v 759.755n 0.95v 764.745n 0.95v 764.755n 0.95v 769.745n 0.95v 769.755n 0.95v 774.745n 0.95v 774.755n 0.95v 779.745n 0.95v 779.755n 0.95v 784.745n 0.95v 784.755n 0.95v 789.745n 0.95v 789.755n 0.95v 794.745n 0.95v 794.755n 0.95v 799.745n 0.95v 799.755n 0.95v 804.745n 0.95v 804.755n 0.95v 809.745n 0.95v 809.755n 0.0v 814.745n 0.0v 814.755n 0.95v 819.745n 0.95v 819.755n 0.95v 824.745n 0.95v 824.755n 0.95v 829.745n 0.95v 829.755n 0.95v 834.745n 0.95v 834.755n 0.95v 839.745n 0.95v 839.755n 0.95v 844.745n 0.95v 844.755n 0.95v 849.745n 0.95v 849.755n 0.95v 854.745n 0.95v 854.755n 0.95v 859.745n 0.95v 859.755n 0.95v 864.745n 0.95v 864.755n 0.95v 869.745n 0.95v 869.755n 0.0v 874.745n 0.0v 874.755n 0.0v 879.745n 0.0v 879.755n 0.0v 884.745n 0.0v 884.755n 0.0v 889.745n 0.0v 889.755n 0.95v 894.745n 0.95v 894.755n 0.95v 899.745n 0.95v 899.755n 0.95v 904.745n 0.95v 904.755n 0.95v 909.745n 0.95v 909.755n 0.95v 914.745n 0.95v 914.755n 0.0v 919.745n 0.0v 919.755n 0.0v 924.745n 0.0v 924.755n 0.0v 929.745n 0.0v 929.755n 0.0v 934.745n 0.0v 934.755n 0.0v 939.745n 0.0v 939.755n 0.95v 944.745n 0.95v 944.755n 0.95v 949.745n 0.95v 949.755n 0.95v 954.745n 0.95v 954.755n 0.0v 959.745n 0.0v 959.755n 0.0v 964.745n 0.0v 964.755n 0.0v 969.745n 0.0v 969.755n 0.0v 974.745n 0.0v 974.755n 0.0v 979.745n 0.0v 979.755n 0.0v 984.745n 0.0v 984.755n 0.0v 989.745n 0.0v 989.755n 0.0v 994.745n 0.0v 994.755n 0.0v 999.745n 0.0v 999.755n 0.0v 1004.745n 0.0v 1004.755n 0.0v 1009.745n 0.0v 1009.755n 0.95v 1014.745n 0.95v 1014.755n 0.95v 1019.745n 0.95v 1019.755n 0.95v 1024.745n 0.95v 1024.755n 0.95v )
* (time, data): [(0, 0), (5, 1), (10, 0), (15, 0), (20, 0), (25, 1), (30, 1), (35, 1), (40, 1), (45, 0), (50, 0), (55, 0), (60, 0), (65, 0), (70, 0), (75, 0), (80, 0), (85, 0), (90, 0), (95, 1), (100, 1), (105, 1), (110, 1), (115, 1), (120, 1), (125, 1), (130, 1), (135, 0), (140, 0), (145, 1), (150, 1), (155, 1), (160, 1), (165, 0), (170, 0), (175, 0), (180, 0), (185, 1), (190, 1), (195, 1), (200, 1), (205, 1), (210, 1), (215, 1), (220, 0), (225, 1), (230, 0), (235, 0), (240, 0), (245, 0), (250, 0), (255, 0), (260, 0), (265, 0), (270, 0), (275, 0), (280, 0), (285, 0), (290, 0), (295, 0), (300, 0), (305, 0), (310, 0), (315, 0), (320, 0), (325, 0), (330, 0), (335, 0), (340, 0), (345, 0), (350, 0), (355, 0), (360, 0), (365, 1), (370, 1), (375, 0), (380, 0), (385, 0), (390, 0), (395, 0), (400, 0), (405, 0), (410, 0), (415, 0), (420, 1), (425, 1), (430, 1), (435, 1), (440, 0), (445, 0), (450, 0), (455, 0), (460, 0), (465, 0), (470, 0), (475, 0), (480, 0), (485, 0), (490, 0), (495, 0), (500, 0), (505, 0), (510, 1), (515, 0), (520, 0), (525, 0), (530, 0), (535, 1), (540, 1), (545, 1), (550, 1), (555, 1), (560, 1), (565, 0), (570, 0), (575, 1), (580, 0), (585, 0), (590, 0), (595, 0), (600, 0), (605, 1), (610, 1), (615, 0), (620, 0), (625, 0), (630, 1), (635, 0), (640, 1), (645, 1), (650, 1), (655, 1), (660, 1), (665, 1), (670, 1), (675, 0), (680, 0), (685, 0), (690, 0), (695, 0), (700, 0), (705, 1), (710, 1), (715, 1), (720, 1), (725, 1), (730, 1), (735, 1), (740, 1), (745, 1), (750, 1), (755, 1), (760, 1), (765, 1), (770, 1), (775, 1), (780, 1), (785, 1), (790, 1), (795, 1), (800, 1), (805, 1), (810, 1), (815, 0), (820, 0), (825, 0), (830, 0), (835, 0), (840, 0), (845, 0), (850, 0), (855, 0), (860, 0), (865, 0), (870, 0), (875, 0), (880, 1), (885, 0), (890, 1), (895, 1), (900, 1), (905, 1), (910, 1), (915, 1), (920, 1), (925, 1), (930, 1), (935, 1), (940, 0), (945, 0), (950, 0), (955, 1), (960, 1), (965, 1), (970, 1), (975, 1), (980, 1), (985, 1), (990, 1), (995, 1), (1000, 1), (1005, 1), (1010, 0), (1015, 0), (1020, 0), (1025, 0)]
Vdin0_1  din0_1  0 PWL (0n 0.0v 4.745n 0.0v 4.755n 0.95v 9.745n 0.95v 9.755n 0.0v 14.745n 0.0v 14.755n 0.0v 19.745n 0.0v 19.755n 0.0v 24.745n 0.0v 24.755n 0.95v 29.745n 0.95v 29.755n 0.95v 34.745n 0.95v 34.755n 0.95v 39.745n 0.95v 39.755n 0.95v 44.745n 0.95v 44.755n 0.0v 49.745n 0.0v 49.755n 0.0v 54.745n 0.0v 54.755n 0.0v 59.745n 0.0v 59.755n 0.0v 64.745n 0.0v 64.755n 0.0v 69.745n 0.0v 69.755n 0.0v 74.745n 0.0v 74.755n 0.0v 79.745n 0.0v 79.755n 0.0v 84.745n 0.0v 84.755n 0.0v 89.745n 0.0v 89.755n 0.0v 94.745n 0.0v 94.755n 0.95v 99.745n 0.95v 99.755n 0.95v 104.745n 0.95v 104.755n 0.95v 109.745n 0.95v 109.755n 0.95v 114.745n 0.95v 114.755n 0.95v 119.745n 0.95v 119.755n 0.95v 124.745n 0.95v 124.755n 0.95v 129.745n 0.95v 129.755n 0.95v 134.745n 0.95v 134.755n 0.0v 139.745n 0.0v 139.755n 0.0v 144.745n 0.0v 144.755n 0.95v 149.745n 0.95v 149.755n 0.95v 154.745n 0.95v 154.755n 0.95v 159.745n 0.95v 159.755n 0.95v 164.745n 0.95v 164.755n 0.0v 169.745n 0.0v 169.755n 0.0v 174.745n 0.0v 174.755n 0.0v 179.745n 0.0v 179.755n 0.0v 184.745n 0.0v 184.755n 0.95v 189.745n 0.95v 189.755n 0.95v 194.745n 0.95v 194.755n 0.95v 199.745n 0.95v 199.755n 0.95v 204.745n 0.95v 204.755n 0.95v 209.745n 0.95v 209.755n 0.95v 214.745n 0.95v 214.755n 0.95v 219.745n 0.95v 219.755n 0.0v 224.745n 0.0v 224.755n 0.95v 229.745n 0.95v 229.755n 0.0v 234.745n 0.0v 234.755n 0.0v 239.745n 0.0v 239.755n 0.0v 244.745n 0.0v 244.755n 0.0v 249.745n 0.0v 249.755n 0.0v 254.745n 0.0v 254.755n 0.0v 259.745n 0.0v 259.755n 0.0v 264.745n 0.0v 264.755n 0.0v 269.745n 0.0v 269.755n 0.0v 274.745n 0.0v 274.755n 0.0v 279.745n 0.0v 279.755n 0.0v 284.745n 0.0v 284.755n 0.0v 289.745n 0.0v 289.755n 0.0v 294.745n 0.0v 294.755n 0.0v 299.745n 0.0v 299.755n 0.0v 304.745n 0.0v 304.755n 0.0v 309.745n 0.0v 309.755n 0.0v 314.745n 0.0v 314.755n 0.0v 319.745n 0.0v 319.755n 0.0v 324.745n 0.0v 324.755n 0.0v 329.745n 0.0v 329.755n 0.0v 334.745n 0.0v 334.755n 0.0v 339.745n 0.0v 339.755n 0.0v 344.745n 0.0v 344.755n 0.0v 349.745n 0.0v 349.755n 0.0v 354.745n 0.0v 354.755n 0.0v 359.745n 0.0v 359.755n 0.0v 364.745n 0.0v 364.755n 0.95v 369.745n 0.95v 369.755n 0.95v 374.745n 0.95v 374.755n 0.0v 379.745n 0.0v 379.755n 0.0v 384.745n 0.0v 384.755n 0.0v 389.745n 0.0v 389.755n 0.0v 394.745n 0.0v 394.755n 0.0v 399.745n 0.0v 399.755n 0.0v 404.745n 0.0v 404.755n 0.0v 409.745n 0.0v 409.755n 0.0v 414.745n 0.0v 414.755n 0.0v 419.745n 0.0v 419.755n 0.95v 424.745n 0.95v 424.755n 0.95v 429.745n 0.95v 429.755n 0.95v 434.745n 0.95v 434.755n 0.95v 439.745n 0.95v 439.755n 0.0v 444.745n 0.0v 444.755n 0.0v 449.745n 0.0v 449.755n 0.0v 454.745n 0.0v 454.755n 0.0v 459.745n 0.0v 459.755n 0.0v 464.745n 0.0v 464.755n 0.0v 469.745n 0.0v 469.755n 0.0v 474.745n 0.0v 474.755n 0.0v 479.745n 0.0v 479.755n 0.0v 484.745n 0.0v 484.755n 0.0v 489.745n 0.0v 489.755n 0.0v 494.745n 0.0v 494.755n 0.0v 499.745n 0.0v 499.755n 0.0v 504.745n 0.0v 504.755n 0.0v 509.745n 0.0v 509.755n 0.95v 514.745n 0.95v 514.755n 0.0v 519.745n 0.0v 519.755n 0.0v 524.745n 0.0v 524.755n 0.0v 529.745n 0.0v 529.755n 0.0v 534.745n 0.0v 534.755n 0.95v 539.745n 0.95v 539.755n 0.95v 544.745n 0.95v 544.755n 0.95v 549.745n 0.95v 549.755n 0.95v 554.745n 0.95v 554.755n 0.95v 559.745n 0.95v 559.755n 0.95v 564.745n 0.95v 564.755n 0.0v 569.745n 0.0v 569.755n 0.0v 574.745n 0.0v 574.755n 0.95v 579.745n 0.95v 579.755n 0.0v 584.745n 0.0v 584.755n 0.0v 589.745n 0.0v 589.755n 0.0v 594.745n 0.0v 594.755n 0.0v 599.745n 0.0v 599.755n 0.0v 604.745n 0.0v 604.755n 0.95v 609.745n 0.95v 609.755n 0.95v 614.745n 0.95v 614.755n 0.0v 619.745n 0.0v 619.755n 0.0v 624.745n 0.0v 624.755n 0.0v 629.745n 0.0v 629.755n 0.95v 634.745n 0.95v 634.755n 0.0v 639.745n 0.0v 639.755n 0.95v 644.745n 0.95v 644.755n 0.95v 649.745n 0.95v 649.755n 0.95v 654.745n 0.95v 654.755n 0.95v 659.745n 0.95v 659.755n 0.95v 664.745n 0.95v 664.755n 0.95v 669.745n 0.95v 669.755n 0.95v 674.745n 0.95v 674.755n 0.0v 679.745n 0.0v 679.755n 0.0v 684.745n 0.0v 684.755n 0.0v 689.745n 0.0v 689.755n 0.0v 694.745n 0.0v 694.755n 0.0v 699.745n 0.0v 699.755n 0.0v 704.745n 0.0v 704.755n 0.95v 709.745n 0.95v 709.755n 0.95v 714.745n 0.95v 714.755n 0.95v 719.745n 0.95v 719.755n 0.95v 724.745n 0.95v 724.755n 0.95v 729.745n 0.95v 729.755n 0.95v 734.745n 0.95v 734.755n 0.95v 739.745n 0.95v 739.755n 0.95v 744.745n 0.95v 744.755n 0.95v 749.745n 0.95v 749.755n 0.95v 754.745n 0.95v 754.755n 0.95v 759.745n 0.95v 759.755n 0.95v 764.745n 0.95v 764.755n 0.95v 769.745n 0.95v 769.755n 0.95v 774.745n 0.95v 774.755n 0.95v 779.745n 0.95v 779.755n 0.95v 784.745n 0.95v 784.755n 0.95v 789.745n 0.95v 789.755n 0.95v 794.745n 0.95v 794.755n 0.95v 799.745n 0.95v 799.755n 0.95v 804.745n 0.95v 804.755n 0.95v 809.745n 0.95v 809.755n 0.95v 814.745n 0.95v 814.755n 0.0v 819.745n 0.0v 819.755n 0.0v 824.745n 0.0v 824.755n 0.0v 829.745n 0.0v 829.755n 0.0v 834.745n 0.0v 834.755n 0.0v 839.745n 0.0v 839.755n 0.0v 844.745n 0.0v 844.755n 0.0v 849.745n 0.0v 849.755n 0.0v 854.745n 0.0v 854.755n 0.0v 859.745n 0.0v 859.755n 0.0v 864.745n 0.0v 864.755n 0.0v 869.745n 0.0v 869.755n 0.0v 874.745n 0.0v 874.755n 0.0v 879.745n 0.0v 879.755n 0.95v 884.745n 0.95v 884.755n 0.0v 889.745n 0.0v 889.755n 0.95v 894.745n 0.95v 894.755n 0.95v 899.745n 0.95v 899.755n 0.95v 904.745n 0.95v 904.755n 0.95v 909.745n 0.95v 909.755n 0.95v 914.745n 0.95v 914.755n 0.95v 919.745n 0.95v 919.755n 0.95v 924.745n 0.95v 924.755n 0.95v 929.745n 0.95v 929.755n 0.95v 934.745n 0.95v 934.755n 0.95v 939.745n 0.95v 939.755n 0.0v 944.745n 0.0v 944.755n 0.0v 949.745n 0.0v 949.755n 0.0v 954.745n 0.0v 954.755n 0.95v 959.745n 0.95v 959.755n 0.95v 964.745n 0.95v 964.755n 0.95v 969.745n 0.95v 969.755n 0.95v 974.745n 0.95v 974.755n 0.95v 979.745n 0.95v 979.755n 0.95v 984.745n 0.95v 984.755n 0.95v 989.745n 0.95v 989.755n 0.95v 994.745n 0.95v 994.755n 0.95v 999.745n 0.95v 999.755n 0.95v 1004.745n 0.95v 1004.755n 0.95v 1009.745n 0.95v 1009.755n 0.0v 1014.745n 0.0v 1014.755n 0.0v 1019.745n 0.0v 1019.755n 0.0v 1024.745n 0.0v 1024.755n 0.0v )
* (time, data): [(0, 0), (5, 0), (10, 0), (15, 0), (20, 0), (25, 0), (30, 1), (35, 1), (40, 0), (45, 1), (50, 1), (55, 1), (60, 0), (65, 1), (70, 1), (75, 0), (80, 0), (85, 0), (90, 0), (95, 0), (100, 0), (105, 0), (110, 0), (115, 0), (120, 0), (125, 0), (130, 0), (135, 0), (140, 1), (145, 0), (150, 1), (155, 1), (160, 1), (165, 0), (170, 0), (175, 0), (180, 0), (185, 0), (190, 0), (195, 0), (200, 0), (205, 0), (210, 1), (215, 1), (220, 0), (225, 1), (230, 1), (235, 1), (240, 1), (245, 0), (250, 0), (255, 0), (260, 0), (265, 0), (270, 0), (275, 0), (280, 0), (285, 0), (290, 0), (295, 0), (300, 0), (305, 0), (310, 0), (315, 0), (320, 0), (325, 0), (330, 0), (335, 0), (340, 0), (345, 0), (350, 0), (355, 0), (360, 0), (365, 0), (370, 0), (375, 0), (380, 1), (385, 1), (390, 1), (395, 1), (400, 1), (405, 1), (410, 1), (415, 1), (420, 1), (425, 1), (430, 1), (435, 1), (440, 0), (445, 0), (450, 0), (455, 0), (460, 0), (465, 1), (470, 1), (475, 1), (480, 1), (485, 1), (490, 1), (495, 1), (500, 1), (505, 1), (510, 0), (515, 0), (520, 0), (525, 0), (530, 0), (535, 1), (540, 1), (545, 1), (550, 0), (555, 0), (560, 0), (565, 0), (570, 0), (575, 0), (580, 1), (585, 1), (590, 1), (595, 1), (600, 1), (605, 0), (610, 0), (615, 0), (620, 0), (625, 0), (630, 0), (635, 1), (640, 0), (645, 0), (650, 0), (655, 0), (660, 0), (665, 0), (670, 1), (675, 0), (680, 0), (685, 0), (690, 0), (695, 0), (700, 1), (705, 1), (710, 1), (715, 1), (720, 1), (725, 1), (730, 1), (735, 0), (740, 0), (745, 1), (750, 1), (755, 1), (760, 1), (765, 1), (770, 0), (775, 0), (780, 0), (785, 0), (790, 0), (795, 0), (800, 0), (805, 0), (810, 1), (815, 1), (820, 1), (825, 1), (830, 1), (835, 1), (840, 1), (845, 1), (850, 1), (855, 1), (860, 1), (865, 1), (870, 0), (875, 0), (880, 0), (885, 0), (890, 1), (895, 1), (900, 1), (905, 1), (910, 1), (915, 0), (920, 0), (925, 0), (930, 0), (935, 0), (940, 1), (945, 1), (950, 1), (955, 0), (960, 0), (965, 1), (970, 1), (975, 1), (980, 1), (985, 1), (990, 1), (995, 1), (1000, 1), (1005, 1), (1010, 1), (1015, 1), (1020, 1), (1025, 1)]
Vdin0_2  din0_2  0 PWL (0n 0.0v 4.745n 0.0v 4.755n 0.0v 9.745n 0.0v 9.755n 0.0v 14.745n 0.0v 14.755n 0.0v 19.745n 0.0v 19.755n 0.0v 24.745n 0.0v 24.755n 0.0v 29.745n 0.0v 29.755n 0.95v 34.745n 0.95v 34.755n 0.95v 39.745n 0.95v 39.755n 0.0v 44.745n 0.0v 44.755n 0.95v 49.745n 0.95v 49.755n 0.95v 54.745n 0.95v 54.755n 0.95v 59.745n 0.95v 59.755n 0.0v 64.745n 0.0v 64.755n 0.95v 69.745n 0.95v 69.755n 0.95v 74.745n 0.95v 74.755n 0.0v 79.745n 0.0v 79.755n 0.0v 84.745n 0.0v 84.755n 0.0v 89.745n 0.0v 89.755n 0.0v 94.745n 0.0v 94.755n 0.0v 99.745n 0.0v 99.755n 0.0v 104.745n 0.0v 104.755n 0.0v 109.745n 0.0v 109.755n 0.0v 114.745n 0.0v 114.755n 0.0v 119.745n 0.0v 119.755n 0.0v 124.745n 0.0v 124.755n 0.0v 129.745n 0.0v 129.755n 0.0v 134.745n 0.0v 134.755n 0.0v 139.745n 0.0v 139.755n 0.95v 144.745n 0.95v 144.755n 0.0v 149.745n 0.0v 149.755n 0.95v 154.745n 0.95v 154.755n 0.95v 159.745n 0.95v 159.755n 0.95v 164.745n 0.95v 164.755n 0.0v 169.745n 0.0v 169.755n 0.0v 174.745n 0.0v 174.755n 0.0v 179.745n 0.0v 179.755n 0.0v 184.745n 0.0v 184.755n 0.0v 189.745n 0.0v 189.755n 0.0v 194.745n 0.0v 194.755n 0.0v 199.745n 0.0v 199.755n 0.0v 204.745n 0.0v 204.755n 0.0v 209.745n 0.0v 209.755n 0.95v 214.745n 0.95v 214.755n 0.95v 219.745n 0.95v 219.755n 0.0v 224.745n 0.0v 224.755n 0.95v 229.745n 0.95v 229.755n 0.95v 234.745n 0.95v 234.755n 0.95v 239.745n 0.95v 239.755n 0.95v 244.745n 0.95v 244.755n 0.0v 249.745n 0.0v 249.755n 0.0v 254.745n 0.0v 254.755n 0.0v 259.745n 0.0v 259.755n 0.0v 264.745n 0.0v 264.755n 0.0v 269.745n 0.0v 269.755n 0.0v 274.745n 0.0v 274.755n 0.0v 279.745n 0.0v 279.755n 0.0v 284.745n 0.0v 284.755n 0.0v 289.745n 0.0v 289.755n 0.0v 294.745n 0.0v 294.755n 0.0v 299.745n 0.0v 299.755n 0.0v 304.745n 0.0v 304.755n 0.0v 309.745n 0.0v 309.755n 0.0v 314.745n 0.0v 314.755n 0.0v 319.745n 0.0v 319.755n 0.0v 324.745n 0.0v 324.755n 0.0v 329.745n 0.0v 329.755n 0.0v 334.745n 0.0v 334.755n 0.0v 339.745n 0.0v 339.755n 0.0v 344.745n 0.0v 344.755n 0.0v 349.745n 0.0v 349.755n 0.0v 354.745n 0.0v 354.755n 0.0v 359.745n 0.0v 359.755n 0.0v 364.745n 0.0v 364.755n 0.0v 369.745n 0.0v 369.755n 0.0v 374.745n 0.0v 374.755n 0.0v 379.745n 0.0v 379.755n 0.95v 384.745n 0.95v 384.755n 0.95v 389.745n 0.95v 389.755n 0.95v 394.745n 0.95v 394.755n 0.95v 399.745n 0.95v 399.755n 0.95v 404.745n 0.95v 404.755n 0.95v 409.745n 0.95v 409.755n 0.95v 414.745n 0.95v 414.755n 0.95v 419.745n 0.95v 419.755n 0.95v 424.745n 0.95v 424.755n 0.95v 429.745n 0.95v 429.755n 0.95v 434.745n 0.95v 434.755n 0.95v 439.745n 0.95v 439.755n 0.0v 444.745n 0.0v 444.755n 0.0v 449.745n 0.0v 449.755n 0.0v 454.745n 0.0v 454.755n 0.0v 459.745n 0.0v 459.755n 0.0v 464.745n 0.0v 464.755n 0.95v 469.745n 0.95v 469.755n 0.95v 474.745n 0.95v 474.755n 0.95v 479.745n 0.95v 479.755n 0.95v 484.745n 0.95v 484.755n 0.95v 489.745n 0.95v 489.755n 0.95v 494.745n 0.95v 494.755n 0.95v 499.745n 0.95v 499.755n 0.95v 504.745n 0.95v 504.755n 0.95v 509.745n 0.95v 509.755n 0.0v 514.745n 0.0v 514.755n 0.0v 519.745n 0.0v 519.755n 0.0v 524.745n 0.0v 524.755n 0.0v 529.745n 0.0v 529.755n 0.0v 534.745n 0.0v 534.755n 0.95v 539.745n 0.95v 539.755n 0.95v 544.745n 0.95v 544.755n 0.95v 549.745n 0.95v 549.755n 0.0v 554.745n 0.0v 554.755n 0.0v 559.745n 0.0v 559.755n 0.0v 564.745n 0.0v 564.755n 0.0v 569.745n 0.0v 569.755n 0.0v 574.745n 0.0v 574.755n 0.0v 579.745n 0.0v 579.755n 0.95v 584.745n 0.95v 584.755n 0.95v 589.745n 0.95v 589.755n 0.95v 594.745n 0.95v 594.755n 0.95v 599.745n 0.95v 599.755n 0.95v 604.745n 0.95v 604.755n 0.0v 609.745n 0.0v 609.755n 0.0v 614.745n 0.0v 614.755n 0.0v 619.745n 0.0v 619.755n 0.0v 624.745n 0.0v 624.755n 0.0v 629.745n 0.0v 629.755n 0.0v 634.745n 0.0v 634.755n 0.95v 639.745n 0.95v 639.755n 0.0v 644.745n 0.0v 644.755n 0.0v 649.745n 0.0v 649.755n 0.0v 654.745n 0.0v 654.755n 0.0v 659.745n 0.0v 659.755n 0.0v 664.745n 0.0v 664.755n 0.0v 669.745n 0.0v 669.755n 0.95v 674.745n 0.95v 674.755n 0.0v 679.745n 0.0v 679.755n 0.0v 684.745n 0.0v 684.755n 0.0v 689.745n 0.0v 689.755n 0.0v 694.745n 0.0v 694.755n 0.0v 699.745n 0.0v 699.755n 0.95v 704.745n 0.95v 704.755n 0.95v 709.745n 0.95v 709.755n 0.95v 714.745n 0.95v 714.755n 0.95v 719.745n 0.95v 719.755n 0.95v 724.745n 0.95v 724.755n 0.95v 729.745n 0.95v 729.755n 0.95v 734.745n 0.95v 734.755n 0.0v 739.745n 0.0v 739.755n 0.0v 744.745n 0.0v 744.755n 0.95v 749.745n 0.95v 749.755n 0.95v 754.745n 0.95v 754.755n 0.95v 759.745n 0.95v 759.755n 0.95v 764.745n 0.95v 764.755n 0.95v 769.745n 0.95v 769.755n 0.0v 774.745n 0.0v 774.755n 0.0v 779.745n 0.0v 779.755n 0.0v 784.745n 0.0v 784.755n 0.0v 789.745n 0.0v 789.755n 0.0v 794.745n 0.0v 794.755n 0.0v 799.745n 0.0v 799.755n 0.0v 804.745n 0.0v 804.755n 0.0v 809.745n 0.0v 809.755n 0.95v 814.745n 0.95v 814.755n 0.95v 819.745n 0.95v 819.755n 0.95v 824.745n 0.95v 824.755n 0.95v 829.745n 0.95v 829.755n 0.95v 834.745n 0.95v 834.755n 0.95v 839.745n 0.95v 839.755n 0.95v 844.745n 0.95v 844.755n 0.95v 849.745n 0.95v 849.755n 0.95v 854.745n 0.95v 854.755n 0.95v 859.745n 0.95v 859.755n 0.95v 864.745n 0.95v 864.755n 0.95v 869.745n 0.95v 869.755n 0.0v 874.745n 0.0v 874.755n 0.0v 879.745n 0.0v 879.755n 0.0v 884.745n 0.0v 884.755n 0.0v 889.745n 0.0v 889.755n 0.95v 894.745n 0.95v 894.755n 0.95v 899.745n 0.95v 899.755n 0.95v 904.745n 0.95v 904.755n 0.95v 909.745n 0.95v 909.755n 0.95v 914.745n 0.95v 914.755n 0.0v 919.745n 0.0v 919.755n 0.0v 924.745n 0.0v 924.755n 0.0v 929.745n 0.0v 929.755n 0.0v 934.745n 0.0v 934.755n 0.0v 939.745n 0.0v 939.755n 0.95v 944.745n 0.95v 944.755n 0.95v 949.745n 0.95v 949.755n 0.95v 954.745n 0.95v 954.755n 0.0v 959.745n 0.0v 959.755n 0.0v 964.745n 0.0v 964.755n 0.95v 969.745n 0.95v 969.755n 0.95v 974.745n 0.95v 974.755n 0.95v 979.745n 0.95v 979.755n 0.95v 984.745n 0.95v 984.755n 0.95v 989.745n 0.95v 989.755n 0.95v 994.745n 0.95v 994.755n 0.95v 999.745n 0.95v 999.755n 0.95v 1004.745n 0.95v 1004.755n 0.95v 1009.745n 0.95v 1009.755n 0.95v 1014.745n 0.95v 1014.755n 0.95v 1019.745n 0.95v 1019.755n 0.95v 1024.745n 0.95v 1024.755n 0.95v )
* (time, data): [(0, 0), (5, 1), (10, 1), (15, 1), (20, 1), (25, 1), (30, 1), (35, 1), (40, 0), (45, 1), (50, 1), (55, 1), (60, 0), (65, 1), (70, 1), (75, 0), (80, 0), (85, 0), (90, 0), (95, 0), (100, 0), (105, 0), (110, 0), (115, 0), (120, 0), (125, 0), (130, 0), (135, 1), (140, 0), (145, 0), (150, 0), (155, 0), (160, 0), (165, 1), (170, 1), (175, 1), (180, 1), (185, 0), (190, 0), (195, 0), (200, 0), (205, 0), (210, 0), (215, 0), (220, 0), (225, 1), (230, 1), (235, 1), (240, 1), (245, 0), (250, 0), (255, 0), (260, 0), (265, 0), (270, 1), (275, 1), (280, 1), (285, 1), (290, 1), (295, 1), (300, 1), (305, 0), (310, 0), (315, 0), (320, 1), (325, 1), (330, 1), (335, 1), (340, 1), (345, 1), (350, 1), (355, 1), (360, 1), (365, 1), (370, 1), (375, 1), (380, 0), (385, 0), (390, 0), (395, 0), (400, 0), (405, 0), (410, 0), (415, 0), (420, 1), (425, 1), (430, 1), (435, 1), (440, 0), (445, 0), (450, 1), (455, 1), (460, 1), (465, 0), (470, 0), (475, 0), (480, 0), (485, 0), (490, 0), (495, 0), (500, 0), (505, 1), (510, 1), (515, 0), (520, 0), (525, 0), (530, 0), (535, 1), (540, 1), (545, 1), (550, 0), (555, 0), (560, 0), (565, 1), (570, 1), (575, 0), (580, 1), (585, 1), (590, 1), (595, 1), (600, 1), (605, 0), (610, 0), (615, 1), (620, 1), (625, 1), (630, 0), (635, 1), (640, 1), (645, 1), (650, 1), (655, 0), (660, 0), (665, 0), (670, 0), (675, 0), (680, 0), (685, 0), (690, 0), (695, 0), (700, 0), (705, 0), (710, 0), (715, 0), (720, 0), (725, 0), (730, 0), (735, 0), (740, 0), (745, 1), (750, 1), (755, 1), (760, 1), (765, 1), (770, 0), (775, 0), (780, 0), (785, 0), (790, 0), (795, 0), (800, 0), (805, 0), (810, 1), (815, 1), (820, 1), (825, 1), (830, 1), (835, 1), (840, 1), (845, 1), (850, 1), (855, 1), (860, 1), (865, 1), (870, 0), (875, 0), (880, 0), (885, 0), (890, 0), (895, 0), (900, 1), (905, 1), (910, 1), (915, 1), (920, 1), (925, 1), (930, 1), (935, 1), (940, 0), (945, 0), (950, 0), (955, 1), (960, 1), (965, 1), (970, 1), (975, 1), (980, 1), (985, 1), (990, 1), (995, 1), (1000, 1), (1005, 1), (1010, 0), (1015, 0), (1020, 0), (1025, 0)]
Vdin0_3  din0_3  0 PWL (0n 0.0v 4.745n 0.0v 4.755n 0.95v 9.745n 0.95v 9.755n 0.95v 14.745n 0.95v 14.755n 0.95v 19.745n 0.95v 19.755n 0.95v 24.745n 0.95v 24.755n 0.95v 29.745n 0.95v 29.755n 0.95v 34.745n 0.95v 34.755n 0.95v 39.745n 0.95v 39.755n 0.0v 44.745n 0.0v 44.755n 0.95v 49.745n 0.95v 49.755n 0.95v 54.745n 0.95v 54.755n 0.95v 59.745n 0.95v 59.755n 0.0v 64.745n 0.0v 64.755n 0.95v 69.745n 0.95v 69.755n 0.95v 74.745n 0.95v 74.755n 0.0v 79.745n 0.0v 79.755n 0.0v 84.745n 0.0v 84.755n 0.0v 89.745n 0.0v 89.755n 0.0v 94.745n 0.0v 94.755n 0.0v 99.745n 0.0v 99.755n 0.0v 104.745n 0.0v 104.755n 0.0v 109.745n 0.0v 109.755n 0.0v 114.745n 0.0v 114.755n 0.0v 119.745n 0.0v 119.755n 0.0v 124.745n 0.0v 124.755n 0.0v 129.745n 0.0v 129.755n 0.0v 134.745n 0.0v 134.755n 0.95v 139.745n 0.95v 139.755n 0.0v 144.745n 0.0v 144.755n 0.0v 149.745n 0.0v 149.755n 0.0v 154.745n 0.0v 154.755n 0.0v 159.745n 0.0v 159.755n 0.0v 164.745n 0.0v 164.755n 0.95v 169.745n 0.95v 169.755n 0.95v 174.745n 0.95v 174.755n 0.95v 179.745n 0.95v 179.755n 0.95v 184.745n 0.95v 184.755n 0.0v 189.745n 0.0v 189.755n 0.0v 194.745n 0.0v 194.755n 0.0v 199.745n 0.0v 199.755n 0.0v 204.745n 0.0v 204.755n 0.0v 209.745n 0.0v 209.755n 0.0v 214.745n 0.0v 214.755n 0.0v 219.745n 0.0v 219.755n 0.0v 224.745n 0.0v 224.755n 0.95v 229.745n 0.95v 229.755n 0.95v 234.745n 0.95v 234.755n 0.95v 239.745n 0.95v 239.755n 0.95v 244.745n 0.95v 244.755n 0.0v 249.745n 0.0v 249.755n 0.0v 254.745n 0.0v 254.755n 0.0v 259.745n 0.0v 259.755n 0.0v 264.745n 0.0v 264.755n 0.0v 269.745n 0.0v 269.755n 0.95v 274.745n 0.95v 274.755n 0.95v 279.745n 0.95v 279.755n 0.95v 284.745n 0.95v 284.755n 0.95v 289.745n 0.95v 289.755n 0.95v 294.745n 0.95v 294.755n 0.95v 299.745n 0.95v 299.755n 0.95v 304.745n 0.95v 304.755n 0.0v 309.745n 0.0v 309.755n 0.0v 314.745n 0.0v 314.755n 0.0v 319.745n 0.0v 319.755n 0.95v 324.745n 0.95v 324.755n 0.95v 329.745n 0.95v 329.755n 0.95v 334.745n 0.95v 334.755n 0.95v 339.745n 0.95v 339.755n 0.95v 344.745n 0.95v 344.755n 0.95v 349.745n 0.95v 349.755n 0.95v 354.745n 0.95v 354.755n 0.95v 359.745n 0.95v 359.755n 0.95v 364.745n 0.95v 364.755n 0.95v 369.745n 0.95v 369.755n 0.95v 374.745n 0.95v 374.755n 0.95v 379.745n 0.95v 379.755n 0.0v 384.745n 0.0v 384.755n 0.0v 389.745n 0.0v 389.755n 0.0v 394.745n 0.0v 394.755n 0.0v 399.745n 0.0v 399.755n 0.0v 404.745n 0.0v 404.755n 0.0v 409.745n 0.0v 409.755n 0.0v 414.745n 0.0v 414.755n 0.0v 419.745n 0.0v 419.755n 0.95v 424.745n 0.95v 424.755n 0.95v 429.745n 0.95v 429.755n 0.95v 434.745n 0.95v 434.755n 0.95v 439.745n 0.95v 439.755n 0.0v 444.745n 0.0v 444.755n 0.0v 449.745n 0.0v 449.755n 0.95v 454.745n 0.95v 454.755n 0.95v 459.745n 0.95v 459.755n 0.95v 464.745n 0.95v 464.755n 0.0v 469.745n 0.0v 469.755n 0.0v 474.745n 0.0v 474.755n 0.0v 479.745n 0.0v 479.755n 0.0v 484.745n 0.0v 484.755n 0.0v 489.745n 0.0v 489.755n 0.0v 494.745n 0.0v 494.755n 0.0v 499.745n 0.0v 499.755n 0.0v 504.745n 0.0v 504.755n 0.95v 509.745n 0.95v 509.755n 0.95v 514.745n 0.95v 514.755n 0.0v 519.745n 0.0v 519.755n 0.0v 524.745n 0.0v 524.755n 0.0v 529.745n 0.0v 529.755n 0.0v 534.745n 0.0v 534.755n 0.95v 539.745n 0.95v 539.755n 0.95v 544.745n 0.95v 544.755n 0.95v 549.745n 0.95v 549.755n 0.0v 554.745n 0.0v 554.755n 0.0v 559.745n 0.0v 559.755n 0.0v 564.745n 0.0v 564.755n 0.95v 569.745n 0.95v 569.755n 0.95v 574.745n 0.95v 574.755n 0.0v 579.745n 0.0v 579.755n 0.95v 584.745n 0.95v 584.755n 0.95v 589.745n 0.95v 589.755n 0.95v 594.745n 0.95v 594.755n 0.95v 599.745n 0.95v 599.755n 0.95v 604.745n 0.95v 604.755n 0.0v 609.745n 0.0v 609.755n 0.0v 614.745n 0.0v 614.755n 0.95v 619.745n 0.95v 619.755n 0.95v 624.745n 0.95v 624.755n 0.95v 629.745n 0.95v 629.755n 0.0v 634.745n 0.0v 634.755n 0.95v 639.745n 0.95v 639.755n 0.95v 644.745n 0.95v 644.755n 0.95v 649.745n 0.95v 649.755n 0.95v 654.745n 0.95v 654.755n 0.0v 659.745n 0.0v 659.755n 0.0v 664.745n 0.0v 664.755n 0.0v 669.745n 0.0v 669.755n 0.0v 674.745n 0.0v 674.755n 0.0v 679.745n 0.0v 679.755n 0.0v 684.745n 0.0v 684.755n 0.0v 689.745n 0.0v 689.755n 0.0v 694.745n 0.0v 694.755n 0.0v 699.745n 0.0v 699.755n 0.0v 704.745n 0.0v 704.755n 0.0v 709.745n 0.0v 709.755n 0.0v 714.745n 0.0v 714.755n 0.0v 719.745n 0.0v 719.755n 0.0v 724.745n 0.0v 724.755n 0.0v 729.745n 0.0v 729.755n 0.0v 734.745n 0.0v 734.755n 0.0v 739.745n 0.0v 739.755n 0.0v 744.745n 0.0v 744.755n 0.95v 749.745n 0.95v 749.755n 0.95v 754.745n 0.95v 754.755n 0.95v 759.745n 0.95v 759.755n 0.95v 764.745n 0.95v 764.755n 0.95v 769.745n 0.95v 769.755n 0.0v 774.745n 0.0v 774.755n 0.0v 779.745n 0.0v 779.755n 0.0v 784.745n 0.0v 784.755n 0.0v 789.745n 0.0v 789.755n 0.0v 794.745n 0.0v 794.755n 0.0v 799.745n 0.0v 799.755n 0.0v 804.745n 0.0v 804.755n 0.0v 809.745n 0.0v 809.755n 0.95v 814.745n 0.95v 814.755n 0.95v 819.745n 0.95v 819.755n 0.95v 824.745n 0.95v 824.755n 0.95v 829.745n 0.95v 829.755n 0.95v 834.745n 0.95v 834.755n 0.95v 839.745n 0.95v 839.755n 0.95v 844.745n 0.95v 844.755n 0.95v 849.745n 0.95v 849.755n 0.95v 854.745n 0.95v 854.755n 0.95v 859.745n 0.95v 859.755n 0.95v 864.745n 0.95v 864.755n 0.95v 869.745n 0.95v 869.755n 0.0v 874.745n 0.0v 874.755n 0.0v 879.745n 0.0v 879.755n 0.0v 884.745n 0.0v 884.755n 0.0v 889.745n 0.0v 889.755n 0.0v 894.745n 0.0v 894.755n 0.0v 899.745n 0.0v 899.755n 0.95v 904.745n 0.95v 904.755n 0.95v 909.745n 0.95v 909.755n 0.95v 914.745n 0.95v 914.755n 0.95v 919.745n 0.95v 919.755n 0.95v 924.745n 0.95v 924.755n 0.95v 929.745n 0.95v 929.755n 0.95v 934.745n 0.95v 934.755n 0.95v 939.745n 0.95v 939.755n 0.0v 944.745n 0.0v 944.755n 0.0v 949.745n 0.0v 949.755n 0.0v 954.745n 0.0v 954.755n 0.95v 959.745n 0.95v 959.755n 0.95v 964.745n 0.95v 964.755n 0.95v 969.745n 0.95v 969.755n 0.95v 974.745n 0.95v 974.755n 0.95v 979.745n 0.95v 979.755n 0.95v 984.745n 0.95v 984.755n 0.95v 989.745n 0.95v 989.755n 0.95v 994.745n 0.95v 994.755n 0.95v 999.745n 0.95v 999.755n 0.95v 1004.745n 0.95v 1004.755n 0.95v 1009.745n 0.95v 1009.755n 0.0v 1014.745n 0.0v 1014.755n 0.0v 1019.745n 0.0v 1019.755n 0.0v 1024.745n 0.0v 1024.755n 0.0v )
* (time, data): [(0, 0), (5, 0), (10, 1), (15, 0), (20, 0), (25, 1), (30, 1), (35, 1), (40, 0), (45, 1), (50, 1), (55, 1), (60, 0), (65, 1), (70, 1), (75, 1), (80, 1), (85, 1), (90, 1), (95, 1), (100, 1), (105, 1), (110, 1), (115, 1), (120, 1), (125, 1), (130, 1), (135, 1), (140, 0), (145, 0), (150, 0), (155, 0), (160, 0), (165, 0), (170, 0), (175, 0), (180, 0), (185, 1), (190, 1), (195, 1), (200, 1), (205, 1), (210, 1), (215, 1), (220, 0), (225, 0), (230, 0), (235, 0), (240, 0), (245, 1), (250, 1), (255, 1), (260, 1), (265, 1), (270, 1), (275, 1), (280, 1), (285, 1), (290, 1), (295, 1), (300, 1), (305, 1), (310, 1), (315, 1), (320, 1), (325, 1), (330, 1), (335, 1), (340, 1), (345, 1), (350, 1), (355, 1), (360, 1), (365, 0), (370, 0), (375, 1), (380, 1), (385, 1), (390, 1), (395, 1), (400, 0), (405, 0), (410, 0), (415, 0), (420, 0), (425, 0), (430, 0), (435, 0), (440, 1), (445, 0), (450, 0), (455, 0), (460, 0), (465, 0), (470, 0), (475, 0), (480, 0), (485, 0), (490, 0), (495, 0), (500, 0), (505, 0), (510, 1), (515, 1), (520, 1), (525, 1), (530, 1), (535, 1), (540, 1), (545, 1), (550, 0), (555, 0), (560, 1), (565, 0), (570, 0), (575, 1), (580, 0), (585, 0), (590, 0), (595, 0), (600, 0), (605, 0), (610, 0), (615, 1), (620, 1), (625, 1), (630, 1), (635, 1), (640, 0), (645, 0), (650, 0), (655, 0), (660, 0), (665, 0), (670, 1), (675, 1), (680, 1), (685, 1), (690, 1), (695, 1), (700, 0), (705, 1), (710, 1), (715, 1), (720, 1), (725, 1), (730, 1), (735, 0), (740, 0), (745, 1), (750, 1), (755, 1), (760, 1), (765, 1), (770, 1), (775, 1), (780, 1), (785, 1), (790, 1), (795, 1), (800, 1), (805, 1), (810, 1), (815, 1), (820, 1), (825, 1), (830, 1), (835, 1), (840, 1), (845, 1), (850, 1), (855, 1), (860, 1), (865, 1), (870, 0), (875, 0), (880, 0), (885, 1), (890, 1), (895, 0), (900, 1), (905, 1), (910, 1), (915, 1), (920, 1), (925, 1), (930, 1), (935, 1), (940, 0), (945, 0), (950, 0), (955, 1), (960, 1), (965, 0), (970, 0), (975, 0), (980, 0), (985, 0), (990, 0), (995, 0), (1000, 0), (1005, 0), (1010, 0), (1015, 0), (1020, 0), (1025, 0)]
Vdin0_4  din0_4  0 PWL (0n 0.0v 4.745n 0.0v 4.755n 0.0v 9.745n 0.0v 9.755n 0.95v 14.745n 0.95v 14.755n 0.0v 19.745n 0.0v 19.755n 0.0v 24.745n 0.0v 24.755n 0.95v 29.745n 0.95v 29.755n 0.95v 34.745n 0.95v 34.755n 0.95v 39.745n 0.95v 39.755n 0.0v 44.745n 0.0v 44.755n 0.95v 49.745n 0.95v 49.755n 0.95v 54.745n 0.95v 54.755n 0.95v 59.745n 0.95v 59.755n 0.0v 64.745n 0.0v 64.755n 0.95v 69.745n 0.95v 69.755n 0.95v 74.745n 0.95v 74.755n 0.95v 79.745n 0.95v 79.755n 0.95v 84.745n 0.95v 84.755n 0.95v 89.745n 0.95v 89.755n 0.95v 94.745n 0.95v 94.755n 0.95v 99.745n 0.95v 99.755n 0.95v 104.745n 0.95v 104.755n 0.95v 109.745n 0.95v 109.755n 0.95v 114.745n 0.95v 114.755n 0.95v 119.745n 0.95v 119.755n 0.95v 124.745n 0.95v 124.755n 0.95v 129.745n 0.95v 129.755n 0.95v 134.745n 0.95v 134.755n 0.95v 139.745n 0.95v 139.755n 0.0v 144.745n 0.0v 144.755n 0.0v 149.745n 0.0v 149.755n 0.0v 154.745n 0.0v 154.755n 0.0v 159.745n 0.0v 159.755n 0.0v 164.745n 0.0v 164.755n 0.0v 169.745n 0.0v 169.755n 0.0v 174.745n 0.0v 174.755n 0.0v 179.745n 0.0v 179.755n 0.0v 184.745n 0.0v 184.755n 0.95v 189.745n 0.95v 189.755n 0.95v 194.745n 0.95v 194.755n 0.95v 199.745n 0.95v 199.755n 0.95v 204.745n 0.95v 204.755n 0.95v 209.745n 0.95v 209.755n 0.95v 214.745n 0.95v 214.755n 0.95v 219.745n 0.95v 219.755n 0.0v 224.745n 0.0v 224.755n 0.0v 229.745n 0.0v 229.755n 0.0v 234.745n 0.0v 234.755n 0.0v 239.745n 0.0v 239.755n 0.0v 244.745n 0.0v 244.755n 0.95v 249.745n 0.95v 249.755n 0.95v 254.745n 0.95v 254.755n 0.95v 259.745n 0.95v 259.755n 0.95v 264.745n 0.95v 264.755n 0.95v 269.745n 0.95v 269.755n 0.95v 274.745n 0.95v 274.755n 0.95v 279.745n 0.95v 279.755n 0.95v 284.745n 0.95v 284.755n 0.95v 289.745n 0.95v 289.755n 0.95v 294.745n 0.95v 294.755n 0.95v 299.745n 0.95v 299.755n 0.95v 304.745n 0.95v 304.755n 0.95v 309.745n 0.95v 309.755n 0.95v 314.745n 0.95v 314.755n 0.95v 319.745n 0.95v 319.755n 0.95v 324.745n 0.95v 324.755n 0.95v 329.745n 0.95v 329.755n 0.95v 334.745n 0.95v 334.755n 0.95v 339.745n 0.95v 339.755n 0.95v 344.745n 0.95v 344.755n 0.95v 349.745n 0.95v 349.755n 0.95v 354.745n 0.95v 354.755n 0.95v 359.745n 0.95v 359.755n 0.95v 364.745n 0.95v 364.755n 0.0v 369.745n 0.0v 369.755n 0.0v 374.745n 0.0v 374.755n 0.95v 379.745n 0.95v 379.755n 0.95v 384.745n 0.95v 384.755n 0.95v 389.745n 0.95v 389.755n 0.95v 394.745n 0.95v 394.755n 0.95v 399.745n 0.95v 399.755n 0.0v 404.745n 0.0v 404.755n 0.0v 409.745n 0.0v 409.755n 0.0v 414.745n 0.0v 414.755n 0.0v 419.745n 0.0v 419.755n 0.0v 424.745n 0.0v 424.755n 0.0v 429.745n 0.0v 429.755n 0.0v 434.745n 0.0v 434.755n 0.0v 439.745n 0.0v 439.755n 0.95v 444.745n 0.95v 444.755n 0.0v 449.745n 0.0v 449.755n 0.0v 454.745n 0.0v 454.755n 0.0v 459.745n 0.0v 459.755n 0.0v 464.745n 0.0v 464.755n 0.0v 469.745n 0.0v 469.755n 0.0v 474.745n 0.0v 474.755n 0.0v 479.745n 0.0v 479.755n 0.0v 484.745n 0.0v 484.755n 0.0v 489.745n 0.0v 489.755n 0.0v 494.745n 0.0v 494.755n 0.0v 499.745n 0.0v 499.755n 0.0v 504.745n 0.0v 504.755n 0.0v 509.745n 0.0v 509.755n 0.95v 514.745n 0.95v 514.755n 0.95v 519.745n 0.95v 519.755n 0.95v 524.745n 0.95v 524.755n 0.95v 529.745n 0.95v 529.755n 0.95v 534.745n 0.95v 534.755n 0.95v 539.745n 0.95v 539.755n 0.95v 544.745n 0.95v 544.755n 0.95v 549.745n 0.95v 549.755n 0.0v 554.745n 0.0v 554.755n 0.0v 559.745n 0.0v 559.755n 0.95v 564.745n 0.95v 564.755n 0.0v 569.745n 0.0v 569.755n 0.0v 574.745n 0.0v 574.755n 0.95v 579.745n 0.95v 579.755n 0.0v 584.745n 0.0v 584.755n 0.0v 589.745n 0.0v 589.755n 0.0v 594.745n 0.0v 594.755n 0.0v 599.745n 0.0v 599.755n 0.0v 604.745n 0.0v 604.755n 0.0v 609.745n 0.0v 609.755n 0.0v 614.745n 0.0v 614.755n 0.95v 619.745n 0.95v 619.755n 0.95v 624.745n 0.95v 624.755n 0.95v 629.745n 0.95v 629.755n 0.95v 634.745n 0.95v 634.755n 0.95v 639.745n 0.95v 639.755n 0.0v 644.745n 0.0v 644.755n 0.0v 649.745n 0.0v 649.755n 0.0v 654.745n 0.0v 654.755n 0.0v 659.745n 0.0v 659.755n 0.0v 664.745n 0.0v 664.755n 0.0v 669.745n 0.0v 669.755n 0.95v 674.745n 0.95v 674.755n 0.95v 679.745n 0.95v 679.755n 0.95v 684.745n 0.95v 684.755n 0.95v 689.745n 0.95v 689.755n 0.95v 694.745n 0.95v 694.755n 0.95v 699.745n 0.95v 699.755n 0.0v 704.745n 0.0v 704.755n 0.95v 709.745n 0.95v 709.755n 0.95v 714.745n 0.95v 714.755n 0.95v 719.745n 0.95v 719.755n 0.95v 724.745n 0.95v 724.755n 0.95v 729.745n 0.95v 729.755n 0.95v 734.745n 0.95v 734.755n 0.0v 739.745n 0.0v 739.755n 0.0v 744.745n 0.0v 744.755n 0.95v 749.745n 0.95v 749.755n 0.95v 754.745n 0.95v 754.755n 0.95v 759.745n 0.95v 759.755n 0.95v 764.745n 0.95v 764.755n 0.95v 769.745n 0.95v 769.755n 0.95v 774.745n 0.95v 774.755n 0.95v 779.745n 0.95v 779.755n 0.95v 784.745n 0.95v 784.755n 0.95v 789.745n 0.95v 789.755n 0.95v 794.745n 0.95v 794.755n 0.95v 799.745n 0.95v 799.755n 0.95v 804.745n 0.95v 804.755n 0.95v 809.745n 0.95v 809.755n 0.95v 814.745n 0.95v 814.755n 0.95v 819.745n 0.95v 819.755n 0.95v 824.745n 0.95v 824.755n 0.95v 829.745n 0.95v 829.755n 0.95v 834.745n 0.95v 834.755n 0.95v 839.745n 0.95v 839.755n 0.95v 844.745n 0.95v 844.755n 0.95v 849.745n 0.95v 849.755n 0.95v 854.745n 0.95v 854.755n 0.95v 859.745n 0.95v 859.755n 0.95v 864.745n 0.95v 864.755n 0.95v 869.745n 0.95v 869.755n 0.0v 874.745n 0.0v 874.755n 0.0v 879.745n 0.0v 879.755n 0.0v 884.745n 0.0v 884.755n 0.95v 889.745n 0.95v 889.755n 0.95v 894.745n 0.95v 894.755n 0.0v 899.745n 0.0v 899.755n 0.95v 904.745n 0.95v 904.755n 0.95v 909.745n 0.95v 909.755n 0.95v 914.745n 0.95v 914.755n 0.95v 919.745n 0.95v 919.755n 0.95v 924.745n 0.95v 924.755n 0.95v 929.745n 0.95v 929.755n 0.95v 934.745n 0.95v 934.755n 0.95v 939.745n 0.95v 939.755n 0.0v 944.745n 0.0v 944.755n 0.0v 949.745n 0.0v 949.755n 0.0v 954.745n 0.0v 954.755n 0.95v 959.745n 0.95v 959.755n 0.95v 964.745n 0.95v 964.755n 0.0v 969.745n 0.0v 969.755n 0.0v 974.745n 0.0v 974.755n 0.0v 979.745n 0.0v 979.755n 0.0v 984.745n 0.0v 984.755n 0.0v 989.745n 0.0v 989.755n 0.0v 994.745n 0.0v 994.755n 0.0v 999.745n 0.0v 999.755n 0.0v 1004.745n 0.0v 1004.755n 0.0v 1009.745n 0.0v 1009.755n 0.0v 1014.745n 0.0v 1014.755n 0.0v 1019.745n 0.0v 1019.755n 0.0v 1024.745n 0.0v 1024.755n 0.0v )
* (time, data): [(0, 0), (5, 0), (10, 0), (15, 1), (20, 1), (25, 0), (30, 1), (35, 1), (40, 0), (45, 1), (50, 1), (55, 1), (60, 0), (65, 1), (70, 1), (75, 0), (80, 0), (85, 0), (90, 0), (95, 1), (100, 1), (105, 1), (110, 1), (115, 1), (120, 1), (125, 1), (130, 1), (135, 0), (140, 1), (145, 0), (150, 1), (155, 1), (160, 1), (165, 1), (170, 1), (175, 1), (180, 1), (185, 0), (190, 0), (195, 0), (200, 0), (205, 0), (210, 1), (215, 1), (220, 0), (225, 0), (230, 0), (235, 0), (240, 0), (245, 0), (250, 0), (255, 0), (260, 0), (265, 0), (270, 0), (275, 0), (280, 0), (285, 0), (290, 0), (295, 0), (300, 0), (305, 1), (310, 1), (315, 1), (320, 0), (325, 0), (330, 0), (335, 0), (340, 0), (345, 0), (350, 0), (355, 0), (360, 0), (365, 0), (370, 0), (375, 0), (380, 0), (385, 0), (390, 0), (395, 0), (400, 1), (405, 1), (410, 1), (415, 1), (420, 1), (425, 1), (430, 1), (435, 1), (440, 1), (445, 0), (450, 0), (455, 0), (460, 0), (465, 1), (470, 1), (475, 1), (480, 1), (485, 1), (490, 1), (495, 1), (500, 1), (505, 0), (510, 0), (515, 1), (520, 1), (525, 1), (530, 1), (535, 1), (540, 1), (545, 1), (550, 1), (555, 1), (560, 0), (565, 0), (570, 0), (575, 0), (580, 0), (585, 0), (590, 0), (595, 0), (600, 0), (605, 0), (610, 0), (615, 1), (620, 1), (625, 1), (630, 1), (635, 1), (640, 0), (645, 0), (650, 0), (655, 1), (660, 1), (665, 1), (670, 1), (675, 1), (680, 1), (685, 1), (690, 1), (695, 1), (700, 0), (705, 0), (710, 0), (715, 0), (720, 0), (725, 0), (730, 0), (735, 0), (740, 0), (745, 0), (750, 0), (755, 0), (760, 0), (765, 0), (770, 0), (775, 0), (780, 0), (785, 0), (790, 0), (795, 0), (800, 0), (805, 0), (810, 0), (815, 0), (820, 0), (825, 0), (830, 0), (835, 0), (840, 0), (845, 0), (850, 0), (855, 0), (860, 0), (865, 0), (870, 1), (875, 1), (880, 0), (885, 0), (890, 0), (895, 0), (900, 0), (905, 0), (910, 0), (915, 0), (920, 0), (925, 0), (930, 0), (935, 0), (940, 1), (945, 1), (950, 1), (955, 1), (960, 1), (965, 0), (970, 0), (975, 0), (980, 0), (985, 0), (990, 0), (995, 0), (1000, 0), (1005, 0), (1010, 0), (1015, 0), (1020, 0), (1025, 0)]
Vdin0_5  din0_5  0 PWL (0n 0.0v 4.745n 0.0v 4.755n 0.0v 9.745n 0.0v 9.755n 0.0v 14.745n 0.0v 14.755n 0.95v 19.745n 0.95v 19.755n 0.95v 24.745n 0.95v 24.755n 0.0v 29.745n 0.0v 29.755n 0.95v 34.745n 0.95v 34.755n 0.95v 39.745n 0.95v 39.755n 0.0v 44.745n 0.0v 44.755n 0.95v 49.745n 0.95v 49.755n 0.95v 54.745n 0.95v 54.755n 0.95v 59.745n 0.95v 59.755n 0.0v 64.745n 0.0v 64.755n 0.95v 69.745n 0.95v 69.755n 0.95v 74.745n 0.95v 74.755n 0.0v 79.745n 0.0v 79.755n 0.0v 84.745n 0.0v 84.755n 0.0v 89.745n 0.0v 89.755n 0.0v 94.745n 0.0v 94.755n 0.95v 99.745n 0.95v 99.755n 0.95v 104.745n 0.95v 104.755n 0.95v 109.745n 0.95v 109.755n 0.95v 114.745n 0.95v 114.755n 0.95v 119.745n 0.95v 119.755n 0.95v 124.745n 0.95v 124.755n 0.95v 129.745n 0.95v 129.755n 0.95v 134.745n 0.95v 134.755n 0.0v 139.745n 0.0v 139.755n 0.95v 144.745n 0.95v 144.755n 0.0v 149.745n 0.0v 149.755n 0.95v 154.745n 0.95v 154.755n 0.95v 159.745n 0.95v 159.755n 0.95v 164.745n 0.95v 164.755n 0.95v 169.745n 0.95v 169.755n 0.95v 174.745n 0.95v 174.755n 0.95v 179.745n 0.95v 179.755n 0.95v 184.745n 0.95v 184.755n 0.0v 189.745n 0.0v 189.755n 0.0v 194.745n 0.0v 194.755n 0.0v 199.745n 0.0v 199.755n 0.0v 204.745n 0.0v 204.755n 0.0v 209.745n 0.0v 209.755n 0.95v 214.745n 0.95v 214.755n 0.95v 219.745n 0.95v 219.755n 0.0v 224.745n 0.0v 224.755n 0.0v 229.745n 0.0v 229.755n 0.0v 234.745n 0.0v 234.755n 0.0v 239.745n 0.0v 239.755n 0.0v 244.745n 0.0v 244.755n 0.0v 249.745n 0.0v 249.755n 0.0v 254.745n 0.0v 254.755n 0.0v 259.745n 0.0v 259.755n 0.0v 264.745n 0.0v 264.755n 0.0v 269.745n 0.0v 269.755n 0.0v 274.745n 0.0v 274.755n 0.0v 279.745n 0.0v 279.755n 0.0v 284.745n 0.0v 284.755n 0.0v 289.745n 0.0v 289.755n 0.0v 294.745n 0.0v 294.755n 0.0v 299.745n 0.0v 299.755n 0.0v 304.745n 0.0v 304.755n 0.95v 309.745n 0.95v 309.755n 0.95v 314.745n 0.95v 314.755n 0.95v 319.745n 0.95v 319.755n 0.0v 324.745n 0.0v 324.755n 0.0v 329.745n 0.0v 329.755n 0.0v 334.745n 0.0v 334.755n 0.0v 339.745n 0.0v 339.755n 0.0v 344.745n 0.0v 344.755n 0.0v 349.745n 0.0v 349.755n 0.0v 354.745n 0.0v 354.755n 0.0v 359.745n 0.0v 359.755n 0.0v 364.745n 0.0v 364.755n 0.0v 369.745n 0.0v 369.755n 0.0v 374.745n 0.0v 374.755n 0.0v 379.745n 0.0v 379.755n 0.0v 384.745n 0.0v 384.755n 0.0v 389.745n 0.0v 389.755n 0.0v 394.745n 0.0v 394.755n 0.0v 399.745n 0.0v 399.755n 0.95v 404.745n 0.95v 404.755n 0.95v 409.745n 0.95v 409.755n 0.95v 414.745n 0.95v 414.755n 0.95v 419.745n 0.95v 419.755n 0.95v 424.745n 0.95v 424.755n 0.95v 429.745n 0.95v 429.755n 0.95v 434.745n 0.95v 434.755n 0.95v 439.745n 0.95v 439.755n 0.95v 444.745n 0.95v 444.755n 0.0v 449.745n 0.0v 449.755n 0.0v 454.745n 0.0v 454.755n 0.0v 459.745n 0.0v 459.755n 0.0v 464.745n 0.0v 464.755n 0.95v 469.745n 0.95v 469.755n 0.95v 474.745n 0.95v 474.755n 0.95v 479.745n 0.95v 479.755n 0.95v 484.745n 0.95v 484.755n 0.95v 489.745n 0.95v 489.755n 0.95v 494.745n 0.95v 494.755n 0.95v 499.745n 0.95v 499.755n 0.95v 504.745n 0.95v 504.755n 0.0v 509.745n 0.0v 509.755n 0.0v 514.745n 0.0v 514.755n 0.95v 519.745n 0.95v 519.755n 0.95v 524.745n 0.95v 524.755n 0.95v 529.745n 0.95v 529.755n 0.95v 534.745n 0.95v 534.755n 0.95v 539.745n 0.95v 539.755n 0.95v 544.745n 0.95v 544.755n 0.95v 549.745n 0.95v 549.755n 0.95v 554.745n 0.95v 554.755n 0.95v 559.745n 0.95v 559.755n 0.0v 564.745n 0.0v 564.755n 0.0v 569.745n 0.0v 569.755n 0.0v 574.745n 0.0v 574.755n 0.0v 579.745n 0.0v 579.755n 0.0v 584.745n 0.0v 584.755n 0.0v 589.745n 0.0v 589.755n 0.0v 594.745n 0.0v 594.755n 0.0v 599.745n 0.0v 599.755n 0.0v 604.745n 0.0v 604.755n 0.0v 609.745n 0.0v 609.755n 0.0v 614.745n 0.0v 614.755n 0.95v 619.745n 0.95v 619.755n 0.95v 624.745n 0.95v 624.755n 0.95v 629.745n 0.95v 629.755n 0.95v 634.745n 0.95v 634.755n 0.95v 639.745n 0.95v 639.755n 0.0v 644.745n 0.0v 644.755n 0.0v 649.745n 0.0v 649.755n 0.0v 654.745n 0.0v 654.755n 0.95v 659.745n 0.95v 659.755n 0.95v 664.745n 0.95v 664.755n 0.95v 669.745n 0.95v 669.755n 0.95v 674.745n 0.95v 674.755n 0.95v 679.745n 0.95v 679.755n 0.95v 684.745n 0.95v 684.755n 0.95v 689.745n 0.95v 689.755n 0.95v 694.745n 0.95v 694.755n 0.95v 699.745n 0.95v 699.755n 0.0v 704.745n 0.0v 704.755n 0.0v 709.745n 0.0v 709.755n 0.0v 714.745n 0.0v 714.755n 0.0v 719.745n 0.0v 719.755n 0.0v 724.745n 0.0v 724.755n 0.0v 729.745n 0.0v 729.755n 0.0v 734.745n 0.0v 734.755n 0.0v 739.745n 0.0v 739.755n 0.0v 744.745n 0.0v 744.755n 0.0v 749.745n 0.0v 749.755n 0.0v 754.745n 0.0v 754.755n 0.0v 759.745n 0.0v 759.755n 0.0v 764.745n 0.0v 764.755n 0.0v 769.745n 0.0v 769.755n 0.0v 774.745n 0.0v 774.755n 0.0v 779.745n 0.0v 779.755n 0.0v 784.745n 0.0v 784.755n 0.0v 789.745n 0.0v 789.755n 0.0v 794.745n 0.0v 794.755n 0.0v 799.745n 0.0v 799.755n 0.0v 804.745n 0.0v 804.755n 0.0v 809.745n 0.0v 809.755n 0.0v 814.745n 0.0v 814.755n 0.0v 819.745n 0.0v 819.755n 0.0v 824.745n 0.0v 824.755n 0.0v 829.745n 0.0v 829.755n 0.0v 834.745n 0.0v 834.755n 0.0v 839.745n 0.0v 839.755n 0.0v 844.745n 0.0v 844.755n 0.0v 849.745n 0.0v 849.755n 0.0v 854.745n 0.0v 854.755n 0.0v 859.745n 0.0v 859.755n 0.0v 864.745n 0.0v 864.755n 0.0v 869.745n 0.0v 869.755n 0.95v 874.745n 0.95v 874.755n 0.95v 879.745n 0.95v 879.755n 0.0v 884.745n 0.0v 884.755n 0.0v 889.745n 0.0v 889.755n 0.0v 894.745n 0.0v 894.755n 0.0v 899.745n 0.0v 899.755n 0.0v 904.745n 0.0v 904.755n 0.0v 909.745n 0.0v 909.755n 0.0v 914.745n 0.0v 914.755n 0.0v 919.745n 0.0v 919.755n 0.0v 924.745n 0.0v 924.755n 0.0v 929.745n 0.0v 929.755n 0.0v 934.745n 0.0v 934.755n 0.0v 939.745n 0.0v 939.755n 0.95v 944.745n 0.95v 944.755n 0.95v 949.745n 0.95v 949.755n 0.95v 954.745n 0.95v 954.755n 0.95v 959.745n 0.95v 959.755n 0.95v 964.745n 0.95v 964.755n 0.0v 969.745n 0.0v 969.755n 0.0v 974.745n 0.0v 974.755n 0.0v 979.745n 0.0v 979.755n 0.0v 984.745n 0.0v 984.755n 0.0v 989.745n 0.0v 989.755n 0.0v 994.745n 0.0v 994.755n 0.0v 999.745n 0.0v 999.755n 0.0v 1004.745n 0.0v 1004.755n 0.0v 1009.745n 0.0v 1009.755n 0.0v 1014.745n 0.0v 1014.755n 0.0v 1019.745n 0.0v 1019.755n 0.0v 1024.745n 0.0v 1024.755n 0.0v )
* (time, data): [(0, 0), (5, 0), (10, 0), (15, 1), (20, 1), (25, 0), (30, 1), (35, 1), (40, 1), (45, 0), (50, 0), (55, 0), (60, 1), (65, 1), (70, 1), (75, 1), (80, 1), (85, 1), (90, 1), (95, 0), (100, 0), (105, 0), (110, 0), (115, 0), (120, 0), (125, 0), (130, 0), (135, 1), (140, 1), (145, 0), (150, 0), (155, 0), (160, 0), (165, 1), (170, 1), (175, 1), (180, 1), (185, 1), (190, 1), (195, 1), (200, 1), (205, 1), (210, 0), (215, 0), (220, 1), (225, 0), (230, 1), (235, 1), (240, 1), (245, 1), (250, 1), (255, 1), (260, 1), (265, 1), (270, 1), (275, 1), (280, 1), (285, 1), (290, 1), (295, 1), (300, 1), (305, 0), (310, 0), (315, 0), (320, 1), (325, 1), (330, 1), (335, 1), (340, 1), (345, 1), (350, 1), (355, 1), (360, 1), (365, 1), (370, 1), (375, 0), (380, 0), (385, 0), (390, 0), (395, 0), (400, 1), (405, 1), (410, 1), (415, 1), (420, 0), (425, 0), (430, 0), (435, 0), (440, 0), (445, 1), (450, 0), (455, 0), (460, 0), (465, 1), (470, 1), (475, 1), (480, 1), (485, 1), (490, 1), (495, 1), (500, 1), (505, 1), (510, 1), (515, 0), (520, 0), (525, 0), (530, 0), (535, 0), (540, 0), (545, 0), (550, 0), (555, 0), (560, 0), (565, 1), (570, 1), (575, 1), (580, 1), (585, 1), (590, 1), (595, 1), (600, 1), (605, 0), (610, 0), (615, 0), (620, 0), (625, 0), (630, 0), (635, 1), (640, 0), (645, 0), (650, 0), (655, 1), (660, 1), (665, 1), (670, 0), (675, 0), (680, 0), (685, 0), (690, 0), (695, 0), (700, 1), (705, 0), (710, 0), (715, 0), (720, 0), (725, 0), (730, 0), (735, 0), (740, 0), (745, 1), (750, 1), (755, 1), (760, 1), (765, 1), (770, 1), (775, 1), (780, 1), (785, 1), (790, 1), (795, 1), (800, 1), (805, 1), (810, 1), (815, 0), (820, 0), (825, 0), (830, 0), (835, 0), (840, 0), (845, 0), (850, 0), (855, 0), (860, 0), (865, 0), (870, 1), (875, 1), (880, 1), (885, 0), (890, 0), (895, 1), (900, 0), (905, 0), (910, 0), (915, 1), (920, 1), (925, 1), (930, 1), (935, 1), (940, 1), (945, 1), (950, 1), (955, 0), (960, 0), (965, 1), (970, 1), (975, 1), (980, 1), (985, 1), (990, 1), (995, 1), (1000, 1), (1005, 1), (1010, 0), (1015, 0), (1020, 0), (1025, 0)]
Vdin0_6  din0_6  0 PWL (0n 0.0v 4.745n 0.0v 4.755n 0.0v 9.745n 0.0v 9.755n 0.0v 14.745n 0.0v 14.755n 0.95v 19.745n 0.95v 19.755n 0.95v 24.745n 0.95v 24.755n 0.0v 29.745n 0.0v 29.755n 0.95v 34.745n 0.95v 34.755n 0.95v 39.745n 0.95v 39.755n 0.95v 44.745n 0.95v 44.755n 0.0v 49.745n 0.0v 49.755n 0.0v 54.745n 0.0v 54.755n 0.0v 59.745n 0.0v 59.755n 0.95v 64.745n 0.95v 64.755n 0.95v 69.745n 0.95v 69.755n 0.95v 74.745n 0.95v 74.755n 0.95v 79.745n 0.95v 79.755n 0.95v 84.745n 0.95v 84.755n 0.95v 89.745n 0.95v 89.755n 0.95v 94.745n 0.95v 94.755n 0.0v 99.745n 0.0v 99.755n 0.0v 104.745n 0.0v 104.755n 0.0v 109.745n 0.0v 109.755n 0.0v 114.745n 0.0v 114.755n 0.0v 119.745n 0.0v 119.755n 0.0v 124.745n 0.0v 124.755n 0.0v 129.745n 0.0v 129.755n 0.0v 134.745n 0.0v 134.755n 0.95v 139.745n 0.95v 139.755n 0.95v 144.745n 0.95v 144.755n 0.0v 149.745n 0.0v 149.755n 0.0v 154.745n 0.0v 154.755n 0.0v 159.745n 0.0v 159.755n 0.0v 164.745n 0.0v 164.755n 0.95v 169.745n 0.95v 169.755n 0.95v 174.745n 0.95v 174.755n 0.95v 179.745n 0.95v 179.755n 0.95v 184.745n 0.95v 184.755n 0.95v 189.745n 0.95v 189.755n 0.95v 194.745n 0.95v 194.755n 0.95v 199.745n 0.95v 199.755n 0.95v 204.745n 0.95v 204.755n 0.95v 209.745n 0.95v 209.755n 0.0v 214.745n 0.0v 214.755n 0.0v 219.745n 0.0v 219.755n 0.95v 224.745n 0.95v 224.755n 0.0v 229.745n 0.0v 229.755n 0.95v 234.745n 0.95v 234.755n 0.95v 239.745n 0.95v 239.755n 0.95v 244.745n 0.95v 244.755n 0.95v 249.745n 0.95v 249.755n 0.95v 254.745n 0.95v 254.755n 0.95v 259.745n 0.95v 259.755n 0.95v 264.745n 0.95v 264.755n 0.95v 269.745n 0.95v 269.755n 0.95v 274.745n 0.95v 274.755n 0.95v 279.745n 0.95v 279.755n 0.95v 284.745n 0.95v 284.755n 0.95v 289.745n 0.95v 289.755n 0.95v 294.745n 0.95v 294.755n 0.95v 299.745n 0.95v 299.755n 0.95v 304.745n 0.95v 304.755n 0.0v 309.745n 0.0v 309.755n 0.0v 314.745n 0.0v 314.755n 0.0v 319.745n 0.0v 319.755n 0.95v 324.745n 0.95v 324.755n 0.95v 329.745n 0.95v 329.755n 0.95v 334.745n 0.95v 334.755n 0.95v 339.745n 0.95v 339.755n 0.95v 344.745n 0.95v 344.755n 0.95v 349.745n 0.95v 349.755n 0.95v 354.745n 0.95v 354.755n 0.95v 359.745n 0.95v 359.755n 0.95v 364.745n 0.95v 364.755n 0.95v 369.745n 0.95v 369.755n 0.95v 374.745n 0.95v 374.755n 0.0v 379.745n 0.0v 379.755n 0.0v 384.745n 0.0v 384.755n 0.0v 389.745n 0.0v 389.755n 0.0v 394.745n 0.0v 394.755n 0.0v 399.745n 0.0v 399.755n 0.95v 404.745n 0.95v 404.755n 0.95v 409.745n 0.95v 409.755n 0.95v 414.745n 0.95v 414.755n 0.95v 419.745n 0.95v 419.755n 0.0v 424.745n 0.0v 424.755n 0.0v 429.745n 0.0v 429.755n 0.0v 434.745n 0.0v 434.755n 0.0v 439.745n 0.0v 439.755n 0.0v 444.745n 0.0v 444.755n 0.95v 449.745n 0.95v 449.755n 0.0v 454.745n 0.0v 454.755n 0.0v 459.745n 0.0v 459.755n 0.0v 464.745n 0.0v 464.755n 0.95v 469.745n 0.95v 469.755n 0.95v 474.745n 0.95v 474.755n 0.95v 479.745n 0.95v 479.755n 0.95v 484.745n 0.95v 484.755n 0.95v 489.745n 0.95v 489.755n 0.95v 494.745n 0.95v 494.755n 0.95v 499.745n 0.95v 499.755n 0.95v 504.745n 0.95v 504.755n 0.95v 509.745n 0.95v 509.755n 0.95v 514.745n 0.95v 514.755n 0.0v 519.745n 0.0v 519.755n 0.0v 524.745n 0.0v 524.755n 0.0v 529.745n 0.0v 529.755n 0.0v 534.745n 0.0v 534.755n 0.0v 539.745n 0.0v 539.755n 0.0v 544.745n 0.0v 544.755n 0.0v 549.745n 0.0v 549.755n 0.0v 554.745n 0.0v 554.755n 0.0v 559.745n 0.0v 559.755n 0.0v 564.745n 0.0v 564.755n 0.95v 569.745n 0.95v 569.755n 0.95v 574.745n 0.95v 574.755n 0.95v 579.745n 0.95v 579.755n 0.95v 584.745n 0.95v 584.755n 0.95v 589.745n 0.95v 589.755n 0.95v 594.745n 0.95v 594.755n 0.95v 599.745n 0.95v 599.755n 0.95v 604.745n 0.95v 604.755n 0.0v 609.745n 0.0v 609.755n 0.0v 614.745n 0.0v 614.755n 0.0v 619.745n 0.0v 619.755n 0.0v 624.745n 0.0v 624.755n 0.0v 629.745n 0.0v 629.755n 0.0v 634.745n 0.0v 634.755n 0.95v 639.745n 0.95v 639.755n 0.0v 644.745n 0.0v 644.755n 0.0v 649.745n 0.0v 649.755n 0.0v 654.745n 0.0v 654.755n 0.95v 659.745n 0.95v 659.755n 0.95v 664.745n 0.95v 664.755n 0.95v 669.745n 0.95v 669.755n 0.0v 674.745n 0.0v 674.755n 0.0v 679.745n 0.0v 679.755n 0.0v 684.745n 0.0v 684.755n 0.0v 689.745n 0.0v 689.755n 0.0v 694.745n 0.0v 694.755n 0.0v 699.745n 0.0v 699.755n 0.95v 704.745n 0.95v 704.755n 0.0v 709.745n 0.0v 709.755n 0.0v 714.745n 0.0v 714.755n 0.0v 719.745n 0.0v 719.755n 0.0v 724.745n 0.0v 724.755n 0.0v 729.745n 0.0v 729.755n 0.0v 734.745n 0.0v 734.755n 0.0v 739.745n 0.0v 739.755n 0.0v 744.745n 0.0v 744.755n 0.95v 749.745n 0.95v 749.755n 0.95v 754.745n 0.95v 754.755n 0.95v 759.745n 0.95v 759.755n 0.95v 764.745n 0.95v 764.755n 0.95v 769.745n 0.95v 769.755n 0.95v 774.745n 0.95v 774.755n 0.95v 779.745n 0.95v 779.755n 0.95v 784.745n 0.95v 784.755n 0.95v 789.745n 0.95v 789.755n 0.95v 794.745n 0.95v 794.755n 0.95v 799.745n 0.95v 799.755n 0.95v 804.745n 0.95v 804.755n 0.95v 809.745n 0.95v 809.755n 0.95v 814.745n 0.95v 814.755n 0.0v 819.745n 0.0v 819.755n 0.0v 824.745n 0.0v 824.755n 0.0v 829.745n 0.0v 829.755n 0.0v 834.745n 0.0v 834.755n 0.0v 839.745n 0.0v 839.755n 0.0v 844.745n 0.0v 844.755n 0.0v 849.745n 0.0v 849.755n 0.0v 854.745n 0.0v 854.755n 0.0v 859.745n 0.0v 859.755n 0.0v 864.745n 0.0v 864.755n 0.0v 869.745n 0.0v 869.755n 0.95v 874.745n 0.95v 874.755n 0.95v 879.745n 0.95v 879.755n 0.95v 884.745n 0.95v 884.755n 0.0v 889.745n 0.0v 889.755n 0.0v 894.745n 0.0v 894.755n 0.95v 899.745n 0.95v 899.755n 0.0v 904.745n 0.0v 904.755n 0.0v 909.745n 0.0v 909.755n 0.0v 914.745n 0.0v 914.755n 0.95v 919.745n 0.95v 919.755n 0.95v 924.745n 0.95v 924.755n 0.95v 929.745n 0.95v 929.755n 0.95v 934.745n 0.95v 934.755n 0.95v 939.745n 0.95v 939.755n 0.95v 944.745n 0.95v 944.755n 0.95v 949.745n 0.95v 949.755n 0.95v 954.745n 0.95v 954.755n 0.0v 959.745n 0.0v 959.755n 0.0v 964.745n 0.0v 964.755n 0.95v 969.745n 0.95v 969.755n 0.95v 974.745n 0.95v 974.755n 0.95v 979.745n 0.95v 979.755n 0.95v 984.745n 0.95v 984.755n 0.95v 989.745n 0.95v 989.755n 0.95v 994.745n 0.95v 994.755n 0.95v 999.745n 0.95v 999.755n 0.95v 1004.745n 0.95v 1004.755n 0.95v 1009.745n 0.95v 1009.755n 0.0v 1014.745n 0.0v 1014.755n 0.0v 1019.745n 0.0v 1019.755n 0.0v 1024.745n 0.0v 1024.755n 0.0v )
* (time, data): [(0, 0), (5, 0), (10, 1), (15, 1), (20, 1), (25, 1), (30, 0), (35, 0), (40, 1), (45, 1), (50, 1), (55, 1), (60, 0), (65, 0), (70, 0), (75, 1), (80, 1), (85, 1), (90, 1), (95, 0), (100, 0), (105, 0), (110, 0), (115, 0), (120, 0), (125, 0), (130, 0), (135, 1), (140, 1), (145, 1), (150, 1), (155, 1), (160, 1), (165, 1), (170, 1), (175, 1), (180, 1), (185, 0), (190, 0), (195, 0), (200, 0), (205, 0), (210, 1), (215, 1), (220, 0), (225, 0), (230, 0), (235, 0), (240, 0), (245, 1), (250, 1), (255, 1), (260, 1), (265, 1), (270, 0), (275, 0), (280, 0), (285, 0), (290, 0), (295, 0), (300, 0), (305, 0), (310, 0), (315, 0), (320, 0), (325, 0), (330, 0), (335, 0), (340, 0), (345, 0), (350, 0), (355, 0), (360, 0), (365, 1), (370, 1), (375, 0), (380, 0), (385, 0), (390, 0), (395, 0), (400, 0), (405, 0), (410, 0), (415, 0), (420, 0), (425, 0), (430, 0), (435, 0), (440, 1), (445, 1), (450, 1), (455, 1), (460, 1), (465, 1), (470, 1), (475, 1), (480, 1), (485, 1), (490, 1), (495, 1), (500, 1), (505, 0), (510, 1), (515, 1), (520, 1), (525, 1), (530, 1), (535, 1), (540, 1), (545, 1), (550, 1), (555, 1), (560, 1), (565, 0), (570, 0), (575, 0), (580, 1), (585, 1), (590, 1), (595, 1), (600, 1), (605, 1), (610, 1), (615, 0), (620, 0), (625, 0), (630, 0), (635, 0), (640, 0), (645, 0), (650, 0), (655, 1), (660, 1), (665, 1), (670, 1), (675, 0), (680, 0), (685, 0), (690, 0), (695, 0), (700, 1), (705, 0), (710, 0), (715, 0), (720, 0), (725, 0), (730, 0), (735, 1), (740, 1), (745, 0), (750, 0), (755, 0), (760, 0), (765, 0), (770, 1), (775, 1), (780, 1), (785, 1), (790, 1), (795, 1), (800, 1), (805, 1), (810, 1), (815, 0), (820, 0), (825, 0), (830, 0), (835, 0), (840, 0), (845, 0), (850, 0), (855, 0), (860, 0), (865, 0), (870, 1), (875, 1), (880, 0), (885, 1), (890, 0), (895, 1), (900, 1), (905, 1), (910, 1), (915, 0), (920, 0), (925, 0), (930, 0), (935, 0), (940, 1), (945, 1), (950, 1), (955, 1), (960, 1), (965, 1), (970, 1), (975, 1), (980, 1), (985, 1), (990, 1), (995, 1), (1000, 1), (1005, 1), (1010, 1), (1015, 1), (1020, 1), (1025, 1)]
Vdin0_7  din0_7  0 PWL (0n 0.0v 4.745n 0.0v 4.755n 0.0v 9.745n 0.0v 9.755n 0.95v 14.745n 0.95v 14.755n 0.95v 19.745n 0.95v 19.755n 0.95v 24.745n 0.95v 24.755n 0.95v 29.745n 0.95v 29.755n 0.0v 34.745n 0.0v 34.755n 0.0v 39.745n 0.0v 39.755n 0.95v 44.745n 0.95v 44.755n 0.95v 49.745n 0.95v 49.755n 0.95v 54.745n 0.95v 54.755n 0.95v 59.745n 0.95v 59.755n 0.0v 64.745n 0.0v 64.755n 0.0v 69.745n 0.0v 69.755n 0.0v 74.745n 0.0v 74.755n 0.95v 79.745n 0.95v 79.755n 0.95v 84.745n 0.95v 84.755n 0.95v 89.745n 0.95v 89.755n 0.95v 94.745n 0.95v 94.755n 0.0v 99.745n 0.0v 99.755n 0.0v 104.745n 0.0v 104.755n 0.0v 109.745n 0.0v 109.755n 0.0v 114.745n 0.0v 114.755n 0.0v 119.745n 0.0v 119.755n 0.0v 124.745n 0.0v 124.755n 0.0v 129.745n 0.0v 129.755n 0.0v 134.745n 0.0v 134.755n 0.95v 139.745n 0.95v 139.755n 0.95v 144.745n 0.95v 144.755n 0.95v 149.745n 0.95v 149.755n 0.95v 154.745n 0.95v 154.755n 0.95v 159.745n 0.95v 159.755n 0.95v 164.745n 0.95v 164.755n 0.95v 169.745n 0.95v 169.755n 0.95v 174.745n 0.95v 174.755n 0.95v 179.745n 0.95v 179.755n 0.95v 184.745n 0.95v 184.755n 0.0v 189.745n 0.0v 189.755n 0.0v 194.745n 0.0v 194.755n 0.0v 199.745n 0.0v 199.755n 0.0v 204.745n 0.0v 204.755n 0.0v 209.745n 0.0v 209.755n 0.95v 214.745n 0.95v 214.755n 0.95v 219.745n 0.95v 219.755n 0.0v 224.745n 0.0v 224.755n 0.0v 229.745n 0.0v 229.755n 0.0v 234.745n 0.0v 234.755n 0.0v 239.745n 0.0v 239.755n 0.0v 244.745n 0.0v 244.755n 0.95v 249.745n 0.95v 249.755n 0.95v 254.745n 0.95v 254.755n 0.95v 259.745n 0.95v 259.755n 0.95v 264.745n 0.95v 264.755n 0.95v 269.745n 0.95v 269.755n 0.0v 274.745n 0.0v 274.755n 0.0v 279.745n 0.0v 279.755n 0.0v 284.745n 0.0v 284.755n 0.0v 289.745n 0.0v 289.755n 0.0v 294.745n 0.0v 294.755n 0.0v 299.745n 0.0v 299.755n 0.0v 304.745n 0.0v 304.755n 0.0v 309.745n 0.0v 309.755n 0.0v 314.745n 0.0v 314.755n 0.0v 319.745n 0.0v 319.755n 0.0v 324.745n 0.0v 324.755n 0.0v 329.745n 0.0v 329.755n 0.0v 334.745n 0.0v 334.755n 0.0v 339.745n 0.0v 339.755n 0.0v 344.745n 0.0v 344.755n 0.0v 349.745n 0.0v 349.755n 0.0v 354.745n 0.0v 354.755n 0.0v 359.745n 0.0v 359.755n 0.0v 364.745n 0.0v 364.755n 0.95v 369.745n 0.95v 369.755n 0.95v 374.745n 0.95v 374.755n 0.0v 379.745n 0.0v 379.755n 0.0v 384.745n 0.0v 384.755n 0.0v 389.745n 0.0v 389.755n 0.0v 394.745n 0.0v 394.755n 0.0v 399.745n 0.0v 399.755n 0.0v 404.745n 0.0v 404.755n 0.0v 409.745n 0.0v 409.755n 0.0v 414.745n 0.0v 414.755n 0.0v 419.745n 0.0v 419.755n 0.0v 424.745n 0.0v 424.755n 0.0v 429.745n 0.0v 429.755n 0.0v 434.745n 0.0v 434.755n 0.0v 439.745n 0.0v 439.755n 0.95v 444.745n 0.95v 444.755n 0.95v 449.745n 0.95v 449.755n 0.95v 454.745n 0.95v 454.755n 0.95v 459.745n 0.95v 459.755n 0.95v 464.745n 0.95v 464.755n 0.95v 469.745n 0.95v 469.755n 0.95v 474.745n 0.95v 474.755n 0.95v 479.745n 0.95v 479.755n 0.95v 484.745n 0.95v 484.755n 0.95v 489.745n 0.95v 489.755n 0.95v 494.745n 0.95v 494.755n 0.95v 499.745n 0.95v 499.755n 0.95v 504.745n 0.95v 504.755n 0.0v 509.745n 0.0v 509.755n 0.95v 514.745n 0.95v 514.755n 0.95v 519.745n 0.95v 519.755n 0.95v 524.745n 0.95v 524.755n 0.95v 529.745n 0.95v 529.755n 0.95v 534.745n 0.95v 534.755n 0.95v 539.745n 0.95v 539.755n 0.95v 544.745n 0.95v 544.755n 0.95v 549.745n 0.95v 549.755n 0.95v 554.745n 0.95v 554.755n 0.95v 559.745n 0.95v 559.755n 0.95v 564.745n 0.95v 564.755n 0.0v 569.745n 0.0v 569.755n 0.0v 574.745n 0.0v 574.755n 0.0v 579.745n 0.0v 579.755n 0.95v 584.745n 0.95v 584.755n 0.95v 589.745n 0.95v 589.755n 0.95v 594.745n 0.95v 594.755n 0.95v 599.745n 0.95v 599.755n 0.95v 604.745n 0.95v 604.755n 0.95v 609.745n 0.95v 609.755n 0.95v 614.745n 0.95v 614.755n 0.0v 619.745n 0.0v 619.755n 0.0v 624.745n 0.0v 624.755n 0.0v 629.745n 0.0v 629.755n 0.0v 634.745n 0.0v 634.755n 0.0v 639.745n 0.0v 639.755n 0.0v 644.745n 0.0v 644.755n 0.0v 649.745n 0.0v 649.755n 0.0v 654.745n 0.0v 654.755n 0.95v 659.745n 0.95v 659.755n 0.95v 664.745n 0.95v 664.755n 0.95v 669.745n 0.95v 669.755n 0.95v 674.745n 0.95v 674.755n 0.0v 679.745n 0.0v 679.755n 0.0v 684.745n 0.0v 684.755n 0.0v 689.745n 0.0v 689.755n 0.0v 694.745n 0.0v 694.755n 0.0v 699.745n 0.0v 699.755n 0.95v 704.745n 0.95v 704.755n 0.0v 709.745n 0.0v 709.755n 0.0v 714.745n 0.0v 714.755n 0.0v 719.745n 0.0v 719.755n 0.0v 724.745n 0.0v 724.755n 0.0v 729.745n 0.0v 729.755n 0.0v 734.745n 0.0v 734.755n 0.95v 739.745n 0.95v 739.755n 0.95v 744.745n 0.95v 744.755n 0.0v 749.745n 0.0v 749.755n 0.0v 754.745n 0.0v 754.755n 0.0v 759.745n 0.0v 759.755n 0.0v 764.745n 0.0v 764.755n 0.0v 769.745n 0.0v 769.755n 0.95v 774.745n 0.95v 774.755n 0.95v 779.745n 0.95v 779.755n 0.95v 784.745n 0.95v 784.755n 0.95v 789.745n 0.95v 789.755n 0.95v 794.745n 0.95v 794.755n 0.95v 799.745n 0.95v 799.755n 0.95v 804.745n 0.95v 804.755n 0.95v 809.745n 0.95v 809.755n 0.95v 814.745n 0.95v 814.755n 0.0v 819.745n 0.0v 819.755n 0.0v 824.745n 0.0v 824.755n 0.0v 829.745n 0.0v 829.755n 0.0v 834.745n 0.0v 834.755n 0.0v 839.745n 0.0v 839.755n 0.0v 844.745n 0.0v 844.755n 0.0v 849.745n 0.0v 849.755n 0.0v 854.745n 0.0v 854.755n 0.0v 859.745n 0.0v 859.755n 0.0v 864.745n 0.0v 864.755n 0.0v 869.745n 0.0v 869.755n 0.95v 874.745n 0.95v 874.755n 0.95v 879.745n 0.95v 879.755n 0.0v 884.745n 0.0v 884.755n 0.95v 889.745n 0.95v 889.755n 0.0v 894.745n 0.0v 894.755n 0.95v 899.745n 0.95v 899.755n 0.95v 904.745n 0.95v 904.755n 0.95v 909.745n 0.95v 909.755n 0.95v 914.745n 0.95v 914.755n 0.0v 919.745n 0.0v 919.755n 0.0v 924.745n 0.0v 924.755n 0.0v 929.745n 0.0v 929.755n 0.0v 934.745n 0.0v 934.755n 0.0v 939.745n 0.0v 939.755n 0.95v 944.745n 0.95v 944.755n 0.95v 949.745n 0.95v 949.755n 0.95v 954.745n 0.95v 954.755n 0.95v 959.745n 0.95v 959.755n 0.95v 964.745n 0.95v 964.755n 0.95v 969.745n 0.95v 969.755n 0.95v 974.745n 0.95v 974.755n 0.95v 979.745n 0.95v 979.755n 0.95v 984.745n 0.95v 984.755n 0.95v 989.745n 0.95v 989.755n 0.95v 994.745n 0.95v 994.755n 0.95v 999.745n 0.95v 999.755n 0.95v 1004.745n 0.95v 1004.755n 0.95v 1009.745n 0.95v 1009.755n 0.95v 1014.745n 0.95v 1014.755n 0.95v 1019.745n 0.95v 1019.755n 0.95v 1024.745n 0.95v 1024.755n 0.95v )
* (time, data): [(0, 0), (5, 1), (10, 1), (15, 0), (20, 0), (25, 0), (30, 1), (35, 1), (40, 1), (45, 0), (50, 0), (55, 0), (60, 1), (65, 0), (70, 0), (75, 1), (80, 1), (85, 1), (90, 1), (95, 1), (100, 1), (105, 1), (110, 1), (115, 1), (120, 1), (125, 1), (130, 1), (135, 0), (140, 1), (145, 0), (150, 1), (155, 1), (160, 1), (165, 0), (170, 0), (175, 0), (180, 0), (185, 1), (190, 1), (195, 1), (200, 1), (205, 1), (210, 0), (215, 0), (220, 1), (225, 1), (230, 0), (235, 0), (240, 0), (245, 1), (250, 1), (255, 1), (260, 1), (265, 1), (270, 0), (275, 0), (280, 0), (285, 0), (290, 0), (295, 0), (300, 0), (305, 1), (310, 1), (315, 1), (320, 0), (325, 0), (330, 0), (335, 0), (340, 0), (345, 0), (350, 0), (355, 0), (360, 0), (365, 1), (370, 1), (375, 1), (380, 1), (385, 1), (390, 1), (395, 1), (400, 0), (405, 0), (410, 0), (415, 0), (420, 0), (425, 0), (430, 0), (435, 0), (440, 0), (445, 1), (450, 1), (455, 1), (460, 1), (465, 0), (470, 0), (475, 0), (480, 0), (485, 0), (490, 0), (495, 0), (500, 0), (505, 1), (510, 0), (515, 0), (520, 0), (525, 0), (530, 0), (535, 1), (540, 1), (545, 1), (550, 0), (555, 0), (560, 0), (565, 0), (570, 0), (575, 1), (580, 0), (585, 0), (590, 0), (595, 0), (600, 0), (605, 0), (610, 0), (615, 0), (620, 0), (625, 0), (630, 1), (635, 0), (640, 0), (645, 0), (650, 0), (655, 0), (660, 0), (665, 0), (670, 1), (675, 1), (680, 1), (685, 1), (690, 1), (695, 1), (700, 1), (705, 1), (710, 1), (715, 1), (720, 1), (725, 1), (730, 1), (735, 0), (740, 0), (745, 1), (750, 1), (755, 1), (760, 1), (765, 1), (770, 0), (775, 0), (780, 0), (785, 0), (790, 0), (795, 0), (800, 0), (805, 0), (810, 1), (815, 0), (820, 0), (825, 0), (830, 0), (835, 0), (840, 0), (845, 0), (850, 0), (855, 0), (860, 0), (865, 0), (870, 0), (875, 0), (880, 1), (885, 1), (890, 0), (895, 0), (900, 1), (905, 1), (910, 1), (915, 1), (920, 1), (925, 1), (930, 1), (935, 1), (940, 0), (945, 0), (950, 0), (955, 1), (960, 1), (965, 0), (970, 0), (975, 0), (980, 0), (985, 0), (990, 0), (995, 0), (1000, 0), (1005, 0), (1010, 1), (1015, 1), (1020, 1), (1025, 1)]
Vdin0_8  din0_8  0 PWL (0n 0.0v 4.745n 0.0v 4.755n 0.95v 9.745n 0.95v 9.755n 0.95v 14.745n 0.95v 14.755n 0.0v 19.745n 0.0v 19.755n 0.0v 24.745n 0.0v 24.755n 0.0v 29.745n 0.0v 29.755n 0.95v 34.745n 0.95v 34.755n 0.95v 39.745n 0.95v 39.755n 0.95v 44.745n 0.95v 44.755n 0.0v 49.745n 0.0v 49.755n 0.0v 54.745n 0.0v 54.755n 0.0v 59.745n 0.0v 59.755n 0.95v 64.745n 0.95v 64.755n 0.0v 69.745n 0.0v 69.755n 0.0v 74.745n 0.0v 74.755n 0.95v 79.745n 0.95v 79.755n 0.95v 84.745n 0.95v 84.755n 0.95v 89.745n 0.95v 89.755n 0.95v 94.745n 0.95v 94.755n 0.95v 99.745n 0.95v 99.755n 0.95v 104.745n 0.95v 104.755n 0.95v 109.745n 0.95v 109.755n 0.95v 114.745n 0.95v 114.755n 0.95v 119.745n 0.95v 119.755n 0.95v 124.745n 0.95v 124.755n 0.95v 129.745n 0.95v 129.755n 0.95v 134.745n 0.95v 134.755n 0.0v 139.745n 0.0v 139.755n 0.95v 144.745n 0.95v 144.755n 0.0v 149.745n 0.0v 149.755n 0.95v 154.745n 0.95v 154.755n 0.95v 159.745n 0.95v 159.755n 0.95v 164.745n 0.95v 164.755n 0.0v 169.745n 0.0v 169.755n 0.0v 174.745n 0.0v 174.755n 0.0v 179.745n 0.0v 179.755n 0.0v 184.745n 0.0v 184.755n 0.95v 189.745n 0.95v 189.755n 0.95v 194.745n 0.95v 194.755n 0.95v 199.745n 0.95v 199.755n 0.95v 204.745n 0.95v 204.755n 0.95v 209.745n 0.95v 209.755n 0.0v 214.745n 0.0v 214.755n 0.0v 219.745n 0.0v 219.755n 0.95v 224.745n 0.95v 224.755n 0.95v 229.745n 0.95v 229.755n 0.0v 234.745n 0.0v 234.755n 0.0v 239.745n 0.0v 239.755n 0.0v 244.745n 0.0v 244.755n 0.95v 249.745n 0.95v 249.755n 0.95v 254.745n 0.95v 254.755n 0.95v 259.745n 0.95v 259.755n 0.95v 264.745n 0.95v 264.755n 0.95v 269.745n 0.95v 269.755n 0.0v 274.745n 0.0v 274.755n 0.0v 279.745n 0.0v 279.755n 0.0v 284.745n 0.0v 284.755n 0.0v 289.745n 0.0v 289.755n 0.0v 294.745n 0.0v 294.755n 0.0v 299.745n 0.0v 299.755n 0.0v 304.745n 0.0v 304.755n 0.95v 309.745n 0.95v 309.755n 0.95v 314.745n 0.95v 314.755n 0.95v 319.745n 0.95v 319.755n 0.0v 324.745n 0.0v 324.755n 0.0v 329.745n 0.0v 329.755n 0.0v 334.745n 0.0v 334.755n 0.0v 339.745n 0.0v 339.755n 0.0v 344.745n 0.0v 344.755n 0.0v 349.745n 0.0v 349.755n 0.0v 354.745n 0.0v 354.755n 0.0v 359.745n 0.0v 359.755n 0.0v 364.745n 0.0v 364.755n 0.95v 369.745n 0.95v 369.755n 0.95v 374.745n 0.95v 374.755n 0.95v 379.745n 0.95v 379.755n 0.95v 384.745n 0.95v 384.755n 0.95v 389.745n 0.95v 389.755n 0.95v 394.745n 0.95v 394.755n 0.95v 399.745n 0.95v 399.755n 0.0v 404.745n 0.0v 404.755n 0.0v 409.745n 0.0v 409.755n 0.0v 414.745n 0.0v 414.755n 0.0v 419.745n 0.0v 419.755n 0.0v 424.745n 0.0v 424.755n 0.0v 429.745n 0.0v 429.755n 0.0v 434.745n 0.0v 434.755n 0.0v 439.745n 0.0v 439.755n 0.0v 444.745n 0.0v 444.755n 0.95v 449.745n 0.95v 449.755n 0.95v 454.745n 0.95v 454.755n 0.95v 459.745n 0.95v 459.755n 0.95v 464.745n 0.95v 464.755n 0.0v 469.745n 0.0v 469.755n 0.0v 474.745n 0.0v 474.755n 0.0v 479.745n 0.0v 479.755n 0.0v 484.745n 0.0v 484.755n 0.0v 489.745n 0.0v 489.755n 0.0v 494.745n 0.0v 494.755n 0.0v 499.745n 0.0v 499.755n 0.0v 504.745n 0.0v 504.755n 0.95v 509.745n 0.95v 509.755n 0.0v 514.745n 0.0v 514.755n 0.0v 519.745n 0.0v 519.755n 0.0v 524.745n 0.0v 524.755n 0.0v 529.745n 0.0v 529.755n 0.0v 534.745n 0.0v 534.755n 0.95v 539.745n 0.95v 539.755n 0.95v 544.745n 0.95v 544.755n 0.95v 549.745n 0.95v 549.755n 0.0v 554.745n 0.0v 554.755n 0.0v 559.745n 0.0v 559.755n 0.0v 564.745n 0.0v 564.755n 0.0v 569.745n 0.0v 569.755n 0.0v 574.745n 0.0v 574.755n 0.95v 579.745n 0.95v 579.755n 0.0v 584.745n 0.0v 584.755n 0.0v 589.745n 0.0v 589.755n 0.0v 594.745n 0.0v 594.755n 0.0v 599.745n 0.0v 599.755n 0.0v 604.745n 0.0v 604.755n 0.0v 609.745n 0.0v 609.755n 0.0v 614.745n 0.0v 614.755n 0.0v 619.745n 0.0v 619.755n 0.0v 624.745n 0.0v 624.755n 0.0v 629.745n 0.0v 629.755n 0.95v 634.745n 0.95v 634.755n 0.0v 639.745n 0.0v 639.755n 0.0v 644.745n 0.0v 644.755n 0.0v 649.745n 0.0v 649.755n 0.0v 654.745n 0.0v 654.755n 0.0v 659.745n 0.0v 659.755n 0.0v 664.745n 0.0v 664.755n 0.0v 669.745n 0.0v 669.755n 0.95v 674.745n 0.95v 674.755n 0.95v 679.745n 0.95v 679.755n 0.95v 684.745n 0.95v 684.755n 0.95v 689.745n 0.95v 689.755n 0.95v 694.745n 0.95v 694.755n 0.95v 699.745n 0.95v 699.755n 0.95v 704.745n 0.95v 704.755n 0.95v 709.745n 0.95v 709.755n 0.95v 714.745n 0.95v 714.755n 0.95v 719.745n 0.95v 719.755n 0.95v 724.745n 0.95v 724.755n 0.95v 729.745n 0.95v 729.755n 0.95v 734.745n 0.95v 734.755n 0.0v 739.745n 0.0v 739.755n 0.0v 744.745n 0.0v 744.755n 0.95v 749.745n 0.95v 749.755n 0.95v 754.745n 0.95v 754.755n 0.95v 759.745n 0.95v 759.755n 0.95v 764.745n 0.95v 764.755n 0.95v 769.745n 0.95v 769.755n 0.0v 774.745n 0.0v 774.755n 0.0v 779.745n 0.0v 779.755n 0.0v 784.745n 0.0v 784.755n 0.0v 789.745n 0.0v 789.755n 0.0v 794.745n 0.0v 794.755n 0.0v 799.745n 0.0v 799.755n 0.0v 804.745n 0.0v 804.755n 0.0v 809.745n 0.0v 809.755n 0.95v 814.745n 0.95v 814.755n 0.0v 819.745n 0.0v 819.755n 0.0v 824.745n 0.0v 824.755n 0.0v 829.745n 0.0v 829.755n 0.0v 834.745n 0.0v 834.755n 0.0v 839.745n 0.0v 839.755n 0.0v 844.745n 0.0v 844.755n 0.0v 849.745n 0.0v 849.755n 0.0v 854.745n 0.0v 854.755n 0.0v 859.745n 0.0v 859.755n 0.0v 864.745n 0.0v 864.755n 0.0v 869.745n 0.0v 869.755n 0.0v 874.745n 0.0v 874.755n 0.0v 879.745n 0.0v 879.755n 0.95v 884.745n 0.95v 884.755n 0.95v 889.745n 0.95v 889.755n 0.0v 894.745n 0.0v 894.755n 0.0v 899.745n 0.0v 899.755n 0.95v 904.745n 0.95v 904.755n 0.95v 909.745n 0.95v 909.755n 0.95v 914.745n 0.95v 914.755n 0.95v 919.745n 0.95v 919.755n 0.95v 924.745n 0.95v 924.755n 0.95v 929.745n 0.95v 929.755n 0.95v 934.745n 0.95v 934.755n 0.95v 939.745n 0.95v 939.755n 0.0v 944.745n 0.0v 944.755n 0.0v 949.745n 0.0v 949.755n 0.0v 954.745n 0.0v 954.755n 0.95v 959.745n 0.95v 959.755n 0.95v 964.745n 0.95v 964.755n 0.0v 969.745n 0.0v 969.755n 0.0v 974.745n 0.0v 974.755n 0.0v 979.745n 0.0v 979.755n 0.0v 984.745n 0.0v 984.755n 0.0v 989.745n 0.0v 989.755n 0.0v 994.745n 0.0v 994.755n 0.0v 999.745n 0.0v 999.755n 0.0v 1004.745n 0.0v 1004.755n 0.0v 1009.745n 0.0v 1009.755n 0.95v 1014.745n 0.95v 1014.755n 0.95v 1019.745n 0.95v 1019.755n 0.95v 1024.745n 0.95v 1024.755n 0.95v )
* (time, data): [(0, 0), (5, 1), (10, 0), (15, 1), (20, 1), (25, 1), (30, 0), (35, 0), (40, 0), (45, 0), (50, 0), (55, 0), (60, 1), (65, 1), (70, 1), (75, 1), (80, 1), (85, 1), (90, 1), (95, 1), (100, 1), (105, 1), (110, 1), (115, 1), (120, 1), (125, 1), (130, 1), (135, 1), (140, 0), (145, 1), (150, 1), (155, 1), (160, 1), (165, 0), (170, 0), (175, 0), (180, 0), (185, 0), (190, 0), (195, 0), (200, 0), (205, 0), (210, 1), (215, 1), (220, 1), (225, 1), (230, 0), (235, 0), (240, 0), (245, 0), (250, 0), (255, 0), (260, 0), (265, 0), (270, 0), (275, 0), (280, 0), (285, 0), (290, 0), (295, 0), (300, 0), (305, 0), (310, 0), (315, 0), (320, 0), (325, 0), (330, 0), (335, 0), (340, 0), (345, 0), (350, 0), (355, 0), (360, 0), (365, 0), (370, 0), (375, 1), (380, 0), (385, 0), (390, 0), (395, 0), (400, 1), (405, 1), (410, 1), (415, 1), (420, 0), (425, 0), (430, 0), (435, 0), (440, 0), (445, 0), (450, 1), (455, 1), (460, 1), (465, 0), (470, 0), (475, 0), (480, 0), (485, 0), (490, 0), (495, 0), (500, 0), (505, 1), (510, 0), (515, 0), (520, 0), (525, 0), (530, 0), (535, 0), (540, 0), (545, 0), (550, 0), (555, 0), (560, 1), (565, 0), (570, 0), (575, 0), (580, 1), (585, 1), (590, 1), (595, 1), (600, 1), (605, 0), (610, 0), (615, 1), (620, 1), (625, 1), (630, 1), (635, 1), (640, 1), (645, 1), (650, 1), (655, 0), (660, 0), (665, 0), (670, 0), (675, 0), (680, 0), (685, 0), (690, 0), (695, 0), (700, 1), (705, 1), (710, 1), (715, 1), (720, 1), (725, 1), (730, 1), (735, 1), (740, 1), (745, 1), (750, 1), (755, 1), (760, 1), (765, 1), (770, 1), (775, 1), (780, 1), (785, 1), (790, 1), (795, 1), (800, 1), (805, 1), (810, 0), (815, 1), (820, 1), (825, 1), (830, 1), (835, 1), (840, 1), (845, 1), (850, 1), (855, 1), (860, 1), (865, 1), (870, 0), (875, 0), (880, 0), (885, 1), (890, 1), (895, 0), (900, 0), (905, 0), (910, 0), (915, 1), (920, 1), (925, 1), (930, 1), (935, 1), (940, 0), (945, 0), (950, 0), (955, 0), (960, 0), (965, 1), (970, 1), (975, 1), (980, 1), (985, 1), (990, 1), (995, 1), (1000, 1), (1005, 1), (1010, 0), (1015, 0), (1020, 0), (1025, 0)]
Vdin0_9  din0_9  0 PWL (0n 0.0v 4.745n 0.0v 4.755n 0.95v 9.745n 0.95v 9.755n 0.0v 14.745n 0.0v 14.755n 0.95v 19.745n 0.95v 19.755n 0.95v 24.745n 0.95v 24.755n 0.95v 29.745n 0.95v 29.755n 0.0v 34.745n 0.0v 34.755n 0.0v 39.745n 0.0v 39.755n 0.0v 44.745n 0.0v 44.755n 0.0v 49.745n 0.0v 49.755n 0.0v 54.745n 0.0v 54.755n 0.0v 59.745n 0.0v 59.755n 0.95v 64.745n 0.95v 64.755n 0.95v 69.745n 0.95v 69.755n 0.95v 74.745n 0.95v 74.755n 0.95v 79.745n 0.95v 79.755n 0.95v 84.745n 0.95v 84.755n 0.95v 89.745n 0.95v 89.755n 0.95v 94.745n 0.95v 94.755n 0.95v 99.745n 0.95v 99.755n 0.95v 104.745n 0.95v 104.755n 0.95v 109.745n 0.95v 109.755n 0.95v 114.745n 0.95v 114.755n 0.95v 119.745n 0.95v 119.755n 0.95v 124.745n 0.95v 124.755n 0.95v 129.745n 0.95v 129.755n 0.95v 134.745n 0.95v 134.755n 0.95v 139.745n 0.95v 139.755n 0.0v 144.745n 0.0v 144.755n 0.95v 149.745n 0.95v 149.755n 0.95v 154.745n 0.95v 154.755n 0.95v 159.745n 0.95v 159.755n 0.95v 164.745n 0.95v 164.755n 0.0v 169.745n 0.0v 169.755n 0.0v 174.745n 0.0v 174.755n 0.0v 179.745n 0.0v 179.755n 0.0v 184.745n 0.0v 184.755n 0.0v 189.745n 0.0v 189.755n 0.0v 194.745n 0.0v 194.755n 0.0v 199.745n 0.0v 199.755n 0.0v 204.745n 0.0v 204.755n 0.0v 209.745n 0.0v 209.755n 0.95v 214.745n 0.95v 214.755n 0.95v 219.745n 0.95v 219.755n 0.95v 224.745n 0.95v 224.755n 0.95v 229.745n 0.95v 229.755n 0.0v 234.745n 0.0v 234.755n 0.0v 239.745n 0.0v 239.755n 0.0v 244.745n 0.0v 244.755n 0.0v 249.745n 0.0v 249.755n 0.0v 254.745n 0.0v 254.755n 0.0v 259.745n 0.0v 259.755n 0.0v 264.745n 0.0v 264.755n 0.0v 269.745n 0.0v 269.755n 0.0v 274.745n 0.0v 274.755n 0.0v 279.745n 0.0v 279.755n 0.0v 284.745n 0.0v 284.755n 0.0v 289.745n 0.0v 289.755n 0.0v 294.745n 0.0v 294.755n 0.0v 299.745n 0.0v 299.755n 0.0v 304.745n 0.0v 304.755n 0.0v 309.745n 0.0v 309.755n 0.0v 314.745n 0.0v 314.755n 0.0v 319.745n 0.0v 319.755n 0.0v 324.745n 0.0v 324.755n 0.0v 329.745n 0.0v 329.755n 0.0v 334.745n 0.0v 334.755n 0.0v 339.745n 0.0v 339.755n 0.0v 344.745n 0.0v 344.755n 0.0v 349.745n 0.0v 349.755n 0.0v 354.745n 0.0v 354.755n 0.0v 359.745n 0.0v 359.755n 0.0v 364.745n 0.0v 364.755n 0.0v 369.745n 0.0v 369.755n 0.0v 374.745n 0.0v 374.755n 0.95v 379.745n 0.95v 379.755n 0.0v 384.745n 0.0v 384.755n 0.0v 389.745n 0.0v 389.755n 0.0v 394.745n 0.0v 394.755n 0.0v 399.745n 0.0v 399.755n 0.95v 404.745n 0.95v 404.755n 0.95v 409.745n 0.95v 409.755n 0.95v 414.745n 0.95v 414.755n 0.95v 419.745n 0.95v 419.755n 0.0v 424.745n 0.0v 424.755n 0.0v 429.745n 0.0v 429.755n 0.0v 434.745n 0.0v 434.755n 0.0v 439.745n 0.0v 439.755n 0.0v 444.745n 0.0v 444.755n 0.0v 449.745n 0.0v 449.755n 0.95v 454.745n 0.95v 454.755n 0.95v 459.745n 0.95v 459.755n 0.95v 464.745n 0.95v 464.755n 0.0v 469.745n 0.0v 469.755n 0.0v 474.745n 0.0v 474.755n 0.0v 479.745n 0.0v 479.755n 0.0v 484.745n 0.0v 484.755n 0.0v 489.745n 0.0v 489.755n 0.0v 494.745n 0.0v 494.755n 0.0v 499.745n 0.0v 499.755n 0.0v 504.745n 0.0v 504.755n 0.95v 509.745n 0.95v 509.755n 0.0v 514.745n 0.0v 514.755n 0.0v 519.745n 0.0v 519.755n 0.0v 524.745n 0.0v 524.755n 0.0v 529.745n 0.0v 529.755n 0.0v 534.745n 0.0v 534.755n 0.0v 539.745n 0.0v 539.755n 0.0v 544.745n 0.0v 544.755n 0.0v 549.745n 0.0v 549.755n 0.0v 554.745n 0.0v 554.755n 0.0v 559.745n 0.0v 559.755n 0.95v 564.745n 0.95v 564.755n 0.0v 569.745n 0.0v 569.755n 0.0v 574.745n 0.0v 574.755n 0.0v 579.745n 0.0v 579.755n 0.95v 584.745n 0.95v 584.755n 0.95v 589.745n 0.95v 589.755n 0.95v 594.745n 0.95v 594.755n 0.95v 599.745n 0.95v 599.755n 0.95v 604.745n 0.95v 604.755n 0.0v 609.745n 0.0v 609.755n 0.0v 614.745n 0.0v 614.755n 0.95v 619.745n 0.95v 619.755n 0.95v 624.745n 0.95v 624.755n 0.95v 629.745n 0.95v 629.755n 0.95v 634.745n 0.95v 634.755n 0.95v 639.745n 0.95v 639.755n 0.95v 644.745n 0.95v 644.755n 0.95v 649.745n 0.95v 649.755n 0.95v 654.745n 0.95v 654.755n 0.0v 659.745n 0.0v 659.755n 0.0v 664.745n 0.0v 664.755n 0.0v 669.745n 0.0v 669.755n 0.0v 674.745n 0.0v 674.755n 0.0v 679.745n 0.0v 679.755n 0.0v 684.745n 0.0v 684.755n 0.0v 689.745n 0.0v 689.755n 0.0v 694.745n 0.0v 694.755n 0.0v 699.745n 0.0v 699.755n 0.95v 704.745n 0.95v 704.755n 0.95v 709.745n 0.95v 709.755n 0.95v 714.745n 0.95v 714.755n 0.95v 719.745n 0.95v 719.755n 0.95v 724.745n 0.95v 724.755n 0.95v 729.745n 0.95v 729.755n 0.95v 734.745n 0.95v 734.755n 0.95v 739.745n 0.95v 739.755n 0.95v 744.745n 0.95v 744.755n 0.95v 749.745n 0.95v 749.755n 0.95v 754.745n 0.95v 754.755n 0.95v 759.745n 0.95v 759.755n 0.95v 764.745n 0.95v 764.755n 0.95v 769.745n 0.95v 769.755n 0.95v 774.745n 0.95v 774.755n 0.95v 779.745n 0.95v 779.755n 0.95v 784.745n 0.95v 784.755n 0.95v 789.745n 0.95v 789.755n 0.95v 794.745n 0.95v 794.755n 0.95v 799.745n 0.95v 799.755n 0.95v 804.745n 0.95v 804.755n 0.95v 809.745n 0.95v 809.755n 0.0v 814.745n 0.0v 814.755n 0.95v 819.745n 0.95v 819.755n 0.95v 824.745n 0.95v 824.755n 0.95v 829.745n 0.95v 829.755n 0.95v 834.745n 0.95v 834.755n 0.95v 839.745n 0.95v 839.755n 0.95v 844.745n 0.95v 844.755n 0.95v 849.745n 0.95v 849.755n 0.95v 854.745n 0.95v 854.755n 0.95v 859.745n 0.95v 859.755n 0.95v 864.745n 0.95v 864.755n 0.95v 869.745n 0.95v 869.755n 0.0v 874.745n 0.0v 874.755n 0.0v 879.745n 0.0v 879.755n 0.0v 884.745n 0.0v 884.755n 0.95v 889.745n 0.95v 889.755n 0.95v 894.745n 0.95v 894.755n 0.0v 899.745n 0.0v 899.755n 0.0v 904.745n 0.0v 904.755n 0.0v 909.745n 0.0v 909.755n 0.0v 914.745n 0.0v 914.755n 0.95v 919.745n 0.95v 919.755n 0.95v 924.745n 0.95v 924.755n 0.95v 929.745n 0.95v 929.755n 0.95v 934.745n 0.95v 934.755n 0.95v 939.745n 0.95v 939.755n 0.0v 944.745n 0.0v 944.755n 0.0v 949.745n 0.0v 949.755n 0.0v 954.745n 0.0v 954.755n 0.0v 959.745n 0.0v 959.755n 0.0v 964.745n 0.0v 964.755n 0.95v 969.745n 0.95v 969.755n 0.95v 974.745n 0.95v 974.755n 0.95v 979.745n 0.95v 979.755n 0.95v 984.745n 0.95v 984.755n 0.95v 989.745n 0.95v 989.755n 0.95v 994.745n 0.95v 994.755n 0.95v 999.745n 0.95v 999.755n 0.95v 1004.745n 0.95v 1004.755n 0.95v 1009.745n 0.95v 1009.755n 0.0v 1014.745n 0.0v 1014.755n 0.0v 1019.745n 0.0v 1019.755n 0.0v 1024.745n 0.0v 1024.755n 0.0v )
* (time, data): [(0, 0), (5, 0), (10, 1), (15, 0), (20, 0), (25, 0), (30, 0), (35, 0), (40, 0), (45, 1), (50, 1), (55, 1), (60, 1), (65, 1), (70, 1), (75, 1), (80, 1), (85, 1), (90, 1), (95, 0), (100, 0), (105, 0), (110, 0), (115, 0), (120, 0), (125, 0), (130, 0), (135, 1), (140, 1), (145, 0), (150, 1), (155, 1), (160, 1), (165, 1), (170, 1), (175, 1), (180, 1), (185, 0), (190, 0), (195, 0), (200, 0), (205, 0), (210, 1), (215, 1), (220, 1), (225, 0), (230, 1), (235, 1), (240, 1), (245, 0), (250, 0), (255, 0), (260, 0), (265, 0), (270, 1), (275, 1), (280, 1), (285, 1), (290, 1), (295, 1), (300, 1), (305, 1), (310, 1), (315, 1), (320, 0), (325, 0), (330, 0), (335, 0), (340, 0), (345, 0), (350, 0), (355, 0), (360, 0), (365, 0), (370, 0), (375, 1), (380, 1), (385, 1), (390, 1), (395, 1), (400, 0), (405, 0), (410, 0), (415, 0), (420, 0), (425, 0), (430, 0), (435, 0), (440, 0), (445, 0), (450, 0), (455, 0), (460, 0), (465, 1), (470, 1), (475, 1), (480, 1), (485, 1), (490, 1), (495, 1), (500, 1), (505, 1), (510, 0), (515, 0), (520, 0), (525, 0), (530, 0), (535, 1), (540, 1), (545, 1), (550, 1), (555, 1), (560, 0), (565, 0), (570, 0), (575, 0), (580, 0), (585, 0), (590, 0), (595, 0), (600, 0), (605, 0), (610, 0), (615, 0), (620, 0), (625, 0), (630, 0), (635, 0), (640, 0), (645, 0), (650, 0), (655, 1), (660, 1), (665, 1), (670, 1), (675, 0), (680, 0), (685, 0), (690, 0), (695, 0), (700, 0), (705, 0), (710, 0), (715, 0), (720, 0), (725, 0), (730, 0), (735, 1), (740, 1), (745, 0), (750, 0), (755, 0), (760, 0), (765, 0), (770, 0), (775, 0), (780, 0), (785, 0), (790, 0), (795, 0), (800, 0), (805, 0), (810, 0), (815, 0), (820, 0), (825, 0), (830, 0), (835, 0), (840, 0), (845, 0), (850, 0), (855, 0), (860, 0), (865, 0), (870, 0), (875, 0), (880, 1), (885, 0), (890, 0), (895, 1), (900, 1), (905, 1), (910, 1), (915, 0), (920, 0), (925, 0), (930, 0), (935, 0), (940, 1), (945, 1), (950, 1), (955, 1), (960, 1), (965, 0), (970, 0), (975, 0), (980, 0), (985, 0), (990, 0), (995, 0), (1000, 0), (1005, 0), (1010, 0), (1015, 0), (1020, 0), (1025, 0)]
Vdin0_10  din0_10  0 PWL (0n 0.0v 4.745n 0.0v 4.755n 0.0v 9.745n 0.0v 9.755n 0.95v 14.745n 0.95v 14.755n 0.0v 19.745n 0.0v 19.755n 0.0v 24.745n 0.0v 24.755n 0.0v 29.745n 0.0v 29.755n 0.0v 34.745n 0.0v 34.755n 0.0v 39.745n 0.0v 39.755n 0.0v 44.745n 0.0v 44.755n 0.95v 49.745n 0.95v 49.755n 0.95v 54.745n 0.95v 54.755n 0.95v 59.745n 0.95v 59.755n 0.95v 64.745n 0.95v 64.755n 0.95v 69.745n 0.95v 69.755n 0.95v 74.745n 0.95v 74.755n 0.95v 79.745n 0.95v 79.755n 0.95v 84.745n 0.95v 84.755n 0.95v 89.745n 0.95v 89.755n 0.95v 94.745n 0.95v 94.755n 0.0v 99.745n 0.0v 99.755n 0.0v 104.745n 0.0v 104.755n 0.0v 109.745n 0.0v 109.755n 0.0v 114.745n 0.0v 114.755n 0.0v 119.745n 0.0v 119.755n 0.0v 124.745n 0.0v 124.755n 0.0v 129.745n 0.0v 129.755n 0.0v 134.745n 0.0v 134.755n 0.95v 139.745n 0.95v 139.755n 0.95v 144.745n 0.95v 144.755n 0.0v 149.745n 0.0v 149.755n 0.95v 154.745n 0.95v 154.755n 0.95v 159.745n 0.95v 159.755n 0.95v 164.745n 0.95v 164.755n 0.95v 169.745n 0.95v 169.755n 0.95v 174.745n 0.95v 174.755n 0.95v 179.745n 0.95v 179.755n 0.95v 184.745n 0.95v 184.755n 0.0v 189.745n 0.0v 189.755n 0.0v 194.745n 0.0v 194.755n 0.0v 199.745n 0.0v 199.755n 0.0v 204.745n 0.0v 204.755n 0.0v 209.745n 0.0v 209.755n 0.95v 214.745n 0.95v 214.755n 0.95v 219.745n 0.95v 219.755n 0.95v 224.745n 0.95v 224.755n 0.0v 229.745n 0.0v 229.755n 0.95v 234.745n 0.95v 234.755n 0.95v 239.745n 0.95v 239.755n 0.95v 244.745n 0.95v 244.755n 0.0v 249.745n 0.0v 249.755n 0.0v 254.745n 0.0v 254.755n 0.0v 259.745n 0.0v 259.755n 0.0v 264.745n 0.0v 264.755n 0.0v 269.745n 0.0v 269.755n 0.95v 274.745n 0.95v 274.755n 0.95v 279.745n 0.95v 279.755n 0.95v 284.745n 0.95v 284.755n 0.95v 289.745n 0.95v 289.755n 0.95v 294.745n 0.95v 294.755n 0.95v 299.745n 0.95v 299.755n 0.95v 304.745n 0.95v 304.755n 0.95v 309.745n 0.95v 309.755n 0.95v 314.745n 0.95v 314.755n 0.95v 319.745n 0.95v 319.755n 0.0v 324.745n 0.0v 324.755n 0.0v 329.745n 0.0v 329.755n 0.0v 334.745n 0.0v 334.755n 0.0v 339.745n 0.0v 339.755n 0.0v 344.745n 0.0v 344.755n 0.0v 349.745n 0.0v 349.755n 0.0v 354.745n 0.0v 354.755n 0.0v 359.745n 0.0v 359.755n 0.0v 364.745n 0.0v 364.755n 0.0v 369.745n 0.0v 369.755n 0.0v 374.745n 0.0v 374.755n 0.95v 379.745n 0.95v 379.755n 0.95v 384.745n 0.95v 384.755n 0.95v 389.745n 0.95v 389.755n 0.95v 394.745n 0.95v 394.755n 0.95v 399.745n 0.95v 399.755n 0.0v 404.745n 0.0v 404.755n 0.0v 409.745n 0.0v 409.755n 0.0v 414.745n 0.0v 414.755n 0.0v 419.745n 0.0v 419.755n 0.0v 424.745n 0.0v 424.755n 0.0v 429.745n 0.0v 429.755n 0.0v 434.745n 0.0v 434.755n 0.0v 439.745n 0.0v 439.755n 0.0v 444.745n 0.0v 444.755n 0.0v 449.745n 0.0v 449.755n 0.0v 454.745n 0.0v 454.755n 0.0v 459.745n 0.0v 459.755n 0.0v 464.745n 0.0v 464.755n 0.95v 469.745n 0.95v 469.755n 0.95v 474.745n 0.95v 474.755n 0.95v 479.745n 0.95v 479.755n 0.95v 484.745n 0.95v 484.755n 0.95v 489.745n 0.95v 489.755n 0.95v 494.745n 0.95v 494.755n 0.95v 499.745n 0.95v 499.755n 0.95v 504.745n 0.95v 504.755n 0.95v 509.745n 0.95v 509.755n 0.0v 514.745n 0.0v 514.755n 0.0v 519.745n 0.0v 519.755n 0.0v 524.745n 0.0v 524.755n 0.0v 529.745n 0.0v 529.755n 0.0v 534.745n 0.0v 534.755n 0.95v 539.745n 0.95v 539.755n 0.95v 544.745n 0.95v 544.755n 0.95v 549.745n 0.95v 549.755n 0.95v 554.745n 0.95v 554.755n 0.95v 559.745n 0.95v 559.755n 0.0v 564.745n 0.0v 564.755n 0.0v 569.745n 0.0v 569.755n 0.0v 574.745n 0.0v 574.755n 0.0v 579.745n 0.0v 579.755n 0.0v 584.745n 0.0v 584.755n 0.0v 589.745n 0.0v 589.755n 0.0v 594.745n 0.0v 594.755n 0.0v 599.745n 0.0v 599.755n 0.0v 604.745n 0.0v 604.755n 0.0v 609.745n 0.0v 609.755n 0.0v 614.745n 0.0v 614.755n 0.0v 619.745n 0.0v 619.755n 0.0v 624.745n 0.0v 624.755n 0.0v 629.745n 0.0v 629.755n 0.0v 634.745n 0.0v 634.755n 0.0v 639.745n 0.0v 639.755n 0.0v 644.745n 0.0v 644.755n 0.0v 649.745n 0.0v 649.755n 0.0v 654.745n 0.0v 654.755n 0.95v 659.745n 0.95v 659.755n 0.95v 664.745n 0.95v 664.755n 0.95v 669.745n 0.95v 669.755n 0.95v 674.745n 0.95v 674.755n 0.0v 679.745n 0.0v 679.755n 0.0v 684.745n 0.0v 684.755n 0.0v 689.745n 0.0v 689.755n 0.0v 694.745n 0.0v 694.755n 0.0v 699.745n 0.0v 699.755n 0.0v 704.745n 0.0v 704.755n 0.0v 709.745n 0.0v 709.755n 0.0v 714.745n 0.0v 714.755n 0.0v 719.745n 0.0v 719.755n 0.0v 724.745n 0.0v 724.755n 0.0v 729.745n 0.0v 729.755n 0.0v 734.745n 0.0v 734.755n 0.95v 739.745n 0.95v 739.755n 0.95v 744.745n 0.95v 744.755n 0.0v 749.745n 0.0v 749.755n 0.0v 754.745n 0.0v 754.755n 0.0v 759.745n 0.0v 759.755n 0.0v 764.745n 0.0v 764.755n 0.0v 769.745n 0.0v 769.755n 0.0v 774.745n 0.0v 774.755n 0.0v 779.745n 0.0v 779.755n 0.0v 784.745n 0.0v 784.755n 0.0v 789.745n 0.0v 789.755n 0.0v 794.745n 0.0v 794.755n 0.0v 799.745n 0.0v 799.755n 0.0v 804.745n 0.0v 804.755n 0.0v 809.745n 0.0v 809.755n 0.0v 814.745n 0.0v 814.755n 0.0v 819.745n 0.0v 819.755n 0.0v 824.745n 0.0v 824.755n 0.0v 829.745n 0.0v 829.755n 0.0v 834.745n 0.0v 834.755n 0.0v 839.745n 0.0v 839.755n 0.0v 844.745n 0.0v 844.755n 0.0v 849.745n 0.0v 849.755n 0.0v 854.745n 0.0v 854.755n 0.0v 859.745n 0.0v 859.755n 0.0v 864.745n 0.0v 864.755n 0.0v 869.745n 0.0v 869.755n 0.0v 874.745n 0.0v 874.755n 0.0v 879.745n 0.0v 879.755n 0.95v 884.745n 0.95v 884.755n 0.0v 889.745n 0.0v 889.755n 0.0v 894.745n 0.0v 894.755n 0.95v 899.745n 0.95v 899.755n 0.95v 904.745n 0.95v 904.755n 0.95v 909.745n 0.95v 909.755n 0.95v 914.745n 0.95v 914.755n 0.0v 919.745n 0.0v 919.755n 0.0v 924.745n 0.0v 924.755n 0.0v 929.745n 0.0v 929.755n 0.0v 934.745n 0.0v 934.755n 0.0v 939.745n 0.0v 939.755n 0.95v 944.745n 0.95v 944.755n 0.95v 949.745n 0.95v 949.755n 0.95v 954.745n 0.95v 954.755n 0.95v 959.745n 0.95v 959.755n 0.95v 964.745n 0.95v 964.755n 0.0v 969.745n 0.0v 969.755n 0.0v 974.745n 0.0v 974.755n 0.0v 979.745n 0.0v 979.755n 0.0v 984.745n 0.0v 984.755n 0.0v 989.745n 0.0v 989.755n 0.0v 994.745n 0.0v 994.755n 0.0v 999.745n 0.0v 999.755n 0.0v 1004.745n 0.0v 1004.755n 0.0v 1009.745n 0.0v 1009.755n 0.0v 1014.745n 0.0v 1014.755n 0.0v 1019.745n 0.0v 1019.755n 0.0v 1024.745n 0.0v 1024.755n 0.0v )
* (time, data): [(0, 0), (5, 0), (10, 0), (15, 0), (20, 0), (25, 0), (30, 0), (35, 0), (40, 0), (45, 0), (50, 0), (55, 0), (60, 1), (65, 0), (70, 0), (75, 0), (80, 0), (85, 0), (90, 0), (95, 0), (100, 0), (105, 0), (110, 0), (115, 0), (120, 0), (125, 0), (130, 0), (135, 1), (140, 1), (145, 1), (150, 0), (155, 0), (160, 0), (165, 1), (170, 1), (175, 1), (180, 1), (185, 0), (190, 0), (195, 0), (200, 0), (205, 0), (210, 1), (215, 1), (220, 0), (225, 0), (230, 0), (235, 0), (240, 0), (245, 0), (250, 0), (255, 0), (260, 0), (265, 0), (270, 0), (275, 0), (280, 0), (285, 0), (290, 0), (295, 0), (300, 0), (305, 0), (310, 0), (315, 0), (320, 0), (325, 0), (330, 0), (335, 0), (340, 0), (345, 0), (350, 0), (355, 0), (360, 0), (365, 0), (370, 0), (375, 0), (380, 1), (385, 1), (390, 1), (395, 1), (400, 0), (405, 0), (410, 0), (415, 0), (420, 0), (425, 0), (430, 0), (435, 0), (440, 1), (445, 0), (450, 1), (455, 1), (460, 1), (465, 0), (470, 0), (475, 0), (480, 0), (485, 0), (490, 0), (495, 0), (500, 0), (505, 1), (510, 1), (515, 0), (520, 0), (525, 0), (530, 0), (535, 0), (540, 0), (545, 0), (550, 1), (555, 1), (560, 1), (565, 0), (570, 0), (575, 1), (580, 1), (585, 1), (590, 1), (595, 1), (600, 1), (605, 0), (610, 0), (615, 1), (620, 1), (625, 1), (630, 1), (635, 1), (640, 1), (645, 1), (650, 1), (655, 0), (660, 0), (665, 0), (670, 0), (675, 0), (680, 0), (685, 0), (690, 0), (695, 0), (700, 0), (705, 1), (710, 1), (715, 1), (720, 1), (725, 1), (730, 1), (735, 1), (740, 1), (745, 0), (750, 0), (755, 0), (760, 0), (765, 0), (770, 1), (775, 1), (780, 1), (785, 1), (790, 1), (795, 1), (800, 1), (805, 1), (810, 0), (815, 1), (820, 1), (825, 1), (830, 1), (835, 1), (840, 1), (845, 1), (850, 1), (855, 1), (860, 1), (865, 1), (870, 1), (875, 1), (880, 1), (885, 1), (890, 1), (895, 1), (900, 0), (905, 0), (910, 0), (915, 1), (920, 1), (925, 1), (930, 1), (935, 1), (940, 1), (945, 1), (950, 1), (955, 0), (960, 0), (965, 1), (970, 1), (975, 1), (980, 1), (985, 1), (990, 1), (995, 1), (1000, 1), (1005, 1), (1010, 0), (1015, 0), (1020, 0), (1025, 0)]
Vdin0_11  din0_11  0 PWL (0n 0.0v 4.745n 0.0v 4.755n 0.0v 9.745n 0.0v 9.755n 0.0v 14.745n 0.0v 14.755n 0.0v 19.745n 0.0v 19.755n 0.0v 24.745n 0.0v 24.755n 0.0v 29.745n 0.0v 29.755n 0.0v 34.745n 0.0v 34.755n 0.0v 39.745n 0.0v 39.755n 0.0v 44.745n 0.0v 44.755n 0.0v 49.745n 0.0v 49.755n 0.0v 54.745n 0.0v 54.755n 0.0v 59.745n 0.0v 59.755n 0.95v 64.745n 0.95v 64.755n 0.0v 69.745n 0.0v 69.755n 0.0v 74.745n 0.0v 74.755n 0.0v 79.745n 0.0v 79.755n 0.0v 84.745n 0.0v 84.755n 0.0v 89.745n 0.0v 89.755n 0.0v 94.745n 0.0v 94.755n 0.0v 99.745n 0.0v 99.755n 0.0v 104.745n 0.0v 104.755n 0.0v 109.745n 0.0v 109.755n 0.0v 114.745n 0.0v 114.755n 0.0v 119.745n 0.0v 119.755n 0.0v 124.745n 0.0v 124.755n 0.0v 129.745n 0.0v 129.755n 0.0v 134.745n 0.0v 134.755n 0.95v 139.745n 0.95v 139.755n 0.95v 144.745n 0.95v 144.755n 0.95v 149.745n 0.95v 149.755n 0.0v 154.745n 0.0v 154.755n 0.0v 159.745n 0.0v 159.755n 0.0v 164.745n 0.0v 164.755n 0.95v 169.745n 0.95v 169.755n 0.95v 174.745n 0.95v 174.755n 0.95v 179.745n 0.95v 179.755n 0.95v 184.745n 0.95v 184.755n 0.0v 189.745n 0.0v 189.755n 0.0v 194.745n 0.0v 194.755n 0.0v 199.745n 0.0v 199.755n 0.0v 204.745n 0.0v 204.755n 0.0v 209.745n 0.0v 209.755n 0.95v 214.745n 0.95v 214.755n 0.95v 219.745n 0.95v 219.755n 0.0v 224.745n 0.0v 224.755n 0.0v 229.745n 0.0v 229.755n 0.0v 234.745n 0.0v 234.755n 0.0v 239.745n 0.0v 239.755n 0.0v 244.745n 0.0v 244.755n 0.0v 249.745n 0.0v 249.755n 0.0v 254.745n 0.0v 254.755n 0.0v 259.745n 0.0v 259.755n 0.0v 264.745n 0.0v 264.755n 0.0v 269.745n 0.0v 269.755n 0.0v 274.745n 0.0v 274.755n 0.0v 279.745n 0.0v 279.755n 0.0v 284.745n 0.0v 284.755n 0.0v 289.745n 0.0v 289.755n 0.0v 294.745n 0.0v 294.755n 0.0v 299.745n 0.0v 299.755n 0.0v 304.745n 0.0v 304.755n 0.0v 309.745n 0.0v 309.755n 0.0v 314.745n 0.0v 314.755n 0.0v 319.745n 0.0v 319.755n 0.0v 324.745n 0.0v 324.755n 0.0v 329.745n 0.0v 329.755n 0.0v 334.745n 0.0v 334.755n 0.0v 339.745n 0.0v 339.755n 0.0v 344.745n 0.0v 344.755n 0.0v 349.745n 0.0v 349.755n 0.0v 354.745n 0.0v 354.755n 0.0v 359.745n 0.0v 359.755n 0.0v 364.745n 0.0v 364.755n 0.0v 369.745n 0.0v 369.755n 0.0v 374.745n 0.0v 374.755n 0.0v 379.745n 0.0v 379.755n 0.95v 384.745n 0.95v 384.755n 0.95v 389.745n 0.95v 389.755n 0.95v 394.745n 0.95v 394.755n 0.95v 399.745n 0.95v 399.755n 0.0v 404.745n 0.0v 404.755n 0.0v 409.745n 0.0v 409.755n 0.0v 414.745n 0.0v 414.755n 0.0v 419.745n 0.0v 419.755n 0.0v 424.745n 0.0v 424.755n 0.0v 429.745n 0.0v 429.755n 0.0v 434.745n 0.0v 434.755n 0.0v 439.745n 0.0v 439.755n 0.95v 444.745n 0.95v 444.755n 0.0v 449.745n 0.0v 449.755n 0.95v 454.745n 0.95v 454.755n 0.95v 459.745n 0.95v 459.755n 0.95v 464.745n 0.95v 464.755n 0.0v 469.745n 0.0v 469.755n 0.0v 474.745n 0.0v 474.755n 0.0v 479.745n 0.0v 479.755n 0.0v 484.745n 0.0v 484.755n 0.0v 489.745n 0.0v 489.755n 0.0v 494.745n 0.0v 494.755n 0.0v 499.745n 0.0v 499.755n 0.0v 504.745n 0.0v 504.755n 0.95v 509.745n 0.95v 509.755n 0.95v 514.745n 0.95v 514.755n 0.0v 519.745n 0.0v 519.755n 0.0v 524.745n 0.0v 524.755n 0.0v 529.745n 0.0v 529.755n 0.0v 534.745n 0.0v 534.755n 0.0v 539.745n 0.0v 539.755n 0.0v 544.745n 0.0v 544.755n 0.0v 549.745n 0.0v 549.755n 0.95v 554.745n 0.95v 554.755n 0.95v 559.745n 0.95v 559.755n 0.95v 564.745n 0.95v 564.755n 0.0v 569.745n 0.0v 569.755n 0.0v 574.745n 0.0v 574.755n 0.95v 579.745n 0.95v 579.755n 0.95v 584.745n 0.95v 584.755n 0.95v 589.745n 0.95v 589.755n 0.95v 594.745n 0.95v 594.755n 0.95v 599.745n 0.95v 599.755n 0.95v 604.745n 0.95v 604.755n 0.0v 609.745n 0.0v 609.755n 0.0v 614.745n 0.0v 614.755n 0.95v 619.745n 0.95v 619.755n 0.95v 624.745n 0.95v 624.755n 0.95v 629.745n 0.95v 629.755n 0.95v 634.745n 0.95v 634.755n 0.95v 639.745n 0.95v 639.755n 0.95v 644.745n 0.95v 644.755n 0.95v 649.745n 0.95v 649.755n 0.95v 654.745n 0.95v 654.755n 0.0v 659.745n 0.0v 659.755n 0.0v 664.745n 0.0v 664.755n 0.0v 669.745n 0.0v 669.755n 0.0v 674.745n 0.0v 674.755n 0.0v 679.745n 0.0v 679.755n 0.0v 684.745n 0.0v 684.755n 0.0v 689.745n 0.0v 689.755n 0.0v 694.745n 0.0v 694.755n 0.0v 699.745n 0.0v 699.755n 0.0v 704.745n 0.0v 704.755n 0.95v 709.745n 0.95v 709.755n 0.95v 714.745n 0.95v 714.755n 0.95v 719.745n 0.95v 719.755n 0.95v 724.745n 0.95v 724.755n 0.95v 729.745n 0.95v 729.755n 0.95v 734.745n 0.95v 734.755n 0.95v 739.745n 0.95v 739.755n 0.95v 744.745n 0.95v 744.755n 0.0v 749.745n 0.0v 749.755n 0.0v 754.745n 0.0v 754.755n 0.0v 759.745n 0.0v 759.755n 0.0v 764.745n 0.0v 764.755n 0.0v 769.745n 0.0v 769.755n 0.95v 774.745n 0.95v 774.755n 0.95v 779.745n 0.95v 779.755n 0.95v 784.745n 0.95v 784.755n 0.95v 789.745n 0.95v 789.755n 0.95v 794.745n 0.95v 794.755n 0.95v 799.745n 0.95v 799.755n 0.95v 804.745n 0.95v 804.755n 0.95v 809.745n 0.95v 809.755n 0.0v 814.745n 0.0v 814.755n 0.95v 819.745n 0.95v 819.755n 0.95v 824.745n 0.95v 824.755n 0.95v 829.745n 0.95v 829.755n 0.95v 834.745n 0.95v 834.755n 0.95v 839.745n 0.95v 839.755n 0.95v 844.745n 0.95v 844.755n 0.95v 849.745n 0.95v 849.755n 0.95v 854.745n 0.95v 854.755n 0.95v 859.745n 0.95v 859.755n 0.95v 864.745n 0.95v 864.755n 0.95v 869.745n 0.95v 869.755n 0.95v 874.745n 0.95v 874.755n 0.95v 879.745n 0.95v 879.755n 0.95v 884.745n 0.95v 884.755n 0.95v 889.745n 0.95v 889.755n 0.95v 894.745n 0.95v 894.755n 0.95v 899.745n 0.95v 899.755n 0.0v 904.745n 0.0v 904.755n 0.0v 909.745n 0.0v 909.755n 0.0v 914.745n 0.0v 914.755n 0.95v 919.745n 0.95v 919.755n 0.95v 924.745n 0.95v 924.755n 0.95v 929.745n 0.95v 929.755n 0.95v 934.745n 0.95v 934.755n 0.95v 939.745n 0.95v 939.755n 0.95v 944.745n 0.95v 944.755n 0.95v 949.745n 0.95v 949.755n 0.95v 954.745n 0.95v 954.755n 0.0v 959.745n 0.0v 959.755n 0.0v 964.745n 0.0v 964.755n 0.95v 969.745n 0.95v 969.755n 0.95v 974.745n 0.95v 974.755n 0.95v 979.745n 0.95v 979.755n 0.95v 984.745n 0.95v 984.755n 0.95v 989.745n 0.95v 989.755n 0.95v 994.745n 0.95v 994.755n 0.95v 999.745n 0.95v 999.755n 0.95v 1004.745n 0.95v 1004.755n 0.95v 1009.745n 0.95v 1009.755n 0.0v 1014.745n 0.0v 1014.755n 0.0v 1019.745n 0.0v 1019.755n 0.0v 1024.745n 0.0v 1024.755n 0.0v )
* (time, data): [(0, 0), (5, 0), (10, 0), (15, 1), (20, 1), (25, 1), (30, 1), (35, 1), (40, 0), (45, 0), (50, 0), (55, 0), (60, 0), (65, 0), (70, 0), (75, 1), (80, 1), (85, 1), (90, 1), (95, 0), (100, 0), (105, 0), (110, 0), (115, 0), (120, 0), (125, 0), (130, 0), (135, 0), (140, 1), (145, 0), (150, 1), (155, 1), (160, 1), (165, 1), (170, 1), (175, 1), (180, 1), (185, 0), (190, 0), (195, 0), (200, 0), (205, 0), (210, 0), (215, 0), (220, 0), (225, 1), (230, 1), (235, 1), (240, 1), (245, 0), (250, 0), (255, 0), (260, 0), (265, 0), (270, 0), (275, 0), (280, 0), (285, 0), (290, 0), (295, 0), (300, 0), (305, 1), (310, 1), (315, 1), (320, 1), (325, 1), (330, 1), (335, 1), (340, 1), (345, 1), (350, 1), (355, 1), (360, 1), (365, 0), (370, 0), (375, 0), (380, 0), (385, 0), (390, 0), (395, 0), (400, 1), (405, 1), (410, 1), (415, 1), (420, 0), (425, 0), (430, 0), (435, 0), (440, 1), (445, 1), (450, 1), (455, 1), (460, 1), (465, 1), (470, 1), (475, 1), (480, 1), (485, 1), (490, 1), (495, 1), (500, 1), (505, 1), (510, 1), (515, 0), (520, 0), (525, 0), (530, 0), (535, 1), (540, 1), (545, 1), (550, 0), (555, 0), (560, 1), (565, 0), (570, 0), (575, 0), (580, 1), (585, 1), (590, 1), (595, 1), (600, 1), (605, 0), (610, 0), (615, 1), (620, 1), (625, 1), (630, 0), (635, 0), (640, 1), (645, 1), (650, 1), (655, 1), (660, 1), (665, 1), (670, 1), (675, 0), (680, 0), (685, 0), (690, 0), (695, 0), (700, 0), (705, 1), (710, 1), (715, 1), (720, 1), (725, 1), (730, 1), (735, 1), (740, 1), (745, 0), (750, 0), (755, 0), (760, 0), (765, 0), (770, 1), (775, 1), (780, 1), (785, 1), (790, 1), (795, 1), (800, 1), (805, 1), (810, 1), (815, 0), (820, 0), (825, 0), (830, 0), (835, 0), (840, 0), (845, 0), (850, 0), (855, 0), (860, 0), (865, 0), (870, 1), (875, 1), (880, 0), (885, 1), (890, 1), (895, 0), (900, 0), (905, 0), (910, 0), (915, 1), (920, 1), (925, 1), (930, 1), (935, 1), (940, 1), (945, 1), (950, 1), (955, 1), (960, 1), (965, 0), (970, 0), (975, 0), (980, 0), (985, 0), (990, 0), (995, 0), (1000, 0), (1005, 0), (1010, 0), (1015, 0), (1020, 0), (1025, 0)]
Vdin0_12  din0_12  0 PWL (0n 0.0v 4.745n 0.0v 4.755n 0.0v 9.745n 0.0v 9.755n 0.0v 14.745n 0.0v 14.755n 0.95v 19.745n 0.95v 19.755n 0.95v 24.745n 0.95v 24.755n 0.95v 29.745n 0.95v 29.755n 0.95v 34.745n 0.95v 34.755n 0.95v 39.745n 0.95v 39.755n 0.0v 44.745n 0.0v 44.755n 0.0v 49.745n 0.0v 49.755n 0.0v 54.745n 0.0v 54.755n 0.0v 59.745n 0.0v 59.755n 0.0v 64.745n 0.0v 64.755n 0.0v 69.745n 0.0v 69.755n 0.0v 74.745n 0.0v 74.755n 0.95v 79.745n 0.95v 79.755n 0.95v 84.745n 0.95v 84.755n 0.95v 89.745n 0.95v 89.755n 0.95v 94.745n 0.95v 94.755n 0.0v 99.745n 0.0v 99.755n 0.0v 104.745n 0.0v 104.755n 0.0v 109.745n 0.0v 109.755n 0.0v 114.745n 0.0v 114.755n 0.0v 119.745n 0.0v 119.755n 0.0v 124.745n 0.0v 124.755n 0.0v 129.745n 0.0v 129.755n 0.0v 134.745n 0.0v 134.755n 0.0v 139.745n 0.0v 139.755n 0.95v 144.745n 0.95v 144.755n 0.0v 149.745n 0.0v 149.755n 0.95v 154.745n 0.95v 154.755n 0.95v 159.745n 0.95v 159.755n 0.95v 164.745n 0.95v 164.755n 0.95v 169.745n 0.95v 169.755n 0.95v 174.745n 0.95v 174.755n 0.95v 179.745n 0.95v 179.755n 0.95v 184.745n 0.95v 184.755n 0.0v 189.745n 0.0v 189.755n 0.0v 194.745n 0.0v 194.755n 0.0v 199.745n 0.0v 199.755n 0.0v 204.745n 0.0v 204.755n 0.0v 209.745n 0.0v 209.755n 0.0v 214.745n 0.0v 214.755n 0.0v 219.745n 0.0v 219.755n 0.0v 224.745n 0.0v 224.755n 0.95v 229.745n 0.95v 229.755n 0.95v 234.745n 0.95v 234.755n 0.95v 239.745n 0.95v 239.755n 0.95v 244.745n 0.95v 244.755n 0.0v 249.745n 0.0v 249.755n 0.0v 254.745n 0.0v 254.755n 0.0v 259.745n 0.0v 259.755n 0.0v 264.745n 0.0v 264.755n 0.0v 269.745n 0.0v 269.755n 0.0v 274.745n 0.0v 274.755n 0.0v 279.745n 0.0v 279.755n 0.0v 284.745n 0.0v 284.755n 0.0v 289.745n 0.0v 289.755n 0.0v 294.745n 0.0v 294.755n 0.0v 299.745n 0.0v 299.755n 0.0v 304.745n 0.0v 304.755n 0.95v 309.745n 0.95v 309.755n 0.95v 314.745n 0.95v 314.755n 0.95v 319.745n 0.95v 319.755n 0.95v 324.745n 0.95v 324.755n 0.95v 329.745n 0.95v 329.755n 0.95v 334.745n 0.95v 334.755n 0.95v 339.745n 0.95v 339.755n 0.95v 344.745n 0.95v 344.755n 0.95v 349.745n 0.95v 349.755n 0.95v 354.745n 0.95v 354.755n 0.95v 359.745n 0.95v 359.755n 0.95v 364.745n 0.95v 364.755n 0.0v 369.745n 0.0v 369.755n 0.0v 374.745n 0.0v 374.755n 0.0v 379.745n 0.0v 379.755n 0.0v 384.745n 0.0v 384.755n 0.0v 389.745n 0.0v 389.755n 0.0v 394.745n 0.0v 394.755n 0.0v 399.745n 0.0v 399.755n 0.95v 404.745n 0.95v 404.755n 0.95v 409.745n 0.95v 409.755n 0.95v 414.745n 0.95v 414.755n 0.95v 419.745n 0.95v 419.755n 0.0v 424.745n 0.0v 424.755n 0.0v 429.745n 0.0v 429.755n 0.0v 434.745n 0.0v 434.755n 0.0v 439.745n 0.0v 439.755n 0.95v 444.745n 0.95v 444.755n 0.95v 449.745n 0.95v 449.755n 0.95v 454.745n 0.95v 454.755n 0.95v 459.745n 0.95v 459.755n 0.95v 464.745n 0.95v 464.755n 0.95v 469.745n 0.95v 469.755n 0.95v 474.745n 0.95v 474.755n 0.95v 479.745n 0.95v 479.755n 0.95v 484.745n 0.95v 484.755n 0.95v 489.745n 0.95v 489.755n 0.95v 494.745n 0.95v 494.755n 0.95v 499.745n 0.95v 499.755n 0.95v 504.745n 0.95v 504.755n 0.95v 509.745n 0.95v 509.755n 0.95v 514.745n 0.95v 514.755n 0.0v 519.745n 0.0v 519.755n 0.0v 524.745n 0.0v 524.755n 0.0v 529.745n 0.0v 529.755n 0.0v 534.745n 0.0v 534.755n 0.95v 539.745n 0.95v 539.755n 0.95v 544.745n 0.95v 544.755n 0.95v 549.745n 0.95v 549.755n 0.0v 554.745n 0.0v 554.755n 0.0v 559.745n 0.0v 559.755n 0.95v 564.745n 0.95v 564.755n 0.0v 569.745n 0.0v 569.755n 0.0v 574.745n 0.0v 574.755n 0.0v 579.745n 0.0v 579.755n 0.95v 584.745n 0.95v 584.755n 0.95v 589.745n 0.95v 589.755n 0.95v 594.745n 0.95v 594.755n 0.95v 599.745n 0.95v 599.755n 0.95v 604.745n 0.95v 604.755n 0.0v 609.745n 0.0v 609.755n 0.0v 614.745n 0.0v 614.755n 0.95v 619.745n 0.95v 619.755n 0.95v 624.745n 0.95v 624.755n 0.95v 629.745n 0.95v 629.755n 0.0v 634.745n 0.0v 634.755n 0.0v 639.745n 0.0v 639.755n 0.95v 644.745n 0.95v 644.755n 0.95v 649.745n 0.95v 649.755n 0.95v 654.745n 0.95v 654.755n 0.95v 659.745n 0.95v 659.755n 0.95v 664.745n 0.95v 664.755n 0.95v 669.745n 0.95v 669.755n 0.95v 674.745n 0.95v 674.755n 0.0v 679.745n 0.0v 679.755n 0.0v 684.745n 0.0v 684.755n 0.0v 689.745n 0.0v 689.755n 0.0v 694.745n 0.0v 694.755n 0.0v 699.745n 0.0v 699.755n 0.0v 704.745n 0.0v 704.755n 0.95v 709.745n 0.95v 709.755n 0.95v 714.745n 0.95v 714.755n 0.95v 719.745n 0.95v 719.755n 0.95v 724.745n 0.95v 724.755n 0.95v 729.745n 0.95v 729.755n 0.95v 734.745n 0.95v 734.755n 0.95v 739.745n 0.95v 739.755n 0.95v 744.745n 0.95v 744.755n 0.0v 749.745n 0.0v 749.755n 0.0v 754.745n 0.0v 754.755n 0.0v 759.745n 0.0v 759.755n 0.0v 764.745n 0.0v 764.755n 0.0v 769.745n 0.0v 769.755n 0.95v 774.745n 0.95v 774.755n 0.95v 779.745n 0.95v 779.755n 0.95v 784.745n 0.95v 784.755n 0.95v 789.745n 0.95v 789.755n 0.95v 794.745n 0.95v 794.755n 0.95v 799.745n 0.95v 799.755n 0.95v 804.745n 0.95v 804.755n 0.95v 809.745n 0.95v 809.755n 0.95v 814.745n 0.95v 814.755n 0.0v 819.745n 0.0v 819.755n 0.0v 824.745n 0.0v 824.755n 0.0v 829.745n 0.0v 829.755n 0.0v 834.745n 0.0v 834.755n 0.0v 839.745n 0.0v 839.755n 0.0v 844.745n 0.0v 844.755n 0.0v 849.745n 0.0v 849.755n 0.0v 854.745n 0.0v 854.755n 0.0v 859.745n 0.0v 859.755n 0.0v 864.745n 0.0v 864.755n 0.0v 869.745n 0.0v 869.755n 0.95v 874.745n 0.95v 874.755n 0.95v 879.745n 0.95v 879.755n 0.0v 884.745n 0.0v 884.755n 0.95v 889.745n 0.95v 889.755n 0.95v 894.745n 0.95v 894.755n 0.0v 899.745n 0.0v 899.755n 0.0v 904.745n 0.0v 904.755n 0.0v 909.745n 0.0v 909.755n 0.0v 914.745n 0.0v 914.755n 0.95v 919.745n 0.95v 919.755n 0.95v 924.745n 0.95v 924.755n 0.95v 929.745n 0.95v 929.755n 0.95v 934.745n 0.95v 934.755n 0.95v 939.745n 0.95v 939.755n 0.95v 944.745n 0.95v 944.755n 0.95v 949.745n 0.95v 949.755n 0.95v 954.745n 0.95v 954.755n 0.95v 959.745n 0.95v 959.755n 0.95v 964.745n 0.95v 964.755n 0.0v 969.745n 0.0v 969.755n 0.0v 974.745n 0.0v 974.755n 0.0v 979.745n 0.0v 979.755n 0.0v 984.745n 0.0v 984.755n 0.0v 989.745n 0.0v 989.755n 0.0v 994.745n 0.0v 994.755n 0.0v 999.745n 0.0v 999.755n 0.0v 1004.745n 0.0v 1004.755n 0.0v 1009.745n 0.0v 1009.755n 0.0v 1014.745n 0.0v 1014.755n 0.0v 1019.745n 0.0v 1019.755n 0.0v 1024.745n 0.0v 1024.755n 0.0v )
* (time, data): [(0, 0), (5, 0), (10, 1), (15, 1), (20, 1), (25, 1), (30, 1), (35, 1), (40, 0), (45, 0), (50, 0), (55, 0), (60, 0), (65, 0), (70, 0), (75, 0), (80, 0), (85, 0), (90, 0), (95, 0), (100, 0), (105, 0), (110, 0), (115, 0), (120, 0), (125, 0), (130, 0), (135, 1), (140, 0), (145, 1), (150, 0), (155, 0), (160, 0), (165, 1), (170, 1), (175, 1), (180, 1), (185, 0), (190, 0), (195, 0), (200, 0), (205, 0), (210, 0), (215, 0), (220, 1), (225, 1), (230, 1), (235, 1), (240, 1), (245, 1), (250, 1), (255, 1), (260, 1), (265, 1), (270, 1), (275, 1), (280, 1), (285, 1), (290, 1), (295, 1), (300, 1), (305, 0), (310, 0), (315, 0), (320, 0), (325, 0), (330, 0), (335, 0), (340, 0), (345, 0), (350, 0), (355, 0), (360, 0), (365, 1), (370, 1), (375, 0), (380, 1), (385, 1), (390, 1), (395, 1), (400, 0), (405, 0), (410, 0), (415, 0), (420, 1), (425, 1), (430, 1), (435, 1), (440, 0), (445, 0), (450, 0), (455, 0), (460, 0), (465, 1), (470, 1), (475, 1), (480, 1), (485, 1), (490, 1), (495, 1), (500, 1), (505, 1), (510, 0), (515, 1), (520, 1), (525, 1), (530, 1), (535, 0), (540, 0), (545, 0), (550, 1), (555, 1), (560, 0), (565, 0), (570, 0), (575, 0), (580, 0), (585, 0), (590, 0), (595, 0), (600, 0), (605, 1), (610, 1), (615, 0), (620, 0), (625, 0), (630, 1), (635, 0), (640, 0), (645, 0), (650, 0), (655, 0), (660, 0), (665, 0), (670, 0), (675, 0), (680, 0), (685, 0), (690, 0), (695, 0), (700, 0), (705, 0), (710, 0), (715, 0), (720, 0), (725, 0), (730, 0), (735, 0), (740, 0), (745, 1), (750, 1), (755, 1), (760, 1), (765, 1), (770, 0), (775, 0), (780, 0), (785, 0), (790, 0), (795, 0), (800, 0), (805, 0), (810, 0), (815, 0), (820, 0), (825, 0), (830, 0), (835, 0), (840, 0), (845, 0), (850, 0), (855, 0), (860, 0), (865, 0), (870, 1), (875, 1), (880, 1), (885, 0), (890, 1), (895, 0), (900, 1), (905, 1), (910, 1), (915, 0), (920, 0), (925, 0), (930, 0), (935, 0), (940, 1), (945, 1), (950, 1), (955, 1), (960, 1), (965, 0), (970, 0), (975, 0), (980, 0), (985, 0), (990, 0), (995, 0), (1000, 0), (1005, 0), (1010, 0), (1015, 0), (1020, 0), (1025, 0)]
Vdin0_13  din0_13  0 PWL (0n 0.0v 4.745n 0.0v 4.755n 0.0v 9.745n 0.0v 9.755n 0.95v 14.745n 0.95v 14.755n 0.95v 19.745n 0.95v 19.755n 0.95v 24.745n 0.95v 24.755n 0.95v 29.745n 0.95v 29.755n 0.95v 34.745n 0.95v 34.755n 0.95v 39.745n 0.95v 39.755n 0.0v 44.745n 0.0v 44.755n 0.0v 49.745n 0.0v 49.755n 0.0v 54.745n 0.0v 54.755n 0.0v 59.745n 0.0v 59.755n 0.0v 64.745n 0.0v 64.755n 0.0v 69.745n 0.0v 69.755n 0.0v 74.745n 0.0v 74.755n 0.0v 79.745n 0.0v 79.755n 0.0v 84.745n 0.0v 84.755n 0.0v 89.745n 0.0v 89.755n 0.0v 94.745n 0.0v 94.755n 0.0v 99.745n 0.0v 99.755n 0.0v 104.745n 0.0v 104.755n 0.0v 109.745n 0.0v 109.755n 0.0v 114.745n 0.0v 114.755n 0.0v 119.745n 0.0v 119.755n 0.0v 124.745n 0.0v 124.755n 0.0v 129.745n 0.0v 129.755n 0.0v 134.745n 0.0v 134.755n 0.95v 139.745n 0.95v 139.755n 0.0v 144.745n 0.0v 144.755n 0.95v 149.745n 0.95v 149.755n 0.0v 154.745n 0.0v 154.755n 0.0v 159.745n 0.0v 159.755n 0.0v 164.745n 0.0v 164.755n 0.95v 169.745n 0.95v 169.755n 0.95v 174.745n 0.95v 174.755n 0.95v 179.745n 0.95v 179.755n 0.95v 184.745n 0.95v 184.755n 0.0v 189.745n 0.0v 189.755n 0.0v 194.745n 0.0v 194.755n 0.0v 199.745n 0.0v 199.755n 0.0v 204.745n 0.0v 204.755n 0.0v 209.745n 0.0v 209.755n 0.0v 214.745n 0.0v 214.755n 0.0v 219.745n 0.0v 219.755n 0.95v 224.745n 0.95v 224.755n 0.95v 229.745n 0.95v 229.755n 0.95v 234.745n 0.95v 234.755n 0.95v 239.745n 0.95v 239.755n 0.95v 244.745n 0.95v 244.755n 0.95v 249.745n 0.95v 249.755n 0.95v 254.745n 0.95v 254.755n 0.95v 259.745n 0.95v 259.755n 0.95v 264.745n 0.95v 264.755n 0.95v 269.745n 0.95v 269.755n 0.95v 274.745n 0.95v 274.755n 0.95v 279.745n 0.95v 279.755n 0.95v 284.745n 0.95v 284.755n 0.95v 289.745n 0.95v 289.755n 0.95v 294.745n 0.95v 294.755n 0.95v 299.745n 0.95v 299.755n 0.95v 304.745n 0.95v 304.755n 0.0v 309.745n 0.0v 309.755n 0.0v 314.745n 0.0v 314.755n 0.0v 319.745n 0.0v 319.755n 0.0v 324.745n 0.0v 324.755n 0.0v 329.745n 0.0v 329.755n 0.0v 334.745n 0.0v 334.755n 0.0v 339.745n 0.0v 339.755n 0.0v 344.745n 0.0v 344.755n 0.0v 349.745n 0.0v 349.755n 0.0v 354.745n 0.0v 354.755n 0.0v 359.745n 0.0v 359.755n 0.0v 364.745n 0.0v 364.755n 0.95v 369.745n 0.95v 369.755n 0.95v 374.745n 0.95v 374.755n 0.0v 379.745n 0.0v 379.755n 0.95v 384.745n 0.95v 384.755n 0.95v 389.745n 0.95v 389.755n 0.95v 394.745n 0.95v 394.755n 0.95v 399.745n 0.95v 399.755n 0.0v 404.745n 0.0v 404.755n 0.0v 409.745n 0.0v 409.755n 0.0v 414.745n 0.0v 414.755n 0.0v 419.745n 0.0v 419.755n 0.95v 424.745n 0.95v 424.755n 0.95v 429.745n 0.95v 429.755n 0.95v 434.745n 0.95v 434.755n 0.95v 439.745n 0.95v 439.755n 0.0v 444.745n 0.0v 444.755n 0.0v 449.745n 0.0v 449.755n 0.0v 454.745n 0.0v 454.755n 0.0v 459.745n 0.0v 459.755n 0.0v 464.745n 0.0v 464.755n 0.95v 469.745n 0.95v 469.755n 0.95v 474.745n 0.95v 474.755n 0.95v 479.745n 0.95v 479.755n 0.95v 484.745n 0.95v 484.755n 0.95v 489.745n 0.95v 489.755n 0.95v 494.745n 0.95v 494.755n 0.95v 499.745n 0.95v 499.755n 0.95v 504.745n 0.95v 504.755n 0.95v 509.745n 0.95v 509.755n 0.0v 514.745n 0.0v 514.755n 0.95v 519.745n 0.95v 519.755n 0.95v 524.745n 0.95v 524.755n 0.95v 529.745n 0.95v 529.755n 0.95v 534.745n 0.95v 534.755n 0.0v 539.745n 0.0v 539.755n 0.0v 544.745n 0.0v 544.755n 0.0v 549.745n 0.0v 549.755n 0.95v 554.745n 0.95v 554.755n 0.95v 559.745n 0.95v 559.755n 0.0v 564.745n 0.0v 564.755n 0.0v 569.745n 0.0v 569.755n 0.0v 574.745n 0.0v 574.755n 0.0v 579.745n 0.0v 579.755n 0.0v 584.745n 0.0v 584.755n 0.0v 589.745n 0.0v 589.755n 0.0v 594.745n 0.0v 594.755n 0.0v 599.745n 0.0v 599.755n 0.0v 604.745n 0.0v 604.755n 0.95v 609.745n 0.95v 609.755n 0.95v 614.745n 0.95v 614.755n 0.0v 619.745n 0.0v 619.755n 0.0v 624.745n 0.0v 624.755n 0.0v 629.745n 0.0v 629.755n 0.95v 634.745n 0.95v 634.755n 0.0v 639.745n 0.0v 639.755n 0.0v 644.745n 0.0v 644.755n 0.0v 649.745n 0.0v 649.755n 0.0v 654.745n 0.0v 654.755n 0.0v 659.745n 0.0v 659.755n 0.0v 664.745n 0.0v 664.755n 0.0v 669.745n 0.0v 669.755n 0.0v 674.745n 0.0v 674.755n 0.0v 679.745n 0.0v 679.755n 0.0v 684.745n 0.0v 684.755n 0.0v 689.745n 0.0v 689.755n 0.0v 694.745n 0.0v 694.755n 0.0v 699.745n 0.0v 699.755n 0.0v 704.745n 0.0v 704.755n 0.0v 709.745n 0.0v 709.755n 0.0v 714.745n 0.0v 714.755n 0.0v 719.745n 0.0v 719.755n 0.0v 724.745n 0.0v 724.755n 0.0v 729.745n 0.0v 729.755n 0.0v 734.745n 0.0v 734.755n 0.0v 739.745n 0.0v 739.755n 0.0v 744.745n 0.0v 744.755n 0.95v 749.745n 0.95v 749.755n 0.95v 754.745n 0.95v 754.755n 0.95v 759.745n 0.95v 759.755n 0.95v 764.745n 0.95v 764.755n 0.95v 769.745n 0.95v 769.755n 0.0v 774.745n 0.0v 774.755n 0.0v 779.745n 0.0v 779.755n 0.0v 784.745n 0.0v 784.755n 0.0v 789.745n 0.0v 789.755n 0.0v 794.745n 0.0v 794.755n 0.0v 799.745n 0.0v 799.755n 0.0v 804.745n 0.0v 804.755n 0.0v 809.745n 0.0v 809.755n 0.0v 814.745n 0.0v 814.755n 0.0v 819.745n 0.0v 819.755n 0.0v 824.745n 0.0v 824.755n 0.0v 829.745n 0.0v 829.755n 0.0v 834.745n 0.0v 834.755n 0.0v 839.745n 0.0v 839.755n 0.0v 844.745n 0.0v 844.755n 0.0v 849.745n 0.0v 849.755n 0.0v 854.745n 0.0v 854.755n 0.0v 859.745n 0.0v 859.755n 0.0v 864.745n 0.0v 864.755n 0.0v 869.745n 0.0v 869.755n 0.95v 874.745n 0.95v 874.755n 0.95v 879.745n 0.95v 879.755n 0.95v 884.745n 0.95v 884.755n 0.0v 889.745n 0.0v 889.755n 0.95v 894.745n 0.95v 894.755n 0.0v 899.745n 0.0v 899.755n 0.95v 904.745n 0.95v 904.755n 0.95v 909.745n 0.95v 909.755n 0.95v 914.745n 0.95v 914.755n 0.0v 919.745n 0.0v 919.755n 0.0v 924.745n 0.0v 924.755n 0.0v 929.745n 0.0v 929.755n 0.0v 934.745n 0.0v 934.755n 0.0v 939.745n 0.0v 939.755n 0.95v 944.745n 0.95v 944.755n 0.95v 949.745n 0.95v 949.755n 0.95v 954.745n 0.95v 954.755n 0.95v 959.745n 0.95v 959.755n 0.95v 964.745n 0.95v 964.755n 0.0v 969.745n 0.0v 969.755n 0.0v 974.745n 0.0v 974.755n 0.0v 979.745n 0.0v 979.755n 0.0v 984.745n 0.0v 984.755n 0.0v 989.745n 0.0v 989.755n 0.0v 994.745n 0.0v 994.755n 0.0v 999.745n 0.0v 999.755n 0.0v 1004.745n 0.0v 1004.755n 0.0v 1009.745n 0.0v 1009.755n 0.0v 1014.745n 0.0v 1014.755n 0.0v 1019.745n 0.0v 1019.755n 0.0v 1024.745n 0.0v 1024.755n 0.0v )
* (time, data): [(0, 0), (5, 0), (10, 0), (15, 0), (20, 0), (25, 1), (30, 0), (35, 0), (40, 0), (45, 0), (50, 0), (55, 0), (60, 0), (65, 1), (70, 1), (75, 1), (80, 1), (85, 1), (90, 1), (95, 0), (100, 0), (105, 0), (110, 0), (115, 0), (120, 0), (125, 0), (130, 0), (135, 0), (140, 0), (145, 1), (150, 0), (155, 0), (160, 0), (165, 1), (170, 1), (175, 1), (180, 1), (185, 0), (190, 0), (195, 0), (200, 0), (205, 0), (210, 0), (215, 0), (220, 1), (225, 1), (230, 0), (235, 0), (240, 0), (245, 0), (250, 0), (255, 0), (260, 0), (265, 0), (270, 1), (275, 1), (280, 1), (285, 1), (290, 1), (295, 1), (300, 1), (305, 0), (310, 0), (315, 0), (320, 1), (325, 1), (330, 1), (335, 1), (340, 1), (345, 1), (350, 1), (355, 1), (360, 1), (365, 0), (370, 0), (375, 1), (380, 0), (385, 0), (390, 0), (395, 0), (400, 1), (405, 1), (410, 1), (415, 1), (420, 0), (425, 0), (430, 0), (435, 0), (440, 1), (445, 1), (450, 1), (455, 1), (460, 1), (465, 0), (470, 0), (475, 0), (480, 0), (485, 0), (490, 0), (495, 0), (500, 0), (505, 1), (510, 1), (515, 1), (520, 1), (525, 1), (530, 1), (535, 0), (540, 0), (545, 0), (550, 1), (555, 1), (560, 1), (565, 1), (570, 1), (575, 1), (580, 0), (585, 0), (590, 0), (595, 0), (600, 0), (605, 1), (610, 1), (615, 1), (620, 1), (625, 1), (630, 1), (635, 0), (640, 0), (645, 0), (650, 0), (655, 0), (660, 0), (665, 0), (670, 1), (675, 1), (680, 1), (685, 1), (690, 1), (695, 1), (700, 1), (705, 1), (710, 1), (715, 1), (720, 1), (725, 1), (730, 1), (735, 1), (740, 1), (745, 1), (750, 1), (755, 1), (760, 1), (765, 1), (770, 1), (775, 1), (780, 1), (785, 1), (790, 1), (795, 1), (800, 1), (805, 1), (810, 0), (815, 0), (820, 0), (825, 0), (830, 0), (835, 0), (840, 0), (845, 0), (850, 0), (855, 0), (860, 0), (865, 0), (870, 0), (875, 0), (880, 0), (885, 0), (890, 0), (895, 0), (900, 0), (905, 0), (910, 0), (915, 0), (920, 0), (925, 0), (930, 0), (935, 0), (940, 0), (945, 0), (950, 0), (955, 0), (960, 0), (965, 0), (970, 0), (975, 0), (980, 0), (985, 0), (990, 0), (995, 0), (1000, 0), (1005, 0), (1010, 0), (1015, 0), (1020, 0), (1025, 0)]
Vdin0_14  din0_14  0 PWL (0n 0.0v 4.745n 0.0v 4.755n 0.0v 9.745n 0.0v 9.755n 0.0v 14.745n 0.0v 14.755n 0.0v 19.745n 0.0v 19.755n 0.0v 24.745n 0.0v 24.755n 0.95v 29.745n 0.95v 29.755n 0.0v 34.745n 0.0v 34.755n 0.0v 39.745n 0.0v 39.755n 0.0v 44.745n 0.0v 44.755n 0.0v 49.745n 0.0v 49.755n 0.0v 54.745n 0.0v 54.755n 0.0v 59.745n 0.0v 59.755n 0.0v 64.745n 0.0v 64.755n 0.95v 69.745n 0.95v 69.755n 0.95v 74.745n 0.95v 74.755n 0.95v 79.745n 0.95v 79.755n 0.95v 84.745n 0.95v 84.755n 0.95v 89.745n 0.95v 89.755n 0.95v 94.745n 0.95v 94.755n 0.0v 99.745n 0.0v 99.755n 0.0v 104.745n 0.0v 104.755n 0.0v 109.745n 0.0v 109.755n 0.0v 114.745n 0.0v 114.755n 0.0v 119.745n 0.0v 119.755n 0.0v 124.745n 0.0v 124.755n 0.0v 129.745n 0.0v 129.755n 0.0v 134.745n 0.0v 134.755n 0.0v 139.745n 0.0v 139.755n 0.0v 144.745n 0.0v 144.755n 0.95v 149.745n 0.95v 149.755n 0.0v 154.745n 0.0v 154.755n 0.0v 159.745n 0.0v 159.755n 0.0v 164.745n 0.0v 164.755n 0.95v 169.745n 0.95v 169.755n 0.95v 174.745n 0.95v 174.755n 0.95v 179.745n 0.95v 179.755n 0.95v 184.745n 0.95v 184.755n 0.0v 189.745n 0.0v 189.755n 0.0v 194.745n 0.0v 194.755n 0.0v 199.745n 0.0v 199.755n 0.0v 204.745n 0.0v 204.755n 0.0v 209.745n 0.0v 209.755n 0.0v 214.745n 0.0v 214.755n 0.0v 219.745n 0.0v 219.755n 0.95v 224.745n 0.95v 224.755n 0.95v 229.745n 0.95v 229.755n 0.0v 234.745n 0.0v 234.755n 0.0v 239.745n 0.0v 239.755n 0.0v 244.745n 0.0v 244.755n 0.0v 249.745n 0.0v 249.755n 0.0v 254.745n 0.0v 254.755n 0.0v 259.745n 0.0v 259.755n 0.0v 264.745n 0.0v 264.755n 0.0v 269.745n 0.0v 269.755n 0.95v 274.745n 0.95v 274.755n 0.95v 279.745n 0.95v 279.755n 0.95v 284.745n 0.95v 284.755n 0.95v 289.745n 0.95v 289.755n 0.95v 294.745n 0.95v 294.755n 0.95v 299.745n 0.95v 299.755n 0.95v 304.745n 0.95v 304.755n 0.0v 309.745n 0.0v 309.755n 0.0v 314.745n 0.0v 314.755n 0.0v 319.745n 0.0v 319.755n 0.95v 324.745n 0.95v 324.755n 0.95v 329.745n 0.95v 329.755n 0.95v 334.745n 0.95v 334.755n 0.95v 339.745n 0.95v 339.755n 0.95v 344.745n 0.95v 344.755n 0.95v 349.745n 0.95v 349.755n 0.95v 354.745n 0.95v 354.755n 0.95v 359.745n 0.95v 359.755n 0.95v 364.745n 0.95v 364.755n 0.0v 369.745n 0.0v 369.755n 0.0v 374.745n 0.0v 374.755n 0.95v 379.745n 0.95v 379.755n 0.0v 384.745n 0.0v 384.755n 0.0v 389.745n 0.0v 389.755n 0.0v 394.745n 0.0v 394.755n 0.0v 399.745n 0.0v 399.755n 0.95v 404.745n 0.95v 404.755n 0.95v 409.745n 0.95v 409.755n 0.95v 414.745n 0.95v 414.755n 0.95v 419.745n 0.95v 419.755n 0.0v 424.745n 0.0v 424.755n 0.0v 429.745n 0.0v 429.755n 0.0v 434.745n 0.0v 434.755n 0.0v 439.745n 0.0v 439.755n 0.95v 444.745n 0.95v 444.755n 0.95v 449.745n 0.95v 449.755n 0.95v 454.745n 0.95v 454.755n 0.95v 459.745n 0.95v 459.755n 0.95v 464.745n 0.95v 464.755n 0.0v 469.745n 0.0v 469.755n 0.0v 474.745n 0.0v 474.755n 0.0v 479.745n 0.0v 479.755n 0.0v 484.745n 0.0v 484.755n 0.0v 489.745n 0.0v 489.755n 0.0v 494.745n 0.0v 494.755n 0.0v 499.745n 0.0v 499.755n 0.0v 504.745n 0.0v 504.755n 0.95v 509.745n 0.95v 509.755n 0.95v 514.745n 0.95v 514.755n 0.95v 519.745n 0.95v 519.755n 0.95v 524.745n 0.95v 524.755n 0.95v 529.745n 0.95v 529.755n 0.95v 534.745n 0.95v 534.755n 0.0v 539.745n 0.0v 539.755n 0.0v 544.745n 0.0v 544.755n 0.0v 549.745n 0.0v 549.755n 0.95v 554.745n 0.95v 554.755n 0.95v 559.745n 0.95v 559.755n 0.95v 564.745n 0.95v 564.755n 0.95v 569.745n 0.95v 569.755n 0.95v 574.745n 0.95v 574.755n 0.95v 579.745n 0.95v 579.755n 0.0v 584.745n 0.0v 584.755n 0.0v 589.745n 0.0v 589.755n 0.0v 594.745n 0.0v 594.755n 0.0v 599.745n 0.0v 599.755n 0.0v 604.745n 0.0v 604.755n 0.95v 609.745n 0.95v 609.755n 0.95v 614.745n 0.95v 614.755n 0.95v 619.745n 0.95v 619.755n 0.95v 624.745n 0.95v 624.755n 0.95v 629.745n 0.95v 629.755n 0.95v 634.745n 0.95v 634.755n 0.0v 639.745n 0.0v 639.755n 0.0v 644.745n 0.0v 644.755n 0.0v 649.745n 0.0v 649.755n 0.0v 654.745n 0.0v 654.755n 0.0v 659.745n 0.0v 659.755n 0.0v 664.745n 0.0v 664.755n 0.0v 669.745n 0.0v 669.755n 0.95v 674.745n 0.95v 674.755n 0.95v 679.745n 0.95v 679.755n 0.95v 684.745n 0.95v 684.755n 0.95v 689.745n 0.95v 689.755n 0.95v 694.745n 0.95v 694.755n 0.95v 699.745n 0.95v 699.755n 0.95v 704.745n 0.95v 704.755n 0.95v 709.745n 0.95v 709.755n 0.95v 714.745n 0.95v 714.755n 0.95v 719.745n 0.95v 719.755n 0.95v 724.745n 0.95v 724.755n 0.95v 729.745n 0.95v 729.755n 0.95v 734.745n 0.95v 734.755n 0.95v 739.745n 0.95v 739.755n 0.95v 744.745n 0.95v 744.755n 0.95v 749.745n 0.95v 749.755n 0.95v 754.745n 0.95v 754.755n 0.95v 759.745n 0.95v 759.755n 0.95v 764.745n 0.95v 764.755n 0.95v 769.745n 0.95v 769.755n 0.95v 774.745n 0.95v 774.755n 0.95v 779.745n 0.95v 779.755n 0.95v 784.745n 0.95v 784.755n 0.95v 789.745n 0.95v 789.755n 0.95v 794.745n 0.95v 794.755n 0.95v 799.745n 0.95v 799.755n 0.95v 804.745n 0.95v 804.755n 0.95v 809.745n 0.95v 809.755n 0.0v 814.745n 0.0v 814.755n 0.0v 819.745n 0.0v 819.755n 0.0v 824.745n 0.0v 824.755n 0.0v 829.745n 0.0v 829.755n 0.0v 834.745n 0.0v 834.755n 0.0v 839.745n 0.0v 839.755n 0.0v 844.745n 0.0v 844.755n 0.0v 849.745n 0.0v 849.755n 0.0v 854.745n 0.0v 854.755n 0.0v 859.745n 0.0v 859.755n 0.0v 864.745n 0.0v 864.755n 0.0v 869.745n 0.0v 869.755n 0.0v 874.745n 0.0v 874.755n 0.0v 879.745n 0.0v 879.755n 0.0v 884.745n 0.0v 884.755n 0.0v 889.745n 0.0v 889.755n 0.0v 894.745n 0.0v 894.755n 0.0v 899.745n 0.0v 899.755n 0.0v 904.745n 0.0v 904.755n 0.0v 909.745n 0.0v 909.755n 0.0v 914.745n 0.0v 914.755n 0.0v 919.745n 0.0v 919.755n 0.0v 924.745n 0.0v 924.755n 0.0v 929.745n 0.0v 929.755n 0.0v 934.745n 0.0v 934.755n 0.0v 939.745n 0.0v 939.755n 0.0v 944.745n 0.0v 944.755n 0.0v 949.745n 0.0v 949.755n 0.0v 954.745n 0.0v 954.755n 0.0v 959.745n 0.0v 959.755n 0.0v 964.745n 0.0v 964.755n 0.0v 969.745n 0.0v 969.755n 0.0v 974.745n 0.0v 974.755n 0.0v 979.745n 0.0v 979.755n 0.0v 984.745n 0.0v 984.755n 0.0v 989.745n 0.0v 989.755n 0.0v 994.745n 0.0v 994.755n 0.0v 999.745n 0.0v 999.755n 0.0v 1004.745n 0.0v 1004.755n 0.0v 1009.745n 0.0v 1009.755n 0.0v 1014.745n 0.0v 1014.755n 0.0v 1019.745n 0.0v 1019.755n 0.0v 1024.745n 0.0v 1024.755n 0.0v )
* (time, data): [(0, 0), (5, 1), (10, 0), (15, 1), (20, 1), (25, 1), (30, 0), (35, 0), (40, 0), (45, 1), (50, 1), (55, 1), (60, 1), (65, 0), (70, 0), (75, 1), (80, 1), (85, 1), (90, 1), (95, 0), (100, 0), (105, 0), (110, 0), (115, 0), (120, 0), (125, 0), (130, 0), (135, 1), (140, 1), (145, 1), (150, 1), (155, 1), (160, 1), (165, 1), (170, 1), (175, 1), (180, 1), (185, 1), (190, 1), (195, 1), (200, 1), (205, 1), (210, 1), (215, 1), (220, 1), (225, 1), (230, 0), (235, 0), (240, 0), (245, 1), (250, 1), (255, 1), (260, 1), (265, 1), (270, 1), (275, 1), (280, 1), (285, 1), (290, 1), (295, 1), (300, 1), (305, 0), (310, 0), (315, 0), (320, 0), (325, 0), (330, 0), (335, 0), (340, 0), (345, 0), (350, 0), (355, 0), (360, 0), (365, 1), (370, 1), (375, 1), (380, 1), (385, 1), (390, 1), (395, 1), (400, 1), (405, 1), (410, 1), (415, 1), (420, 0), (425, 0), (430, 0), (435, 0), (440, 1), (445, 1), (450, 0), (455, 0), (460, 0), (465, 0), (470, 0), (475, 0), (480, 0), (485, 0), (490, 0), (495, 0), (500, 0), (505, 1), (510, 0), (515, 1), (520, 1), (525, 1), (530, 1), (535, 0), (540, 0), (545, 0), (550, 0), (555, 0), (560, 1), (565, 0), (570, 0), (575, 0), (580, 0), (585, 0), (590, 0), (595, 0), (600, 0), (605, 0), (610, 0), (615, 0), (620, 0), (625, 0), (630, 1), (635, 0), (640, 1), (645, 1), (650, 1), (655, 1), (660, 1), (665, 1), (670, 1), (675, 0), (680, 0), (685, 0), (690, 0), (695, 0), (700, 0), (705, 0), (710, 0), (715, 0), (720, 0), (725, 0), (730, 0), (735, 1), (740, 1), (745, 1), (750, 1), (755, 1), (760, 1), (765, 1), (770, 0), (775, 0), (780, 0), (785, 0), (790, 0), (795, 0), (800, 0), (805, 0), (810, 1), (815, 1), (820, 1), (825, 1), (830, 1), (835, 1), (840, 1), (845, 1), (850, 1), (855, 1), (860, 1), (865, 1), (870, 0), (875, 0), (880, 0), (885, 0), (890, 1), (895, 1), (900, 1), (905, 1), (910, 1), (915, 1), (920, 1), (925, 1), (930, 1), (935, 1), (940, 0), (945, 0), (950, 0), (955, 0), (960, 0), (965, 1), (970, 1), (975, 1), (980, 1), (985, 1), (990, 1), (995, 1), (1000, 1), (1005, 1), (1010, 1), (1015, 1), (1020, 1), (1025, 1)]
Vdin0_15  din0_15  0 PWL (0n 0.0v 4.745n 0.0v 4.755n 0.95v 9.745n 0.95v 9.755n 0.0v 14.745n 0.0v 14.755n 0.95v 19.745n 0.95v 19.755n 0.95v 24.745n 0.95v 24.755n 0.95v 29.745n 0.95v 29.755n 0.0v 34.745n 0.0v 34.755n 0.0v 39.745n 0.0v 39.755n 0.0v 44.745n 0.0v 44.755n 0.95v 49.745n 0.95v 49.755n 0.95v 54.745n 0.95v 54.755n 0.95v 59.745n 0.95v 59.755n 0.95v 64.745n 0.95v 64.755n 0.0v 69.745n 0.0v 69.755n 0.0v 74.745n 0.0v 74.755n 0.95v 79.745n 0.95v 79.755n 0.95v 84.745n 0.95v 84.755n 0.95v 89.745n 0.95v 89.755n 0.95v 94.745n 0.95v 94.755n 0.0v 99.745n 0.0v 99.755n 0.0v 104.745n 0.0v 104.755n 0.0v 109.745n 0.0v 109.755n 0.0v 114.745n 0.0v 114.755n 0.0v 119.745n 0.0v 119.755n 0.0v 124.745n 0.0v 124.755n 0.0v 129.745n 0.0v 129.755n 0.0v 134.745n 0.0v 134.755n 0.95v 139.745n 0.95v 139.755n 0.95v 144.745n 0.95v 144.755n 0.95v 149.745n 0.95v 149.755n 0.95v 154.745n 0.95v 154.755n 0.95v 159.745n 0.95v 159.755n 0.95v 164.745n 0.95v 164.755n 0.95v 169.745n 0.95v 169.755n 0.95v 174.745n 0.95v 174.755n 0.95v 179.745n 0.95v 179.755n 0.95v 184.745n 0.95v 184.755n 0.95v 189.745n 0.95v 189.755n 0.95v 194.745n 0.95v 194.755n 0.95v 199.745n 0.95v 199.755n 0.95v 204.745n 0.95v 204.755n 0.95v 209.745n 0.95v 209.755n 0.95v 214.745n 0.95v 214.755n 0.95v 219.745n 0.95v 219.755n 0.95v 224.745n 0.95v 224.755n 0.95v 229.745n 0.95v 229.755n 0.0v 234.745n 0.0v 234.755n 0.0v 239.745n 0.0v 239.755n 0.0v 244.745n 0.0v 244.755n 0.95v 249.745n 0.95v 249.755n 0.95v 254.745n 0.95v 254.755n 0.95v 259.745n 0.95v 259.755n 0.95v 264.745n 0.95v 264.755n 0.95v 269.745n 0.95v 269.755n 0.95v 274.745n 0.95v 274.755n 0.95v 279.745n 0.95v 279.755n 0.95v 284.745n 0.95v 284.755n 0.95v 289.745n 0.95v 289.755n 0.95v 294.745n 0.95v 294.755n 0.95v 299.745n 0.95v 299.755n 0.95v 304.745n 0.95v 304.755n 0.0v 309.745n 0.0v 309.755n 0.0v 314.745n 0.0v 314.755n 0.0v 319.745n 0.0v 319.755n 0.0v 324.745n 0.0v 324.755n 0.0v 329.745n 0.0v 329.755n 0.0v 334.745n 0.0v 334.755n 0.0v 339.745n 0.0v 339.755n 0.0v 344.745n 0.0v 344.755n 0.0v 349.745n 0.0v 349.755n 0.0v 354.745n 0.0v 354.755n 0.0v 359.745n 0.0v 359.755n 0.0v 364.745n 0.0v 364.755n 0.95v 369.745n 0.95v 369.755n 0.95v 374.745n 0.95v 374.755n 0.95v 379.745n 0.95v 379.755n 0.95v 384.745n 0.95v 384.755n 0.95v 389.745n 0.95v 389.755n 0.95v 394.745n 0.95v 394.755n 0.95v 399.745n 0.95v 399.755n 0.95v 404.745n 0.95v 404.755n 0.95v 409.745n 0.95v 409.755n 0.95v 414.745n 0.95v 414.755n 0.95v 419.745n 0.95v 419.755n 0.0v 424.745n 0.0v 424.755n 0.0v 429.745n 0.0v 429.755n 0.0v 434.745n 0.0v 434.755n 0.0v 439.745n 0.0v 439.755n 0.95v 444.745n 0.95v 444.755n 0.95v 449.745n 0.95v 449.755n 0.0v 454.745n 0.0v 454.755n 0.0v 459.745n 0.0v 459.755n 0.0v 464.745n 0.0v 464.755n 0.0v 469.745n 0.0v 469.755n 0.0v 474.745n 0.0v 474.755n 0.0v 479.745n 0.0v 479.755n 0.0v 484.745n 0.0v 484.755n 0.0v 489.745n 0.0v 489.755n 0.0v 494.745n 0.0v 494.755n 0.0v 499.745n 0.0v 499.755n 0.0v 504.745n 0.0v 504.755n 0.95v 509.745n 0.95v 509.755n 0.0v 514.745n 0.0v 514.755n 0.95v 519.745n 0.95v 519.755n 0.95v 524.745n 0.95v 524.755n 0.95v 529.745n 0.95v 529.755n 0.95v 534.745n 0.95v 534.755n 0.0v 539.745n 0.0v 539.755n 0.0v 544.745n 0.0v 544.755n 0.0v 549.745n 0.0v 549.755n 0.0v 554.745n 0.0v 554.755n 0.0v 559.745n 0.0v 559.755n 0.95v 564.745n 0.95v 564.755n 0.0v 569.745n 0.0v 569.755n 0.0v 574.745n 0.0v 574.755n 0.0v 579.745n 0.0v 579.755n 0.0v 584.745n 0.0v 584.755n 0.0v 589.745n 0.0v 589.755n 0.0v 594.745n 0.0v 594.755n 0.0v 599.745n 0.0v 599.755n 0.0v 604.745n 0.0v 604.755n 0.0v 609.745n 0.0v 609.755n 0.0v 614.745n 0.0v 614.755n 0.0v 619.745n 0.0v 619.755n 0.0v 624.745n 0.0v 624.755n 0.0v 629.745n 0.0v 629.755n 0.95v 634.745n 0.95v 634.755n 0.0v 639.745n 0.0v 639.755n 0.95v 644.745n 0.95v 644.755n 0.95v 649.745n 0.95v 649.755n 0.95v 654.745n 0.95v 654.755n 0.95v 659.745n 0.95v 659.755n 0.95v 664.745n 0.95v 664.755n 0.95v 669.745n 0.95v 669.755n 0.95v 674.745n 0.95v 674.755n 0.0v 679.745n 0.0v 679.755n 0.0v 684.745n 0.0v 684.755n 0.0v 689.745n 0.0v 689.755n 0.0v 694.745n 0.0v 694.755n 0.0v 699.745n 0.0v 699.755n 0.0v 704.745n 0.0v 704.755n 0.0v 709.745n 0.0v 709.755n 0.0v 714.745n 0.0v 714.755n 0.0v 719.745n 0.0v 719.755n 0.0v 724.745n 0.0v 724.755n 0.0v 729.745n 0.0v 729.755n 0.0v 734.745n 0.0v 734.755n 0.95v 739.745n 0.95v 739.755n 0.95v 744.745n 0.95v 744.755n 0.95v 749.745n 0.95v 749.755n 0.95v 754.745n 0.95v 754.755n 0.95v 759.745n 0.95v 759.755n 0.95v 764.745n 0.95v 764.755n 0.95v 769.745n 0.95v 769.755n 0.0v 774.745n 0.0v 774.755n 0.0v 779.745n 0.0v 779.755n 0.0v 784.745n 0.0v 784.755n 0.0v 789.745n 0.0v 789.755n 0.0v 794.745n 0.0v 794.755n 0.0v 799.745n 0.0v 799.755n 0.0v 804.745n 0.0v 804.755n 0.0v 809.745n 0.0v 809.755n 0.95v 814.745n 0.95v 814.755n 0.95v 819.745n 0.95v 819.755n 0.95v 824.745n 0.95v 824.755n 0.95v 829.745n 0.95v 829.755n 0.95v 834.745n 0.95v 834.755n 0.95v 839.745n 0.95v 839.755n 0.95v 844.745n 0.95v 844.755n 0.95v 849.745n 0.95v 849.755n 0.95v 854.745n 0.95v 854.755n 0.95v 859.745n 0.95v 859.755n 0.95v 864.745n 0.95v 864.755n 0.95v 869.745n 0.95v 869.755n 0.0v 874.745n 0.0v 874.755n 0.0v 879.745n 0.0v 879.755n 0.0v 884.745n 0.0v 884.755n 0.0v 889.745n 0.0v 889.755n 0.95v 894.745n 0.95v 894.755n 0.95v 899.745n 0.95v 899.755n 0.95v 904.745n 0.95v 904.755n 0.95v 909.745n 0.95v 909.755n 0.95v 914.745n 0.95v 914.755n 0.95v 919.745n 0.95v 919.755n 0.95v 924.745n 0.95v 924.755n 0.95v 929.745n 0.95v 929.755n 0.95v 934.745n 0.95v 934.755n 0.95v 939.745n 0.95v 939.755n 0.0v 944.745n 0.0v 944.755n 0.0v 949.745n 0.0v 949.755n 0.0v 954.745n 0.0v 954.755n 0.0v 959.745n 0.0v 959.755n 0.0v 964.745n 0.0v 964.755n 0.95v 969.745n 0.95v 969.755n 0.95v 974.745n 0.95v 974.755n 0.95v 979.745n 0.95v 979.755n 0.95v 984.745n 0.95v 984.755n 0.95v 989.745n 0.95v 989.755n 0.95v 994.745n 0.95v 994.755n 0.95v 999.745n 0.95v 999.755n 0.95v 1004.745n 0.95v 1004.755n 0.95v 1009.745n 0.95v 1009.755n 0.95v 1014.745n 0.95v 1014.755n 0.95v 1019.745n 0.95v 1019.755n 0.95v 1024.745n 0.95v 1024.755n 0.95v )
* (time, data): [(0, 0), (5, 0), (10, 1), (15, 1), (20, 1), (25, 0), (30, 0), (35, 0), (40, 1), (45, 1), (50, 1), (55, 1), (60, 1), (65, 1), (70, 1), (75, 1), (80, 1), (85, 1), (90, 1), (95, 0), (100, 0), (105, 0), (110, 0), (115, 0), (120, 0), (125, 0), (130, 0), (135, 0), (140, 0), (145, 0), (150, 1), (155, 1), (160, 1), (165, 1), (170, 1), (175, 1), (180, 1), (185, 1), (190, 1), (195, 1), (200, 1), (205, 1), (210, 1), (215, 1), (220, 0), (225, 0), (230, 1), (235, 1), (240, 1), (245, 0), (250, 0), (255, 0), (260, 0), (265, 0), (270, 1), (275, 1), (280, 1), (285, 1), (290, 1), (295, 1), (300, 1), (305, 0), (310, 0), (315, 0), (320, 0), (325, 0), (330, 0), (335, 0), (340, 0), (345, 0), (350, 0), (355, 0), (360, 0), (365, 0), (370, 0), (375, 0), (380, 1), (385, 1), (390, 1), (395, 1), (400, 0), (405, 0), (410, 0), (415, 0), (420, 1), (425, 1), (430, 1), (435, 1), (440, 0), (445, 1), (450, 1), (455, 1), (460, 1), (465, 0), (470, 0), (475, 0), (480, 0), (485, 0), (490, 0), (495, 0), (500, 0), (505, 1), (510, 1), (515, 0), (520, 0), (525, 0), (530, 0), (535, 0), (540, 0), (545, 0), (550, 1), (555, 1), (560, 1), (565, 1), (570, 1), (575, 0), (580, 1), (585, 1), (590, 1), (595, 1), (600, 1), (605, 1), (610, 1), (615, 1), (620, 1), (625, 1), (630, 0), (635, 1), (640, 0), (645, 0), (650, 0), (655, 0), (660, 0), (665, 0), (670, 0), (675, 0), (680, 0), (685, 0), (690, 0), (695, 0), (700, 1), (705, 1), (710, 1), (715, 1), (720, 1), (725, 1), (730, 1), (735, 0), (740, 0), (745, 0), (750, 0), (755, 0), (760, 0), (765, 0), (770, 0), (775, 0), (780, 0), (785, 0), (790, 0), (795, 0), (800, 0), (805, 0), (810, 0), (815, 0), (820, 0), (825, 0), (830, 0), (835, 0), (840, 0), (845, 0), (850, 0), (855, 0), (860, 0), (865, 0), (870, 0), (875, 0), (880, 1), (885, 1), (890, 0), (895, 0), (900, 0), (905, 0), (910, 0), (915, 0), (920, 0), (925, 0), (930, 0), (935, 0), (940, 1), (945, 1), (950, 1), (955, 1), (960, 1), (965, 1), (970, 1), (975, 1), (980, 1), (985, 1), (990, 1), (995, 1), (1000, 1), (1005, 1), (1010, 1), (1015, 1), (1020, 1), (1025, 1)]
Vdin0_16  din0_16  0 PWL (0n 0.0v 4.745n 0.0v 4.755n 0.0v 9.745n 0.0v 9.755n 0.95v 14.745n 0.95v 14.755n 0.95v 19.745n 0.95v 19.755n 0.95v 24.745n 0.95v 24.755n 0.0v 29.745n 0.0v 29.755n 0.0v 34.745n 0.0v 34.755n 0.0v 39.745n 0.0v 39.755n 0.95v 44.745n 0.95v 44.755n 0.95v 49.745n 0.95v 49.755n 0.95v 54.745n 0.95v 54.755n 0.95v 59.745n 0.95v 59.755n 0.95v 64.745n 0.95v 64.755n 0.95v 69.745n 0.95v 69.755n 0.95v 74.745n 0.95v 74.755n 0.95v 79.745n 0.95v 79.755n 0.95v 84.745n 0.95v 84.755n 0.95v 89.745n 0.95v 89.755n 0.95v 94.745n 0.95v 94.755n 0.0v 99.745n 0.0v 99.755n 0.0v 104.745n 0.0v 104.755n 0.0v 109.745n 0.0v 109.755n 0.0v 114.745n 0.0v 114.755n 0.0v 119.745n 0.0v 119.755n 0.0v 124.745n 0.0v 124.755n 0.0v 129.745n 0.0v 129.755n 0.0v 134.745n 0.0v 134.755n 0.0v 139.745n 0.0v 139.755n 0.0v 144.745n 0.0v 144.755n 0.0v 149.745n 0.0v 149.755n 0.95v 154.745n 0.95v 154.755n 0.95v 159.745n 0.95v 159.755n 0.95v 164.745n 0.95v 164.755n 0.95v 169.745n 0.95v 169.755n 0.95v 174.745n 0.95v 174.755n 0.95v 179.745n 0.95v 179.755n 0.95v 184.745n 0.95v 184.755n 0.95v 189.745n 0.95v 189.755n 0.95v 194.745n 0.95v 194.755n 0.95v 199.745n 0.95v 199.755n 0.95v 204.745n 0.95v 204.755n 0.95v 209.745n 0.95v 209.755n 0.95v 214.745n 0.95v 214.755n 0.95v 219.745n 0.95v 219.755n 0.0v 224.745n 0.0v 224.755n 0.0v 229.745n 0.0v 229.755n 0.95v 234.745n 0.95v 234.755n 0.95v 239.745n 0.95v 239.755n 0.95v 244.745n 0.95v 244.755n 0.0v 249.745n 0.0v 249.755n 0.0v 254.745n 0.0v 254.755n 0.0v 259.745n 0.0v 259.755n 0.0v 264.745n 0.0v 264.755n 0.0v 269.745n 0.0v 269.755n 0.95v 274.745n 0.95v 274.755n 0.95v 279.745n 0.95v 279.755n 0.95v 284.745n 0.95v 284.755n 0.95v 289.745n 0.95v 289.755n 0.95v 294.745n 0.95v 294.755n 0.95v 299.745n 0.95v 299.755n 0.95v 304.745n 0.95v 304.755n 0.0v 309.745n 0.0v 309.755n 0.0v 314.745n 0.0v 314.755n 0.0v 319.745n 0.0v 319.755n 0.0v 324.745n 0.0v 324.755n 0.0v 329.745n 0.0v 329.755n 0.0v 334.745n 0.0v 334.755n 0.0v 339.745n 0.0v 339.755n 0.0v 344.745n 0.0v 344.755n 0.0v 349.745n 0.0v 349.755n 0.0v 354.745n 0.0v 354.755n 0.0v 359.745n 0.0v 359.755n 0.0v 364.745n 0.0v 364.755n 0.0v 369.745n 0.0v 369.755n 0.0v 374.745n 0.0v 374.755n 0.0v 379.745n 0.0v 379.755n 0.95v 384.745n 0.95v 384.755n 0.95v 389.745n 0.95v 389.755n 0.95v 394.745n 0.95v 394.755n 0.95v 399.745n 0.95v 399.755n 0.0v 404.745n 0.0v 404.755n 0.0v 409.745n 0.0v 409.755n 0.0v 414.745n 0.0v 414.755n 0.0v 419.745n 0.0v 419.755n 0.95v 424.745n 0.95v 424.755n 0.95v 429.745n 0.95v 429.755n 0.95v 434.745n 0.95v 434.755n 0.95v 439.745n 0.95v 439.755n 0.0v 444.745n 0.0v 444.755n 0.95v 449.745n 0.95v 449.755n 0.95v 454.745n 0.95v 454.755n 0.95v 459.745n 0.95v 459.755n 0.95v 464.745n 0.95v 464.755n 0.0v 469.745n 0.0v 469.755n 0.0v 474.745n 0.0v 474.755n 0.0v 479.745n 0.0v 479.755n 0.0v 484.745n 0.0v 484.755n 0.0v 489.745n 0.0v 489.755n 0.0v 494.745n 0.0v 494.755n 0.0v 499.745n 0.0v 499.755n 0.0v 504.745n 0.0v 504.755n 0.95v 509.745n 0.95v 509.755n 0.95v 514.745n 0.95v 514.755n 0.0v 519.745n 0.0v 519.755n 0.0v 524.745n 0.0v 524.755n 0.0v 529.745n 0.0v 529.755n 0.0v 534.745n 0.0v 534.755n 0.0v 539.745n 0.0v 539.755n 0.0v 544.745n 0.0v 544.755n 0.0v 549.745n 0.0v 549.755n 0.95v 554.745n 0.95v 554.755n 0.95v 559.745n 0.95v 559.755n 0.95v 564.745n 0.95v 564.755n 0.95v 569.745n 0.95v 569.755n 0.95v 574.745n 0.95v 574.755n 0.0v 579.745n 0.0v 579.755n 0.95v 584.745n 0.95v 584.755n 0.95v 589.745n 0.95v 589.755n 0.95v 594.745n 0.95v 594.755n 0.95v 599.745n 0.95v 599.755n 0.95v 604.745n 0.95v 604.755n 0.95v 609.745n 0.95v 609.755n 0.95v 614.745n 0.95v 614.755n 0.95v 619.745n 0.95v 619.755n 0.95v 624.745n 0.95v 624.755n 0.95v 629.745n 0.95v 629.755n 0.0v 634.745n 0.0v 634.755n 0.95v 639.745n 0.95v 639.755n 0.0v 644.745n 0.0v 644.755n 0.0v 649.745n 0.0v 649.755n 0.0v 654.745n 0.0v 654.755n 0.0v 659.745n 0.0v 659.755n 0.0v 664.745n 0.0v 664.755n 0.0v 669.745n 0.0v 669.755n 0.0v 674.745n 0.0v 674.755n 0.0v 679.745n 0.0v 679.755n 0.0v 684.745n 0.0v 684.755n 0.0v 689.745n 0.0v 689.755n 0.0v 694.745n 0.0v 694.755n 0.0v 699.745n 0.0v 699.755n 0.95v 704.745n 0.95v 704.755n 0.95v 709.745n 0.95v 709.755n 0.95v 714.745n 0.95v 714.755n 0.95v 719.745n 0.95v 719.755n 0.95v 724.745n 0.95v 724.755n 0.95v 729.745n 0.95v 729.755n 0.95v 734.745n 0.95v 734.755n 0.0v 739.745n 0.0v 739.755n 0.0v 744.745n 0.0v 744.755n 0.0v 749.745n 0.0v 749.755n 0.0v 754.745n 0.0v 754.755n 0.0v 759.745n 0.0v 759.755n 0.0v 764.745n 0.0v 764.755n 0.0v 769.745n 0.0v 769.755n 0.0v 774.745n 0.0v 774.755n 0.0v 779.745n 0.0v 779.755n 0.0v 784.745n 0.0v 784.755n 0.0v 789.745n 0.0v 789.755n 0.0v 794.745n 0.0v 794.755n 0.0v 799.745n 0.0v 799.755n 0.0v 804.745n 0.0v 804.755n 0.0v 809.745n 0.0v 809.755n 0.0v 814.745n 0.0v 814.755n 0.0v 819.745n 0.0v 819.755n 0.0v 824.745n 0.0v 824.755n 0.0v 829.745n 0.0v 829.755n 0.0v 834.745n 0.0v 834.755n 0.0v 839.745n 0.0v 839.755n 0.0v 844.745n 0.0v 844.755n 0.0v 849.745n 0.0v 849.755n 0.0v 854.745n 0.0v 854.755n 0.0v 859.745n 0.0v 859.755n 0.0v 864.745n 0.0v 864.755n 0.0v 869.745n 0.0v 869.755n 0.0v 874.745n 0.0v 874.755n 0.0v 879.745n 0.0v 879.755n 0.95v 884.745n 0.95v 884.755n 0.95v 889.745n 0.95v 889.755n 0.0v 894.745n 0.0v 894.755n 0.0v 899.745n 0.0v 899.755n 0.0v 904.745n 0.0v 904.755n 0.0v 909.745n 0.0v 909.755n 0.0v 914.745n 0.0v 914.755n 0.0v 919.745n 0.0v 919.755n 0.0v 924.745n 0.0v 924.755n 0.0v 929.745n 0.0v 929.755n 0.0v 934.745n 0.0v 934.755n 0.0v 939.745n 0.0v 939.755n 0.95v 944.745n 0.95v 944.755n 0.95v 949.745n 0.95v 949.755n 0.95v 954.745n 0.95v 954.755n 0.95v 959.745n 0.95v 959.755n 0.95v 964.745n 0.95v 964.755n 0.95v 969.745n 0.95v 969.755n 0.95v 974.745n 0.95v 974.755n 0.95v 979.745n 0.95v 979.755n 0.95v 984.745n 0.95v 984.755n 0.95v 989.745n 0.95v 989.755n 0.95v 994.745n 0.95v 994.755n 0.95v 999.745n 0.95v 999.755n 0.95v 1004.745n 0.95v 1004.755n 0.95v 1009.745n 0.95v 1009.755n 0.95v 1014.745n 0.95v 1014.755n 0.95v 1019.745n 0.95v 1019.755n 0.95v 1024.745n 0.95v 1024.755n 0.95v )
* (time, data): [(0, 0), (5, 0), (10, 0), (15, 1), (20, 1), (25, 0), (30, 0), (35, 0), (40, 0), (45, 0), (50, 0), (55, 0), (60, 1), (65, 1), (70, 1), (75, 1), (80, 1), (85, 1), (90, 1), (95, 1), (100, 1), (105, 1), (110, 1), (115, 1), (120, 1), (125, 1), (130, 1), (135, 1), (140, 1), (145, 0), (150, 0), (155, 0), (160, 0), (165, 0), (170, 0), (175, 0), (180, 0), (185, 1), (190, 1), (195, 1), (200, 1), (205, 1), (210, 1), (215, 1), (220, 1), (225, 0), (230, 0), (235, 0), (240, 0), (245, 0), (250, 0), (255, 0), (260, 0), (265, 0), (270, 0), (275, 0), (280, 0), (285, 0), (290, 0), (295, 0), (300, 0), (305, 0), (310, 0), (315, 0), (320, 1), (325, 1), (330, 1), (335, 1), (340, 1), (345, 1), (350, 1), (355, 1), (360, 1), (365, 1), (370, 1), (375, 1), (380, 0), (385, 0), (390, 0), (395, 0), (400, 1), (405, 1), (410, 1), (415, 1), (420, 1), (425, 1), (430, 1), (435, 1), (440, 1), (445, 0), (450, 0), (455, 0), (460, 0), (465, 0), (470, 0), (475, 0), (480, 0), (485, 0), (490, 0), (495, 0), (500, 0), (505, 0), (510, 0), (515, 0), (520, 0), (525, 0), (530, 0), (535, 1), (540, 1), (545, 1), (550, 1), (555, 1), (560, 1), (565, 1), (570, 1), (575, 1), (580, 1), (585, 1), (590, 1), (595, 1), (600, 1), (605, 0), (610, 0), (615, 1), (620, 1), (625, 1), (630, 1), (635, 1), (640, 0), (645, 0), (650, 0), (655, 1), (660, 1), (665, 1), (670, 1), (675, 0), (680, 0), (685, 0), (690, 0), (695, 0), (700, 0), (705, 1), (710, 1), (715, 1), (720, 1), (725, 1), (730, 1), (735, 0), (740, 0), (745, 1), (750, 1), (755, 1), (760, 1), (765, 1), (770, 0), (775, 0), (780, 0), (785, 0), (790, 0), (795, 0), (800, 0), (805, 0), (810, 0), (815, 0), (820, 0), (825, 0), (830, 0), (835, 0), (840, 0), (845, 0), (850, 0), (855, 0), (860, 0), (865, 0), (870, 0), (875, 0), (880, 1), (885, 0), (890, 1), (895, 1), (900, 0), (905, 0), (910, 0), (915, 1), (920, 1), (925, 1), (930, 1), (935, 1), (940, 0), (945, 0), (950, 0), (955, 1), (960, 1), (965, 0), (970, 0), (975, 0), (980, 0), (985, 0), (990, 0), (995, 0), (1000, 0), (1005, 0), (1010, 0), (1015, 0), (1020, 0), (1025, 0)]
Vdin0_17  din0_17  0 PWL (0n 0.0v 4.745n 0.0v 4.755n 0.0v 9.745n 0.0v 9.755n 0.0v 14.745n 0.0v 14.755n 0.95v 19.745n 0.95v 19.755n 0.95v 24.745n 0.95v 24.755n 0.0v 29.745n 0.0v 29.755n 0.0v 34.745n 0.0v 34.755n 0.0v 39.745n 0.0v 39.755n 0.0v 44.745n 0.0v 44.755n 0.0v 49.745n 0.0v 49.755n 0.0v 54.745n 0.0v 54.755n 0.0v 59.745n 0.0v 59.755n 0.95v 64.745n 0.95v 64.755n 0.95v 69.745n 0.95v 69.755n 0.95v 74.745n 0.95v 74.755n 0.95v 79.745n 0.95v 79.755n 0.95v 84.745n 0.95v 84.755n 0.95v 89.745n 0.95v 89.755n 0.95v 94.745n 0.95v 94.755n 0.95v 99.745n 0.95v 99.755n 0.95v 104.745n 0.95v 104.755n 0.95v 109.745n 0.95v 109.755n 0.95v 114.745n 0.95v 114.755n 0.95v 119.745n 0.95v 119.755n 0.95v 124.745n 0.95v 124.755n 0.95v 129.745n 0.95v 129.755n 0.95v 134.745n 0.95v 134.755n 0.95v 139.745n 0.95v 139.755n 0.95v 144.745n 0.95v 144.755n 0.0v 149.745n 0.0v 149.755n 0.0v 154.745n 0.0v 154.755n 0.0v 159.745n 0.0v 159.755n 0.0v 164.745n 0.0v 164.755n 0.0v 169.745n 0.0v 169.755n 0.0v 174.745n 0.0v 174.755n 0.0v 179.745n 0.0v 179.755n 0.0v 184.745n 0.0v 184.755n 0.95v 189.745n 0.95v 189.755n 0.95v 194.745n 0.95v 194.755n 0.95v 199.745n 0.95v 199.755n 0.95v 204.745n 0.95v 204.755n 0.95v 209.745n 0.95v 209.755n 0.95v 214.745n 0.95v 214.755n 0.95v 219.745n 0.95v 219.755n 0.95v 224.745n 0.95v 224.755n 0.0v 229.745n 0.0v 229.755n 0.0v 234.745n 0.0v 234.755n 0.0v 239.745n 0.0v 239.755n 0.0v 244.745n 0.0v 244.755n 0.0v 249.745n 0.0v 249.755n 0.0v 254.745n 0.0v 254.755n 0.0v 259.745n 0.0v 259.755n 0.0v 264.745n 0.0v 264.755n 0.0v 269.745n 0.0v 269.755n 0.0v 274.745n 0.0v 274.755n 0.0v 279.745n 0.0v 279.755n 0.0v 284.745n 0.0v 284.755n 0.0v 289.745n 0.0v 289.755n 0.0v 294.745n 0.0v 294.755n 0.0v 299.745n 0.0v 299.755n 0.0v 304.745n 0.0v 304.755n 0.0v 309.745n 0.0v 309.755n 0.0v 314.745n 0.0v 314.755n 0.0v 319.745n 0.0v 319.755n 0.95v 324.745n 0.95v 324.755n 0.95v 329.745n 0.95v 329.755n 0.95v 334.745n 0.95v 334.755n 0.95v 339.745n 0.95v 339.755n 0.95v 344.745n 0.95v 344.755n 0.95v 349.745n 0.95v 349.755n 0.95v 354.745n 0.95v 354.755n 0.95v 359.745n 0.95v 359.755n 0.95v 364.745n 0.95v 364.755n 0.95v 369.745n 0.95v 369.755n 0.95v 374.745n 0.95v 374.755n 0.95v 379.745n 0.95v 379.755n 0.0v 384.745n 0.0v 384.755n 0.0v 389.745n 0.0v 389.755n 0.0v 394.745n 0.0v 394.755n 0.0v 399.745n 0.0v 399.755n 0.95v 404.745n 0.95v 404.755n 0.95v 409.745n 0.95v 409.755n 0.95v 414.745n 0.95v 414.755n 0.95v 419.745n 0.95v 419.755n 0.95v 424.745n 0.95v 424.755n 0.95v 429.745n 0.95v 429.755n 0.95v 434.745n 0.95v 434.755n 0.95v 439.745n 0.95v 439.755n 0.95v 444.745n 0.95v 444.755n 0.0v 449.745n 0.0v 449.755n 0.0v 454.745n 0.0v 454.755n 0.0v 459.745n 0.0v 459.755n 0.0v 464.745n 0.0v 464.755n 0.0v 469.745n 0.0v 469.755n 0.0v 474.745n 0.0v 474.755n 0.0v 479.745n 0.0v 479.755n 0.0v 484.745n 0.0v 484.755n 0.0v 489.745n 0.0v 489.755n 0.0v 494.745n 0.0v 494.755n 0.0v 499.745n 0.0v 499.755n 0.0v 504.745n 0.0v 504.755n 0.0v 509.745n 0.0v 509.755n 0.0v 514.745n 0.0v 514.755n 0.0v 519.745n 0.0v 519.755n 0.0v 524.745n 0.0v 524.755n 0.0v 529.745n 0.0v 529.755n 0.0v 534.745n 0.0v 534.755n 0.95v 539.745n 0.95v 539.755n 0.95v 544.745n 0.95v 544.755n 0.95v 549.745n 0.95v 549.755n 0.95v 554.745n 0.95v 554.755n 0.95v 559.745n 0.95v 559.755n 0.95v 564.745n 0.95v 564.755n 0.95v 569.745n 0.95v 569.755n 0.95v 574.745n 0.95v 574.755n 0.95v 579.745n 0.95v 579.755n 0.95v 584.745n 0.95v 584.755n 0.95v 589.745n 0.95v 589.755n 0.95v 594.745n 0.95v 594.755n 0.95v 599.745n 0.95v 599.755n 0.95v 604.745n 0.95v 604.755n 0.0v 609.745n 0.0v 609.755n 0.0v 614.745n 0.0v 614.755n 0.95v 619.745n 0.95v 619.755n 0.95v 624.745n 0.95v 624.755n 0.95v 629.745n 0.95v 629.755n 0.95v 634.745n 0.95v 634.755n 0.95v 639.745n 0.95v 639.755n 0.0v 644.745n 0.0v 644.755n 0.0v 649.745n 0.0v 649.755n 0.0v 654.745n 0.0v 654.755n 0.95v 659.745n 0.95v 659.755n 0.95v 664.745n 0.95v 664.755n 0.95v 669.745n 0.95v 669.755n 0.95v 674.745n 0.95v 674.755n 0.0v 679.745n 0.0v 679.755n 0.0v 684.745n 0.0v 684.755n 0.0v 689.745n 0.0v 689.755n 0.0v 694.745n 0.0v 694.755n 0.0v 699.745n 0.0v 699.755n 0.0v 704.745n 0.0v 704.755n 0.95v 709.745n 0.95v 709.755n 0.95v 714.745n 0.95v 714.755n 0.95v 719.745n 0.95v 719.755n 0.95v 724.745n 0.95v 724.755n 0.95v 729.745n 0.95v 729.755n 0.95v 734.745n 0.95v 734.755n 0.0v 739.745n 0.0v 739.755n 0.0v 744.745n 0.0v 744.755n 0.95v 749.745n 0.95v 749.755n 0.95v 754.745n 0.95v 754.755n 0.95v 759.745n 0.95v 759.755n 0.95v 764.745n 0.95v 764.755n 0.95v 769.745n 0.95v 769.755n 0.0v 774.745n 0.0v 774.755n 0.0v 779.745n 0.0v 779.755n 0.0v 784.745n 0.0v 784.755n 0.0v 789.745n 0.0v 789.755n 0.0v 794.745n 0.0v 794.755n 0.0v 799.745n 0.0v 799.755n 0.0v 804.745n 0.0v 804.755n 0.0v 809.745n 0.0v 809.755n 0.0v 814.745n 0.0v 814.755n 0.0v 819.745n 0.0v 819.755n 0.0v 824.745n 0.0v 824.755n 0.0v 829.745n 0.0v 829.755n 0.0v 834.745n 0.0v 834.755n 0.0v 839.745n 0.0v 839.755n 0.0v 844.745n 0.0v 844.755n 0.0v 849.745n 0.0v 849.755n 0.0v 854.745n 0.0v 854.755n 0.0v 859.745n 0.0v 859.755n 0.0v 864.745n 0.0v 864.755n 0.0v 869.745n 0.0v 869.755n 0.0v 874.745n 0.0v 874.755n 0.0v 879.745n 0.0v 879.755n 0.95v 884.745n 0.95v 884.755n 0.0v 889.745n 0.0v 889.755n 0.95v 894.745n 0.95v 894.755n 0.95v 899.745n 0.95v 899.755n 0.0v 904.745n 0.0v 904.755n 0.0v 909.745n 0.0v 909.755n 0.0v 914.745n 0.0v 914.755n 0.95v 919.745n 0.95v 919.755n 0.95v 924.745n 0.95v 924.755n 0.95v 929.745n 0.95v 929.755n 0.95v 934.745n 0.95v 934.755n 0.95v 939.745n 0.95v 939.755n 0.0v 944.745n 0.0v 944.755n 0.0v 949.745n 0.0v 949.755n 0.0v 954.745n 0.0v 954.755n 0.95v 959.745n 0.95v 959.755n 0.95v 964.745n 0.95v 964.755n 0.0v 969.745n 0.0v 969.755n 0.0v 974.745n 0.0v 974.755n 0.0v 979.745n 0.0v 979.755n 0.0v 984.745n 0.0v 984.755n 0.0v 989.745n 0.0v 989.755n 0.0v 994.745n 0.0v 994.755n 0.0v 999.745n 0.0v 999.755n 0.0v 1004.745n 0.0v 1004.755n 0.0v 1009.745n 0.0v 1009.755n 0.0v 1014.745n 0.0v 1014.755n 0.0v 1019.745n 0.0v 1019.755n 0.0v 1024.745n 0.0v 1024.755n 0.0v )
* (time, data): [(0, 0), (5, 1), (10, 0), (15, 1), (20, 1), (25, 1), (30, 1), (35, 1), (40, 0), (45, 1), (50, 1), (55, 1), (60, 1), (65, 1), (70, 1), (75, 0), (80, 0), (85, 0), (90, 0), (95, 1), (100, 1), (105, 1), (110, 1), (115, 1), (120, 1), (125, 1), (130, 1), (135, 1), (140, 1), (145, 0), (150, 0), (155, 0), (160, 0), (165, 0), (170, 0), (175, 0), (180, 0), (185, 0), (190, 0), (195, 0), (200, 0), (205, 0), (210, 1), (215, 1), (220, 1), (225, 0), (230, 0), (235, 0), (240, 0), (245, 0), (250, 0), (255, 0), (260, 0), (265, 0), (270, 0), (275, 0), (280, 0), (285, 0), (290, 0), (295, 0), (300, 0), (305, 0), (310, 0), (315, 0), (320, 1), (325, 1), (330, 1), (335, 1), (340, 1), (345, 1), (350, 1), (355, 1), (360, 1), (365, 1), (370, 1), (375, 1), (380, 1), (385, 1), (390, 1), (395, 1), (400, 1), (405, 1), (410, 1), (415, 1), (420, 0), (425, 0), (430, 0), (435, 0), (440, 0), (445, 0), (450, 0), (455, 0), (460, 0), (465, 0), (470, 0), (475, 0), (480, 0), (485, 0), (490, 0), (495, 0), (500, 0), (505, 0), (510, 0), (515, 1), (520, 1), (525, 1), (530, 1), (535, 1), (540, 1), (545, 1), (550, 0), (555, 0), (560, 0), (565, 1), (570, 1), (575, 1), (580, 0), (585, 0), (590, 0), (595, 0), (600, 0), (605, 1), (610, 1), (615, 1), (620, 1), (625, 1), (630, 0), (635, 1), (640, 0), (645, 0), (650, 0), (655, 0), (660, 0), (665, 0), (670, 0), (675, 0), (680, 0), (685, 0), (690, 0), (695, 0), (700, 0), (705, 0), (710, 0), (715, 0), (720, 0), (725, 0), (730, 0), (735, 0), (740, 0), (745, 0), (750, 0), (755, 0), (760, 0), (765, 0), (770, 0), (775, 0), (780, 0), (785, 0), (790, 0), (795, 0), (800, 0), (805, 0), (810, 1), (815, 0), (820, 0), (825, 0), (830, 0), (835, 0), (840, 0), (845, 0), (850, 0), (855, 0), (860, 0), (865, 0), (870, 1), (875, 1), (880, 0), (885, 0), (890, 1), (895, 0), (900, 1), (905, 1), (910, 1), (915, 1), (920, 1), (925, 1), (930, 1), (935, 1), (940, 1), (945, 1), (950, 1), (955, 1), (960, 1), (965, 0), (970, 0), (975, 0), (980, 0), (985, 0), (990, 0), (995, 0), (1000, 0), (1005, 0), (1010, 0), (1015, 0), (1020, 0), (1025, 0)]
Vdin0_18  din0_18  0 PWL (0n 0.0v 4.745n 0.0v 4.755n 0.95v 9.745n 0.95v 9.755n 0.0v 14.745n 0.0v 14.755n 0.95v 19.745n 0.95v 19.755n 0.95v 24.745n 0.95v 24.755n 0.95v 29.745n 0.95v 29.755n 0.95v 34.745n 0.95v 34.755n 0.95v 39.745n 0.95v 39.755n 0.0v 44.745n 0.0v 44.755n 0.95v 49.745n 0.95v 49.755n 0.95v 54.745n 0.95v 54.755n 0.95v 59.745n 0.95v 59.755n 0.95v 64.745n 0.95v 64.755n 0.95v 69.745n 0.95v 69.755n 0.95v 74.745n 0.95v 74.755n 0.0v 79.745n 0.0v 79.755n 0.0v 84.745n 0.0v 84.755n 0.0v 89.745n 0.0v 89.755n 0.0v 94.745n 0.0v 94.755n 0.95v 99.745n 0.95v 99.755n 0.95v 104.745n 0.95v 104.755n 0.95v 109.745n 0.95v 109.755n 0.95v 114.745n 0.95v 114.755n 0.95v 119.745n 0.95v 119.755n 0.95v 124.745n 0.95v 124.755n 0.95v 129.745n 0.95v 129.755n 0.95v 134.745n 0.95v 134.755n 0.95v 139.745n 0.95v 139.755n 0.95v 144.745n 0.95v 144.755n 0.0v 149.745n 0.0v 149.755n 0.0v 154.745n 0.0v 154.755n 0.0v 159.745n 0.0v 159.755n 0.0v 164.745n 0.0v 164.755n 0.0v 169.745n 0.0v 169.755n 0.0v 174.745n 0.0v 174.755n 0.0v 179.745n 0.0v 179.755n 0.0v 184.745n 0.0v 184.755n 0.0v 189.745n 0.0v 189.755n 0.0v 194.745n 0.0v 194.755n 0.0v 199.745n 0.0v 199.755n 0.0v 204.745n 0.0v 204.755n 0.0v 209.745n 0.0v 209.755n 0.95v 214.745n 0.95v 214.755n 0.95v 219.745n 0.95v 219.755n 0.95v 224.745n 0.95v 224.755n 0.0v 229.745n 0.0v 229.755n 0.0v 234.745n 0.0v 234.755n 0.0v 239.745n 0.0v 239.755n 0.0v 244.745n 0.0v 244.755n 0.0v 249.745n 0.0v 249.755n 0.0v 254.745n 0.0v 254.755n 0.0v 259.745n 0.0v 259.755n 0.0v 264.745n 0.0v 264.755n 0.0v 269.745n 0.0v 269.755n 0.0v 274.745n 0.0v 274.755n 0.0v 279.745n 0.0v 279.755n 0.0v 284.745n 0.0v 284.755n 0.0v 289.745n 0.0v 289.755n 0.0v 294.745n 0.0v 294.755n 0.0v 299.745n 0.0v 299.755n 0.0v 304.745n 0.0v 304.755n 0.0v 309.745n 0.0v 309.755n 0.0v 314.745n 0.0v 314.755n 0.0v 319.745n 0.0v 319.755n 0.95v 324.745n 0.95v 324.755n 0.95v 329.745n 0.95v 329.755n 0.95v 334.745n 0.95v 334.755n 0.95v 339.745n 0.95v 339.755n 0.95v 344.745n 0.95v 344.755n 0.95v 349.745n 0.95v 349.755n 0.95v 354.745n 0.95v 354.755n 0.95v 359.745n 0.95v 359.755n 0.95v 364.745n 0.95v 364.755n 0.95v 369.745n 0.95v 369.755n 0.95v 374.745n 0.95v 374.755n 0.95v 379.745n 0.95v 379.755n 0.95v 384.745n 0.95v 384.755n 0.95v 389.745n 0.95v 389.755n 0.95v 394.745n 0.95v 394.755n 0.95v 399.745n 0.95v 399.755n 0.95v 404.745n 0.95v 404.755n 0.95v 409.745n 0.95v 409.755n 0.95v 414.745n 0.95v 414.755n 0.95v 419.745n 0.95v 419.755n 0.0v 424.745n 0.0v 424.755n 0.0v 429.745n 0.0v 429.755n 0.0v 434.745n 0.0v 434.755n 0.0v 439.745n 0.0v 439.755n 0.0v 444.745n 0.0v 444.755n 0.0v 449.745n 0.0v 449.755n 0.0v 454.745n 0.0v 454.755n 0.0v 459.745n 0.0v 459.755n 0.0v 464.745n 0.0v 464.755n 0.0v 469.745n 0.0v 469.755n 0.0v 474.745n 0.0v 474.755n 0.0v 479.745n 0.0v 479.755n 0.0v 484.745n 0.0v 484.755n 0.0v 489.745n 0.0v 489.755n 0.0v 494.745n 0.0v 494.755n 0.0v 499.745n 0.0v 499.755n 0.0v 504.745n 0.0v 504.755n 0.0v 509.745n 0.0v 509.755n 0.0v 514.745n 0.0v 514.755n 0.95v 519.745n 0.95v 519.755n 0.95v 524.745n 0.95v 524.755n 0.95v 529.745n 0.95v 529.755n 0.95v 534.745n 0.95v 534.755n 0.95v 539.745n 0.95v 539.755n 0.95v 544.745n 0.95v 544.755n 0.95v 549.745n 0.95v 549.755n 0.0v 554.745n 0.0v 554.755n 0.0v 559.745n 0.0v 559.755n 0.0v 564.745n 0.0v 564.755n 0.95v 569.745n 0.95v 569.755n 0.95v 574.745n 0.95v 574.755n 0.95v 579.745n 0.95v 579.755n 0.0v 584.745n 0.0v 584.755n 0.0v 589.745n 0.0v 589.755n 0.0v 594.745n 0.0v 594.755n 0.0v 599.745n 0.0v 599.755n 0.0v 604.745n 0.0v 604.755n 0.95v 609.745n 0.95v 609.755n 0.95v 614.745n 0.95v 614.755n 0.95v 619.745n 0.95v 619.755n 0.95v 624.745n 0.95v 624.755n 0.95v 629.745n 0.95v 629.755n 0.0v 634.745n 0.0v 634.755n 0.95v 639.745n 0.95v 639.755n 0.0v 644.745n 0.0v 644.755n 0.0v 649.745n 0.0v 649.755n 0.0v 654.745n 0.0v 654.755n 0.0v 659.745n 0.0v 659.755n 0.0v 664.745n 0.0v 664.755n 0.0v 669.745n 0.0v 669.755n 0.0v 674.745n 0.0v 674.755n 0.0v 679.745n 0.0v 679.755n 0.0v 684.745n 0.0v 684.755n 0.0v 689.745n 0.0v 689.755n 0.0v 694.745n 0.0v 694.755n 0.0v 699.745n 0.0v 699.755n 0.0v 704.745n 0.0v 704.755n 0.0v 709.745n 0.0v 709.755n 0.0v 714.745n 0.0v 714.755n 0.0v 719.745n 0.0v 719.755n 0.0v 724.745n 0.0v 724.755n 0.0v 729.745n 0.0v 729.755n 0.0v 734.745n 0.0v 734.755n 0.0v 739.745n 0.0v 739.755n 0.0v 744.745n 0.0v 744.755n 0.0v 749.745n 0.0v 749.755n 0.0v 754.745n 0.0v 754.755n 0.0v 759.745n 0.0v 759.755n 0.0v 764.745n 0.0v 764.755n 0.0v 769.745n 0.0v 769.755n 0.0v 774.745n 0.0v 774.755n 0.0v 779.745n 0.0v 779.755n 0.0v 784.745n 0.0v 784.755n 0.0v 789.745n 0.0v 789.755n 0.0v 794.745n 0.0v 794.755n 0.0v 799.745n 0.0v 799.755n 0.0v 804.745n 0.0v 804.755n 0.0v 809.745n 0.0v 809.755n 0.95v 814.745n 0.95v 814.755n 0.0v 819.745n 0.0v 819.755n 0.0v 824.745n 0.0v 824.755n 0.0v 829.745n 0.0v 829.755n 0.0v 834.745n 0.0v 834.755n 0.0v 839.745n 0.0v 839.755n 0.0v 844.745n 0.0v 844.755n 0.0v 849.745n 0.0v 849.755n 0.0v 854.745n 0.0v 854.755n 0.0v 859.745n 0.0v 859.755n 0.0v 864.745n 0.0v 864.755n 0.0v 869.745n 0.0v 869.755n 0.95v 874.745n 0.95v 874.755n 0.95v 879.745n 0.95v 879.755n 0.0v 884.745n 0.0v 884.755n 0.0v 889.745n 0.0v 889.755n 0.95v 894.745n 0.95v 894.755n 0.0v 899.745n 0.0v 899.755n 0.95v 904.745n 0.95v 904.755n 0.95v 909.745n 0.95v 909.755n 0.95v 914.745n 0.95v 914.755n 0.95v 919.745n 0.95v 919.755n 0.95v 924.745n 0.95v 924.755n 0.95v 929.745n 0.95v 929.755n 0.95v 934.745n 0.95v 934.755n 0.95v 939.745n 0.95v 939.755n 0.95v 944.745n 0.95v 944.755n 0.95v 949.745n 0.95v 949.755n 0.95v 954.745n 0.95v 954.755n 0.95v 959.745n 0.95v 959.755n 0.95v 964.745n 0.95v 964.755n 0.0v 969.745n 0.0v 969.755n 0.0v 974.745n 0.0v 974.755n 0.0v 979.745n 0.0v 979.755n 0.0v 984.745n 0.0v 984.755n 0.0v 989.745n 0.0v 989.755n 0.0v 994.745n 0.0v 994.755n 0.0v 999.745n 0.0v 999.755n 0.0v 1004.745n 0.0v 1004.755n 0.0v 1009.745n 0.0v 1009.755n 0.0v 1014.745n 0.0v 1014.755n 0.0v 1019.745n 0.0v 1019.755n 0.0v 1024.745n 0.0v 1024.755n 0.0v )
* (time, data): [(0, 0), (5, 1), (10, 1), (15, 1), (20, 1), (25, 1), (30, 1), (35, 1), (40, 0), (45, 1), (50, 1), (55, 1), (60, 0), (65, 0), (70, 0), (75, 1), (80, 1), (85, 1), (90, 1), (95, 0), (100, 0), (105, 0), (110, 0), (115, 0), (120, 0), (125, 0), (130, 0), (135, 1), (140, 0), (145, 0), (150, 0), (155, 0), (160, 0), (165, 0), (170, 0), (175, 0), (180, 0), (185, 0), (190, 0), (195, 0), (200, 0), (205, 0), (210, 1), (215, 1), (220, 1), (225, 0), (230, 1), (235, 1), (240, 1), (245, 0), (250, 0), (255, 0), (260, 0), (265, 0), (270, 0), (275, 0), (280, 0), (285, 0), (290, 0), (295, 0), (300, 0), (305, 1), (310, 1), (315, 1), (320, 1), (325, 1), (330, 1), (335, 1), (340, 1), (345, 1), (350, 1), (355, 1), (360, 1), (365, 0), (370, 0), (375, 1), (380, 0), (385, 0), (390, 0), (395, 0), (400, 0), (405, 0), (410, 0), (415, 0), (420, 1), (425, 1), (430, 1), (435, 1), (440, 1), (445, 0), (450, 0), (455, 0), (460, 0), (465, 0), (470, 0), (475, 0), (480, 0), (485, 0), (490, 0), (495, 0), (500, 0), (505, 0), (510, 1), (515, 1), (520, 1), (525, 1), (530, 1), (535, 1), (540, 1), (545, 1), (550, 1), (555, 1), (560, 1), (565, 1), (570, 1), (575, 1), (580, 1), (585, 1), (590, 1), (595, 1), (600, 1), (605, 0), (610, 0), (615, 0), (620, 0), (625, 0), (630, 0), (635, 0), (640, 0), (645, 0), (650, 0), (655, 1), (660, 1), (665, 1), (670, 0), (675, 1), (680, 1), (685, 1), (690, 1), (695, 1), (700, 0), (705, 1), (710, 1), (715, 1), (720, 1), (725, 1), (730, 1), (735, 0), (740, 0), (745, 0), (750, 0), (755, 0), (760, 0), (765, 0), (770, 0), (775, 0), (780, 0), (785, 0), (790, 0), (795, 0), (800, 0), (805, 0), (810, 0), (815, 1), (820, 1), (825, 1), (830, 1), (835, 1), (840, 1), (845, 1), (850, 1), (855, 1), (860, 1), (865, 1), (870, 1), (875, 1), (880, 1), (885, 0), (890, 0), (895, 0), (900, 1), (905, 1), (910, 1), (915, 1), (920, 1), (925, 1), (930, 1), (935, 1), (940, 0), (945, 0), (950, 0), (955, 1), (960, 1), (965, 1), (970, 1), (975, 1), (980, 1), (985, 1), (990, 1), (995, 1), (1000, 1), (1005, 1), (1010, 0), (1015, 0), (1020, 0), (1025, 0)]
Vdin0_19  din0_19  0 PWL (0n 0.0v 4.745n 0.0v 4.755n 0.95v 9.745n 0.95v 9.755n 0.95v 14.745n 0.95v 14.755n 0.95v 19.745n 0.95v 19.755n 0.95v 24.745n 0.95v 24.755n 0.95v 29.745n 0.95v 29.755n 0.95v 34.745n 0.95v 34.755n 0.95v 39.745n 0.95v 39.755n 0.0v 44.745n 0.0v 44.755n 0.95v 49.745n 0.95v 49.755n 0.95v 54.745n 0.95v 54.755n 0.95v 59.745n 0.95v 59.755n 0.0v 64.745n 0.0v 64.755n 0.0v 69.745n 0.0v 69.755n 0.0v 74.745n 0.0v 74.755n 0.95v 79.745n 0.95v 79.755n 0.95v 84.745n 0.95v 84.755n 0.95v 89.745n 0.95v 89.755n 0.95v 94.745n 0.95v 94.755n 0.0v 99.745n 0.0v 99.755n 0.0v 104.745n 0.0v 104.755n 0.0v 109.745n 0.0v 109.755n 0.0v 114.745n 0.0v 114.755n 0.0v 119.745n 0.0v 119.755n 0.0v 124.745n 0.0v 124.755n 0.0v 129.745n 0.0v 129.755n 0.0v 134.745n 0.0v 134.755n 0.95v 139.745n 0.95v 139.755n 0.0v 144.745n 0.0v 144.755n 0.0v 149.745n 0.0v 149.755n 0.0v 154.745n 0.0v 154.755n 0.0v 159.745n 0.0v 159.755n 0.0v 164.745n 0.0v 164.755n 0.0v 169.745n 0.0v 169.755n 0.0v 174.745n 0.0v 174.755n 0.0v 179.745n 0.0v 179.755n 0.0v 184.745n 0.0v 184.755n 0.0v 189.745n 0.0v 189.755n 0.0v 194.745n 0.0v 194.755n 0.0v 199.745n 0.0v 199.755n 0.0v 204.745n 0.0v 204.755n 0.0v 209.745n 0.0v 209.755n 0.95v 214.745n 0.95v 214.755n 0.95v 219.745n 0.95v 219.755n 0.95v 224.745n 0.95v 224.755n 0.0v 229.745n 0.0v 229.755n 0.95v 234.745n 0.95v 234.755n 0.95v 239.745n 0.95v 239.755n 0.95v 244.745n 0.95v 244.755n 0.0v 249.745n 0.0v 249.755n 0.0v 254.745n 0.0v 254.755n 0.0v 259.745n 0.0v 259.755n 0.0v 264.745n 0.0v 264.755n 0.0v 269.745n 0.0v 269.755n 0.0v 274.745n 0.0v 274.755n 0.0v 279.745n 0.0v 279.755n 0.0v 284.745n 0.0v 284.755n 0.0v 289.745n 0.0v 289.755n 0.0v 294.745n 0.0v 294.755n 0.0v 299.745n 0.0v 299.755n 0.0v 304.745n 0.0v 304.755n 0.95v 309.745n 0.95v 309.755n 0.95v 314.745n 0.95v 314.755n 0.95v 319.745n 0.95v 319.755n 0.95v 324.745n 0.95v 324.755n 0.95v 329.745n 0.95v 329.755n 0.95v 334.745n 0.95v 334.755n 0.95v 339.745n 0.95v 339.755n 0.95v 344.745n 0.95v 344.755n 0.95v 349.745n 0.95v 349.755n 0.95v 354.745n 0.95v 354.755n 0.95v 359.745n 0.95v 359.755n 0.95v 364.745n 0.95v 364.755n 0.0v 369.745n 0.0v 369.755n 0.0v 374.745n 0.0v 374.755n 0.95v 379.745n 0.95v 379.755n 0.0v 384.745n 0.0v 384.755n 0.0v 389.745n 0.0v 389.755n 0.0v 394.745n 0.0v 394.755n 0.0v 399.745n 0.0v 399.755n 0.0v 404.745n 0.0v 404.755n 0.0v 409.745n 0.0v 409.755n 0.0v 414.745n 0.0v 414.755n 0.0v 419.745n 0.0v 419.755n 0.95v 424.745n 0.95v 424.755n 0.95v 429.745n 0.95v 429.755n 0.95v 434.745n 0.95v 434.755n 0.95v 439.745n 0.95v 439.755n 0.95v 444.745n 0.95v 444.755n 0.0v 449.745n 0.0v 449.755n 0.0v 454.745n 0.0v 454.755n 0.0v 459.745n 0.0v 459.755n 0.0v 464.745n 0.0v 464.755n 0.0v 469.745n 0.0v 469.755n 0.0v 474.745n 0.0v 474.755n 0.0v 479.745n 0.0v 479.755n 0.0v 484.745n 0.0v 484.755n 0.0v 489.745n 0.0v 489.755n 0.0v 494.745n 0.0v 494.755n 0.0v 499.745n 0.0v 499.755n 0.0v 504.745n 0.0v 504.755n 0.0v 509.745n 0.0v 509.755n 0.95v 514.745n 0.95v 514.755n 0.95v 519.745n 0.95v 519.755n 0.95v 524.745n 0.95v 524.755n 0.95v 529.745n 0.95v 529.755n 0.95v 534.745n 0.95v 534.755n 0.95v 539.745n 0.95v 539.755n 0.95v 544.745n 0.95v 544.755n 0.95v 549.745n 0.95v 549.755n 0.95v 554.745n 0.95v 554.755n 0.95v 559.745n 0.95v 559.755n 0.95v 564.745n 0.95v 564.755n 0.95v 569.745n 0.95v 569.755n 0.95v 574.745n 0.95v 574.755n 0.95v 579.745n 0.95v 579.755n 0.95v 584.745n 0.95v 584.755n 0.95v 589.745n 0.95v 589.755n 0.95v 594.745n 0.95v 594.755n 0.95v 599.745n 0.95v 599.755n 0.95v 604.745n 0.95v 604.755n 0.0v 609.745n 0.0v 609.755n 0.0v 614.745n 0.0v 614.755n 0.0v 619.745n 0.0v 619.755n 0.0v 624.745n 0.0v 624.755n 0.0v 629.745n 0.0v 629.755n 0.0v 634.745n 0.0v 634.755n 0.0v 639.745n 0.0v 639.755n 0.0v 644.745n 0.0v 644.755n 0.0v 649.745n 0.0v 649.755n 0.0v 654.745n 0.0v 654.755n 0.95v 659.745n 0.95v 659.755n 0.95v 664.745n 0.95v 664.755n 0.95v 669.745n 0.95v 669.755n 0.0v 674.745n 0.0v 674.755n 0.95v 679.745n 0.95v 679.755n 0.95v 684.745n 0.95v 684.755n 0.95v 689.745n 0.95v 689.755n 0.95v 694.745n 0.95v 694.755n 0.95v 699.745n 0.95v 699.755n 0.0v 704.745n 0.0v 704.755n 0.95v 709.745n 0.95v 709.755n 0.95v 714.745n 0.95v 714.755n 0.95v 719.745n 0.95v 719.755n 0.95v 724.745n 0.95v 724.755n 0.95v 729.745n 0.95v 729.755n 0.95v 734.745n 0.95v 734.755n 0.0v 739.745n 0.0v 739.755n 0.0v 744.745n 0.0v 744.755n 0.0v 749.745n 0.0v 749.755n 0.0v 754.745n 0.0v 754.755n 0.0v 759.745n 0.0v 759.755n 0.0v 764.745n 0.0v 764.755n 0.0v 769.745n 0.0v 769.755n 0.0v 774.745n 0.0v 774.755n 0.0v 779.745n 0.0v 779.755n 0.0v 784.745n 0.0v 784.755n 0.0v 789.745n 0.0v 789.755n 0.0v 794.745n 0.0v 794.755n 0.0v 799.745n 0.0v 799.755n 0.0v 804.745n 0.0v 804.755n 0.0v 809.745n 0.0v 809.755n 0.0v 814.745n 0.0v 814.755n 0.95v 819.745n 0.95v 819.755n 0.95v 824.745n 0.95v 824.755n 0.95v 829.745n 0.95v 829.755n 0.95v 834.745n 0.95v 834.755n 0.95v 839.745n 0.95v 839.755n 0.95v 844.745n 0.95v 844.755n 0.95v 849.745n 0.95v 849.755n 0.95v 854.745n 0.95v 854.755n 0.95v 859.745n 0.95v 859.755n 0.95v 864.745n 0.95v 864.755n 0.95v 869.745n 0.95v 869.755n 0.95v 874.745n 0.95v 874.755n 0.95v 879.745n 0.95v 879.755n 0.95v 884.745n 0.95v 884.755n 0.0v 889.745n 0.0v 889.755n 0.0v 894.745n 0.0v 894.755n 0.0v 899.745n 0.0v 899.755n 0.95v 904.745n 0.95v 904.755n 0.95v 909.745n 0.95v 909.755n 0.95v 914.745n 0.95v 914.755n 0.95v 919.745n 0.95v 919.755n 0.95v 924.745n 0.95v 924.755n 0.95v 929.745n 0.95v 929.755n 0.95v 934.745n 0.95v 934.755n 0.95v 939.745n 0.95v 939.755n 0.0v 944.745n 0.0v 944.755n 0.0v 949.745n 0.0v 949.755n 0.0v 954.745n 0.0v 954.755n 0.95v 959.745n 0.95v 959.755n 0.95v 964.745n 0.95v 964.755n 0.95v 969.745n 0.95v 969.755n 0.95v 974.745n 0.95v 974.755n 0.95v 979.745n 0.95v 979.755n 0.95v 984.745n 0.95v 984.755n 0.95v 989.745n 0.95v 989.755n 0.95v 994.745n 0.95v 994.755n 0.95v 999.745n 0.95v 999.755n 0.95v 1004.745n 0.95v 1004.755n 0.95v 1009.745n 0.95v 1009.755n 0.0v 1014.745n 0.0v 1014.755n 0.0v 1019.745n 0.0v 1019.755n 0.0v 1024.745n 0.0v 1024.755n 0.0v )
* (time, data): [(0, 0), (5, 1), (10, 0), (15, 1), (20, 1), (25, 0), (30, 1), (35, 1), (40, 0), (45, 0), (50, 0), (55, 0), (60, 1), (65, 1), (70, 0), (75, 1), (80, 1), (85, 1), (90, 0), (95, 1), (100, 1), (105, 1), (110, 1), (115, 1), (120, 1), (125, 1), (130, 1), (135, 1), (140, 0), (145, 0), (150, 1), (155, 1), (160, 0), (165, 1), (170, 1), (175, 1), (180, 1), (185, 0), (190, 0), (195, 0), (200, 0), (205, 1), (210, 0), (215, 0), (220, 1), (225, 1), (230, 0), (235, 0), (240, 0), (245, 1), (250, 1), (255, 1), (260, 1), (265, 1), (270, 1), (275, 1), (280, 1), (285, 1), (290, 1), (295, 0), (300, 0), (305, 1), (310, 1), (315, 0), (320, 0), (325, 0), (330, 0), (335, 1), (340, 1), (345, 0), (350, 1), (355, 1), (360, 1), (365, 0), (370, 0), (375, 1), (380, 0), (385, 0), (390, 1), (395, 1), (400, 0), (405, 0), (410, 0), (415, 1), (420, 0), (425, 0), (430, 1), (435, 1), (440, 0), (445, 0), (450, 0), (455, 0), (460, 0), (465, 0), (470, 0), (475, 1), (480, 1), (485, 1), (490, 1), (495, 0), (500, 1), (505, 0), (510, 0), (515, 0), (520, 0), (525, 0), (530, 0), (535, 0), (540, 0), (545, 0), (550, 0), (555, 1), (560, 1), (565, 0), (570, 1), (575, 0), (580, 0), (585, 0), (590, 0), (595, 0), (600, 1), (605, 1), (610, 1), (615, 1), (620, 1), (625, 1), (630, 1), (635, 1), (640, 1), (645, 1), (650, 1), (655, 1), (660, 1), (665, 1), (670, 0), (675, 0), (680, 1), (685, 1), (690, 1), (695, 1), (700, 0), (705, 1), (710, 1), (715, 0), (720, 0), (725, 0), (730, 0), (735, 1), (740, 0), (745, 1), (750, 1), (755, 1), (760, 1), (765, 1), (770, 1), (775, 0), (780, 1), (785, 0), (790, 1), (795, 1), (800, 1), (805, 1), (810, 1), (815, 0), (820, 1), (825, 1), (830, 1), (835, 0), (840, 0), (845, 0), (850, 0), (855, 0), (860, 0), (865, 0), (870, 0), (875, 1), (880, 0), (885, 1), (890, 1), (895, 0), (900, 0), (905, 0), (910, 1), (915, 0), (920, 1), (925, 1), (930, 1), (935, 0), (940, 0), (945, 0), (950, 0), (955, 0), (960, 1), (965, 1), (970, 1), (975, 1), (980, 1), (985, 1), (990, 1), (995, 1), (1000, 0), (1005, 0), (1010, 0), (1015, 0), (1020, 1), (1025, 1)]
Va0_0  a0_0  0 PWL (0n 0.0v 4.745n 0.0v 4.755n 0.95v 9.745n 0.95v 9.755n 0.0v 14.745n 0.0v 14.755n 0.95v 19.745n 0.95v 19.755n 0.95v 24.745n 0.95v 24.755n 0.0v 29.745n 0.0v 29.755n 0.95v 34.745n 0.95v 34.755n 0.95v 39.745n 0.95v 39.755n 0.0v 44.745n 0.0v 44.755n 0.0v 49.745n 0.0v 49.755n 0.0v 54.745n 0.0v 54.755n 0.0v 59.745n 0.0v 59.755n 0.95v 64.745n 0.95v 64.755n 0.95v 69.745n 0.95v 69.755n 0.0v 74.745n 0.0v 74.755n 0.95v 79.745n 0.95v 79.755n 0.95v 84.745n 0.95v 84.755n 0.95v 89.745n 0.95v 89.755n 0.0v 94.745n 0.0v 94.755n 0.95v 99.745n 0.95v 99.755n 0.95v 104.745n 0.95v 104.755n 0.95v 109.745n 0.95v 109.755n 0.95v 114.745n 0.95v 114.755n 0.95v 119.745n 0.95v 119.755n 0.95v 124.745n 0.95v 124.755n 0.95v 129.745n 0.95v 129.755n 0.95v 134.745n 0.95v 134.755n 0.95v 139.745n 0.95v 139.755n 0.0v 144.745n 0.0v 144.755n 0.0v 149.745n 0.0v 149.755n 0.95v 154.745n 0.95v 154.755n 0.95v 159.745n 0.95v 159.755n 0.0v 164.745n 0.0v 164.755n 0.95v 169.745n 0.95v 169.755n 0.95v 174.745n 0.95v 174.755n 0.95v 179.745n 0.95v 179.755n 0.95v 184.745n 0.95v 184.755n 0.0v 189.745n 0.0v 189.755n 0.0v 194.745n 0.0v 194.755n 0.0v 199.745n 0.0v 199.755n 0.0v 204.745n 0.0v 204.755n 0.95v 209.745n 0.95v 209.755n 0.0v 214.745n 0.0v 214.755n 0.0v 219.745n 0.0v 219.755n 0.95v 224.745n 0.95v 224.755n 0.95v 229.745n 0.95v 229.755n 0.0v 234.745n 0.0v 234.755n 0.0v 239.745n 0.0v 239.755n 0.0v 244.745n 0.0v 244.755n 0.95v 249.745n 0.95v 249.755n 0.95v 254.745n 0.95v 254.755n 0.95v 259.745n 0.95v 259.755n 0.95v 264.745n 0.95v 264.755n 0.95v 269.745n 0.95v 269.755n 0.95v 274.745n 0.95v 274.755n 0.95v 279.745n 0.95v 279.755n 0.95v 284.745n 0.95v 284.755n 0.95v 289.745n 0.95v 289.755n 0.95v 294.745n 0.95v 294.755n 0.0v 299.745n 0.0v 299.755n 0.0v 304.745n 0.0v 304.755n 0.95v 309.745n 0.95v 309.755n 0.95v 314.745n 0.95v 314.755n 0.0v 319.745n 0.0v 319.755n 0.0v 324.745n 0.0v 324.755n 0.0v 329.745n 0.0v 329.755n 0.0v 334.745n 0.0v 334.755n 0.95v 339.745n 0.95v 339.755n 0.95v 344.745n 0.95v 344.755n 0.0v 349.745n 0.0v 349.755n 0.95v 354.745n 0.95v 354.755n 0.95v 359.745n 0.95v 359.755n 0.95v 364.745n 0.95v 364.755n 0.0v 369.745n 0.0v 369.755n 0.0v 374.745n 0.0v 374.755n 0.95v 379.745n 0.95v 379.755n 0.0v 384.745n 0.0v 384.755n 0.0v 389.745n 0.0v 389.755n 0.95v 394.745n 0.95v 394.755n 0.95v 399.745n 0.95v 399.755n 0.0v 404.745n 0.0v 404.755n 0.0v 409.745n 0.0v 409.755n 0.0v 414.745n 0.0v 414.755n 0.95v 419.745n 0.95v 419.755n 0.0v 424.745n 0.0v 424.755n 0.0v 429.745n 0.0v 429.755n 0.95v 434.745n 0.95v 434.755n 0.95v 439.745n 0.95v 439.755n 0.0v 444.745n 0.0v 444.755n 0.0v 449.745n 0.0v 449.755n 0.0v 454.745n 0.0v 454.755n 0.0v 459.745n 0.0v 459.755n 0.0v 464.745n 0.0v 464.755n 0.0v 469.745n 0.0v 469.755n 0.0v 474.745n 0.0v 474.755n 0.95v 479.745n 0.95v 479.755n 0.95v 484.745n 0.95v 484.755n 0.95v 489.745n 0.95v 489.755n 0.95v 494.745n 0.95v 494.755n 0.0v 499.745n 0.0v 499.755n 0.95v 504.745n 0.95v 504.755n 0.0v 509.745n 0.0v 509.755n 0.0v 514.745n 0.0v 514.755n 0.0v 519.745n 0.0v 519.755n 0.0v 524.745n 0.0v 524.755n 0.0v 529.745n 0.0v 529.755n 0.0v 534.745n 0.0v 534.755n 0.0v 539.745n 0.0v 539.755n 0.0v 544.745n 0.0v 544.755n 0.0v 549.745n 0.0v 549.755n 0.0v 554.745n 0.0v 554.755n 0.95v 559.745n 0.95v 559.755n 0.95v 564.745n 0.95v 564.755n 0.0v 569.745n 0.0v 569.755n 0.95v 574.745n 0.95v 574.755n 0.0v 579.745n 0.0v 579.755n 0.0v 584.745n 0.0v 584.755n 0.0v 589.745n 0.0v 589.755n 0.0v 594.745n 0.0v 594.755n 0.0v 599.745n 0.0v 599.755n 0.95v 604.745n 0.95v 604.755n 0.95v 609.745n 0.95v 609.755n 0.95v 614.745n 0.95v 614.755n 0.95v 619.745n 0.95v 619.755n 0.95v 624.745n 0.95v 624.755n 0.95v 629.745n 0.95v 629.755n 0.95v 634.745n 0.95v 634.755n 0.95v 639.745n 0.95v 639.755n 0.95v 644.745n 0.95v 644.755n 0.95v 649.745n 0.95v 649.755n 0.95v 654.745n 0.95v 654.755n 0.95v 659.745n 0.95v 659.755n 0.95v 664.745n 0.95v 664.755n 0.95v 669.745n 0.95v 669.755n 0.0v 674.745n 0.0v 674.755n 0.0v 679.745n 0.0v 679.755n 0.95v 684.745n 0.95v 684.755n 0.95v 689.745n 0.95v 689.755n 0.95v 694.745n 0.95v 694.755n 0.95v 699.745n 0.95v 699.755n 0.0v 704.745n 0.0v 704.755n 0.95v 709.745n 0.95v 709.755n 0.95v 714.745n 0.95v 714.755n 0.0v 719.745n 0.0v 719.755n 0.0v 724.745n 0.0v 724.755n 0.0v 729.745n 0.0v 729.755n 0.0v 734.745n 0.0v 734.755n 0.95v 739.745n 0.95v 739.755n 0.0v 744.745n 0.0v 744.755n 0.95v 749.745n 0.95v 749.755n 0.95v 754.745n 0.95v 754.755n 0.95v 759.745n 0.95v 759.755n 0.95v 764.745n 0.95v 764.755n 0.95v 769.745n 0.95v 769.755n 0.95v 774.745n 0.95v 774.755n 0.0v 779.745n 0.0v 779.755n 0.95v 784.745n 0.95v 784.755n 0.0v 789.745n 0.0v 789.755n 0.95v 794.745n 0.95v 794.755n 0.95v 799.745n 0.95v 799.755n 0.95v 804.745n 0.95v 804.755n 0.95v 809.745n 0.95v 809.755n 0.95v 814.745n 0.95v 814.755n 0.0v 819.745n 0.0v 819.755n 0.95v 824.745n 0.95v 824.755n 0.95v 829.745n 0.95v 829.755n 0.95v 834.745n 0.95v 834.755n 0.0v 839.745n 0.0v 839.755n 0.0v 844.745n 0.0v 844.755n 0.0v 849.745n 0.0v 849.755n 0.0v 854.745n 0.0v 854.755n 0.0v 859.745n 0.0v 859.755n 0.0v 864.745n 0.0v 864.755n 0.0v 869.745n 0.0v 869.755n 0.0v 874.745n 0.0v 874.755n 0.95v 879.745n 0.95v 879.755n 0.0v 884.745n 0.0v 884.755n 0.95v 889.745n 0.95v 889.755n 0.95v 894.745n 0.95v 894.755n 0.0v 899.745n 0.0v 899.755n 0.0v 904.745n 0.0v 904.755n 0.0v 909.745n 0.0v 909.755n 0.95v 914.745n 0.95v 914.755n 0.0v 919.745n 0.0v 919.755n 0.95v 924.745n 0.95v 924.755n 0.95v 929.745n 0.95v 929.755n 0.95v 934.745n 0.95v 934.755n 0.0v 939.745n 0.0v 939.755n 0.0v 944.745n 0.0v 944.755n 0.0v 949.745n 0.0v 949.755n 0.0v 954.745n 0.0v 954.755n 0.0v 959.745n 0.0v 959.755n 0.95v 964.745n 0.95v 964.755n 0.95v 969.745n 0.95v 969.755n 0.95v 974.745n 0.95v 974.755n 0.95v 979.745n 0.95v 979.755n 0.95v 984.745n 0.95v 984.755n 0.95v 989.745n 0.95v 989.755n 0.95v 994.745n 0.95v 994.755n 0.95v 999.745n 0.95v 999.755n 0.0v 1004.745n 0.0v 1004.755n 0.0v 1009.745n 0.0v 1009.755n 0.0v 1014.745n 0.0v 1014.755n 0.0v 1019.745n 0.0v 1019.755n 0.95v 1024.745n 0.95v 1024.755n 0.95v )
* (time, data): [(0, 0), (5, 0), (10, 1), (15, 1), (20, 1), (25, 1), (30, 0), (35, 0), (40, 0), (45, 0), (50, 0), (55, 0), (60, 1), (65, 1), (70, 1), (75, 0), (80, 1), (85, 1), (90, 0), (95, 1), (100, 1), (105, 1), (110, 1), (115, 1), (120, 1), (125, 1), (130, 1), (135, 0), (140, 1), (145, 0), (150, 1), (155, 1), (160, 1), (165, 0), (170, 0), (175, 1), (180, 1), (185, 1), (190, 1), (195, 0), (200, 1), (205, 1), (210, 0), (215, 0), (220, 0), (225, 1), (230, 1), (235, 1), (240, 1), (245, 0), (250, 0), (255, 0), (260, 1), (265, 1), (270, 1), (275, 0), (280, 0), (285, 0), (290, 0), (295, 0), (300, 1), (305, 0), (310, 0), (315, 0), (320, 0), (325, 1), (330, 1), (335, 1), (340, 0), (345, 1), (350, 1), (355, 1), (360, 1), (365, 0), (370, 0), (375, 0), (380, 0), (385, 0), (390, 1), (395, 1), (400, 0), (405, 1), (410, 1), (415, 1), (420, 1), (425, 1), (430, 1), (435, 1), (440, 1), (445, 0), (450, 1), (455, 0), (460, 0), (465, 1), (470, 0), (475, 0), (480, 0), (485, 1), (490, 0), (495, 1), (500, 1), (505, 0), (510, 0), (515, 1), (520, 0), (525, 0), (530, 1), (535, 0), (540, 0), (545, 1), (550, 1), (555, 1), (560, 1), (565, 1), (570, 1), (575, 0), (580, 0), (585, 0), (590, 0), (595, 0), (600, 1), (605, 0), (610, 0), (615, 1), (620, 1), (625, 1), (630, 0), (635, 1), (640, 0), (645, 1), (650, 1), (655, 0), (660, 0), (665, 1), (670, 1), (675, 1), (680, 1), (685, 1), (690, 1), (695, 1), (700, 1), (705, 0), (710, 0), (715, 1), (720, 1), (725, 1), (730, 1), (735, 1), (740, 0), (745, 0), (750, 1), (755, 1), (760, 0), (765, 0), (770, 0), (775, 1), (780, 0), (785, 0), (790, 1), (795, 1), (800, 1), (805, 1), (810, 1), (815, 1), (820, 1), (825, 1), (830, 1), (835, 1), (840, 1), (845, 0), (850, 1), (855, 1), (860, 1), (865, 0), (870, 0), (875, 0), (880, 0), (885, 0), (890, 1), (895, 1), (900, 0), (905, 1), (910, 1), (915, 0), (920, 1), (925, 1), (930, 1), (935, 1), (940, 1), (945, 0), (950, 1), (955, 1), (960, 0), (965, 0), (970, 0), (975, 0), (980, 0), (985, 0), (990, 0), (995, 0), (1000, 0), (1005, 0), (1010, 0), (1015, 1), (1020, 1), (1025, 1)]
Va0_1  a0_1  0 PWL (0n 0.0v 4.745n 0.0v 4.755n 0.0v 9.745n 0.0v 9.755n 0.95v 14.745n 0.95v 14.755n 0.95v 19.745n 0.95v 19.755n 0.95v 24.745n 0.95v 24.755n 0.95v 29.745n 0.95v 29.755n 0.0v 34.745n 0.0v 34.755n 0.0v 39.745n 0.0v 39.755n 0.0v 44.745n 0.0v 44.755n 0.0v 49.745n 0.0v 49.755n 0.0v 54.745n 0.0v 54.755n 0.0v 59.745n 0.0v 59.755n 0.95v 64.745n 0.95v 64.755n 0.95v 69.745n 0.95v 69.755n 0.95v 74.745n 0.95v 74.755n 0.0v 79.745n 0.0v 79.755n 0.95v 84.745n 0.95v 84.755n 0.95v 89.745n 0.95v 89.755n 0.0v 94.745n 0.0v 94.755n 0.95v 99.745n 0.95v 99.755n 0.95v 104.745n 0.95v 104.755n 0.95v 109.745n 0.95v 109.755n 0.95v 114.745n 0.95v 114.755n 0.95v 119.745n 0.95v 119.755n 0.95v 124.745n 0.95v 124.755n 0.95v 129.745n 0.95v 129.755n 0.95v 134.745n 0.95v 134.755n 0.0v 139.745n 0.0v 139.755n 0.95v 144.745n 0.95v 144.755n 0.0v 149.745n 0.0v 149.755n 0.95v 154.745n 0.95v 154.755n 0.95v 159.745n 0.95v 159.755n 0.95v 164.745n 0.95v 164.755n 0.0v 169.745n 0.0v 169.755n 0.0v 174.745n 0.0v 174.755n 0.95v 179.745n 0.95v 179.755n 0.95v 184.745n 0.95v 184.755n 0.95v 189.745n 0.95v 189.755n 0.95v 194.745n 0.95v 194.755n 0.0v 199.745n 0.0v 199.755n 0.95v 204.745n 0.95v 204.755n 0.95v 209.745n 0.95v 209.755n 0.0v 214.745n 0.0v 214.755n 0.0v 219.745n 0.0v 219.755n 0.0v 224.745n 0.0v 224.755n 0.95v 229.745n 0.95v 229.755n 0.95v 234.745n 0.95v 234.755n 0.95v 239.745n 0.95v 239.755n 0.95v 244.745n 0.95v 244.755n 0.0v 249.745n 0.0v 249.755n 0.0v 254.745n 0.0v 254.755n 0.0v 259.745n 0.0v 259.755n 0.95v 264.745n 0.95v 264.755n 0.95v 269.745n 0.95v 269.755n 0.95v 274.745n 0.95v 274.755n 0.0v 279.745n 0.0v 279.755n 0.0v 284.745n 0.0v 284.755n 0.0v 289.745n 0.0v 289.755n 0.0v 294.745n 0.0v 294.755n 0.0v 299.745n 0.0v 299.755n 0.95v 304.745n 0.95v 304.755n 0.0v 309.745n 0.0v 309.755n 0.0v 314.745n 0.0v 314.755n 0.0v 319.745n 0.0v 319.755n 0.0v 324.745n 0.0v 324.755n 0.95v 329.745n 0.95v 329.755n 0.95v 334.745n 0.95v 334.755n 0.95v 339.745n 0.95v 339.755n 0.0v 344.745n 0.0v 344.755n 0.95v 349.745n 0.95v 349.755n 0.95v 354.745n 0.95v 354.755n 0.95v 359.745n 0.95v 359.755n 0.95v 364.745n 0.95v 364.755n 0.0v 369.745n 0.0v 369.755n 0.0v 374.745n 0.0v 374.755n 0.0v 379.745n 0.0v 379.755n 0.0v 384.745n 0.0v 384.755n 0.0v 389.745n 0.0v 389.755n 0.95v 394.745n 0.95v 394.755n 0.95v 399.745n 0.95v 399.755n 0.0v 404.745n 0.0v 404.755n 0.95v 409.745n 0.95v 409.755n 0.95v 414.745n 0.95v 414.755n 0.95v 419.745n 0.95v 419.755n 0.95v 424.745n 0.95v 424.755n 0.95v 429.745n 0.95v 429.755n 0.95v 434.745n 0.95v 434.755n 0.95v 439.745n 0.95v 439.755n 0.95v 444.745n 0.95v 444.755n 0.0v 449.745n 0.0v 449.755n 0.95v 454.745n 0.95v 454.755n 0.0v 459.745n 0.0v 459.755n 0.0v 464.745n 0.0v 464.755n 0.95v 469.745n 0.95v 469.755n 0.0v 474.745n 0.0v 474.755n 0.0v 479.745n 0.0v 479.755n 0.0v 484.745n 0.0v 484.755n 0.95v 489.745n 0.95v 489.755n 0.0v 494.745n 0.0v 494.755n 0.95v 499.745n 0.95v 499.755n 0.95v 504.745n 0.95v 504.755n 0.0v 509.745n 0.0v 509.755n 0.0v 514.745n 0.0v 514.755n 0.95v 519.745n 0.95v 519.755n 0.0v 524.745n 0.0v 524.755n 0.0v 529.745n 0.0v 529.755n 0.95v 534.745n 0.95v 534.755n 0.0v 539.745n 0.0v 539.755n 0.0v 544.745n 0.0v 544.755n 0.95v 549.745n 0.95v 549.755n 0.95v 554.745n 0.95v 554.755n 0.95v 559.745n 0.95v 559.755n 0.95v 564.745n 0.95v 564.755n 0.95v 569.745n 0.95v 569.755n 0.95v 574.745n 0.95v 574.755n 0.0v 579.745n 0.0v 579.755n 0.0v 584.745n 0.0v 584.755n 0.0v 589.745n 0.0v 589.755n 0.0v 594.745n 0.0v 594.755n 0.0v 599.745n 0.0v 599.755n 0.95v 604.745n 0.95v 604.755n 0.0v 609.745n 0.0v 609.755n 0.0v 614.745n 0.0v 614.755n 0.95v 619.745n 0.95v 619.755n 0.95v 624.745n 0.95v 624.755n 0.95v 629.745n 0.95v 629.755n 0.0v 634.745n 0.0v 634.755n 0.95v 639.745n 0.95v 639.755n 0.0v 644.745n 0.0v 644.755n 0.95v 649.745n 0.95v 649.755n 0.95v 654.745n 0.95v 654.755n 0.0v 659.745n 0.0v 659.755n 0.0v 664.745n 0.0v 664.755n 0.95v 669.745n 0.95v 669.755n 0.95v 674.745n 0.95v 674.755n 0.95v 679.745n 0.95v 679.755n 0.95v 684.745n 0.95v 684.755n 0.95v 689.745n 0.95v 689.755n 0.95v 694.745n 0.95v 694.755n 0.95v 699.745n 0.95v 699.755n 0.95v 704.745n 0.95v 704.755n 0.0v 709.745n 0.0v 709.755n 0.0v 714.745n 0.0v 714.755n 0.95v 719.745n 0.95v 719.755n 0.95v 724.745n 0.95v 724.755n 0.95v 729.745n 0.95v 729.755n 0.95v 734.745n 0.95v 734.755n 0.95v 739.745n 0.95v 739.755n 0.0v 744.745n 0.0v 744.755n 0.0v 749.745n 0.0v 749.755n 0.95v 754.745n 0.95v 754.755n 0.95v 759.745n 0.95v 759.755n 0.0v 764.745n 0.0v 764.755n 0.0v 769.745n 0.0v 769.755n 0.0v 774.745n 0.0v 774.755n 0.95v 779.745n 0.95v 779.755n 0.0v 784.745n 0.0v 784.755n 0.0v 789.745n 0.0v 789.755n 0.95v 794.745n 0.95v 794.755n 0.95v 799.745n 0.95v 799.755n 0.95v 804.745n 0.95v 804.755n 0.95v 809.745n 0.95v 809.755n 0.95v 814.745n 0.95v 814.755n 0.95v 819.745n 0.95v 819.755n 0.95v 824.745n 0.95v 824.755n 0.95v 829.745n 0.95v 829.755n 0.95v 834.745n 0.95v 834.755n 0.95v 839.745n 0.95v 839.755n 0.95v 844.745n 0.95v 844.755n 0.0v 849.745n 0.0v 849.755n 0.95v 854.745n 0.95v 854.755n 0.95v 859.745n 0.95v 859.755n 0.95v 864.745n 0.95v 864.755n 0.0v 869.745n 0.0v 869.755n 0.0v 874.745n 0.0v 874.755n 0.0v 879.745n 0.0v 879.755n 0.0v 884.745n 0.0v 884.755n 0.0v 889.745n 0.0v 889.755n 0.95v 894.745n 0.95v 894.755n 0.95v 899.745n 0.95v 899.755n 0.0v 904.745n 0.0v 904.755n 0.95v 909.745n 0.95v 909.755n 0.95v 914.745n 0.95v 914.755n 0.0v 919.745n 0.0v 919.755n 0.95v 924.745n 0.95v 924.755n 0.95v 929.745n 0.95v 929.755n 0.95v 934.745n 0.95v 934.755n 0.95v 939.745n 0.95v 939.755n 0.95v 944.745n 0.95v 944.755n 0.0v 949.745n 0.0v 949.755n 0.95v 954.745n 0.95v 954.755n 0.95v 959.745n 0.95v 959.755n 0.0v 964.745n 0.0v 964.755n 0.0v 969.745n 0.0v 969.755n 0.0v 974.745n 0.0v 974.755n 0.0v 979.745n 0.0v 979.755n 0.0v 984.745n 0.0v 984.755n 0.0v 989.745n 0.0v 989.755n 0.0v 994.745n 0.0v 994.755n 0.0v 999.745n 0.0v 999.755n 0.0v 1004.745n 0.0v 1004.755n 0.0v 1009.745n 0.0v 1009.755n 0.0v 1014.745n 0.0v 1014.755n 0.95v 1019.745n 0.95v 1019.755n 0.95v 1024.745n 0.95v 1024.755n 0.95v )
* (time, data): [(0, 0), (5, 1), (10, 0), (15, 0), (20, 0), (25, 1), (30, 1), (35, 1), (40, 1), (45, 1), (50, 1), (55, 1), (60, 0), (65, 0), (70, 1), (75, 1), (80, 0), (85, 0), (90, 1), (95, 0), (100, 0), (105, 0), (110, 0), (115, 0), (120, 0), (125, 0), (130, 0), (135, 1), (140, 1), (145, 1), (150, 0), (155, 0), (160, 1), (165, 1), (170, 1), (175, 0), (180, 0), (185, 1), (190, 1), (195, 1), (200, 1), (205, 0), (210, 1), (215, 1), (220, 1), (225, 0), (230, 1), (235, 1), (240, 1), (245, 0), (250, 0), (255, 0), (260, 0), (265, 0), (270, 0), (275, 1), (280, 1), (285, 1), (290, 1), (295, 1), (300, 1), (305, 0), (310, 1), (315, 1), (320, 1), (325, 1), (330, 1), (335, 0), (340, 1), (345, 1), (350, 0), (355, 0), (360, 0), (365, 0), (370, 0), (375, 1), (380, 0), (385, 0), (390, 0), (395, 0), (400, 0), (405, 0), (410, 0), (415, 0), (420, 1), (425, 1), (430, 0), (435, 0), (440, 0), (445, 1), (450, 0), (455, 0), (460, 0), (465, 1), (470, 1), (475, 1), (480, 1), (485, 0), (490, 0), (495, 1), (500, 0), (505, 0), (510, 0), (515, 0), (520, 1), (525, 1), (530, 1), (535, 1), (540, 1), (545, 0), (550, 0), (555, 0), (560, 0), (565, 0), (570, 0), (575, 1), (580, 0), (585, 0), (590, 0), (595, 0), (600, 0), (605, 0), (610, 0), (615, 0), (620, 0), (625, 0), (630, 1), (635, 0), (640, 1), (645, 0), (650, 0), (655, 0), (660, 0), (665, 0), (670, 0), (675, 1), (680, 0), (685, 0), (690, 0), (695, 0), (700, 1), (705, 0), (710, 0), (715, 0), (720, 1), (725, 0), (730, 0), (735, 0), (740, 0), (745, 1), (750, 0), (755, 0), (760, 1), (765, 1), (770, 1), (775, 1), (780, 1), (785, 1), (790, 0), (795, 0), (800, 0), (805, 0), (810, 0), (815, 1), (820, 0), (825, 0), (830, 0), (835, 0), (840, 1), (845, 0), (850, 1), (855, 1), (860, 1), (865, 1), (870, 0), (875, 1), (880, 1), (885, 0), (890, 0), (895, 1), (900, 0), (905, 0), (910, 0), (915, 1), (920, 0), (925, 0), (930, 0), (935, 0), (940, 0), (945, 0), (950, 1), (955, 0), (960, 1), (965, 0), (970, 0), (975, 0), (980, 0), (985, 0), (990, 0), (995, 0), (1000, 0), (1005, 0), (1010, 0), (1015, 0), (1020, 0), (1025, 0)]
Va0_2  a0_2  0 PWL (0n 0.0v 4.745n 0.0v 4.755n 0.95v 9.745n 0.95v 9.755n 0.0v 14.745n 0.0v 14.755n 0.0v 19.745n 0.0v 19.755n 0.0v 24.745n 0.0v 24.755n 0.95v 29.745n 0.95v 29.755n 0.95v 34.745n 0.95v 34.755n 0.95v 39.745n 0.95v 39.755n 0.95v 44.745n 0.95v 44.755n 0.95v 49.745n 0.95v 49.755n 0.95v 54.745n 0.95v 54.755n 0.95v 59.745n 0.95v 59.755n 0.0v 64.745n 0.0v 64.755n 0.0v 69.745n 0.0v 69.755n 0.95v 74.745n 0.95v 74.755n 0.95v 79.745n 0.95v 79.755n 0.0v 84.745n 0.0v 84.755n 0.0v 89.745n 0.0v 89.755n 0.95v 94.745n 0.95v 94.755n 0.0v 99.745n 0.0v 99.755n 0.0v 104.745n 0.0v 104.755n 0.0v 109.745n 0.0v 109.755n 0.0v 114.745n 0.0v 114.755n 0.0v 119.745n 0.0v 119.755n 0.0v 124.745n 0.0v 124.755n 0.0v 129.745n 0.0v 129.755n 0.0v 134.745n 0.0v 134.755n 0.95v 139.745n 0.95v 139.755n 0.95v 144.745n 0.95v 144.755n 0.95v 149.745n 0.95v 149.755n 0.0v 154.745n 0.0v 154.755n 0.0v 159.745n 0.0v 159.755n 0.95v 164.745n 0.95v 164.755n 0.95v 169.745n 0.95v 169.755n 0.95v 174.745n 0.95v 174.755n 0.0v 179.745n 0.0v 179.755n 0.0v 184.745n 0.0v 184.755n 0.95v 189.745n 0.95v 189.755n 0.95v 194.745n 0.95v 194.755n 0.95v 199.745n 0.95v 199.755n 0.95v 204.745n 0.95v 204.755n 0.0v 209.745n 0.0v 209.755n 0.95v 214.745n 0.95v 214.755n 0.95v 219.745n 0.95v 219.755n 0.95v 224.745n 0.95v 224.755n 0.0v 229.745n 0.0v 229.755n 0.95v 234.745n 0.95v 234.755n 0.95v 239.745n 0.95v 239.755n 0.95v 244.745n 0.95v 244.755n 0.0v 249.745n 0.0v 249.755n 0.0v 254.745n 0.0v 254.755n 0.0v 259.745n 0.0v 259.755n 0.0v 264.745n 0.0v 264.755n 0.0v 269.745n 0.0v 269.755n 0.0v 274.745n 0.0v 274.755n 0.95v 279.745n 0.95v 279.755n 0.95v 284.745n 0.95v 284.755n 0.95v 289.745n 0.95v 289.755n 0.95v 294.745n 0.95v 294.755n 0.95v 299.745n 0.95v 299.755n 0.95v 304.745n 0.95v 304.755n 0.0v 309.745n 0.0v 309.755n 0.95v 314.745n 0.95v 314.755n 0.95v 319.745n 0.95v 319.755n 0.95v 324.745n 0.95v 324.755n 0.95v 329.745n 0.95v 329.755n 0.95v 334.745n 0.95v 334.755n 0.0v 339.745n 0.0v 339.755n 0.95v 344.745n 0.95v 344.755n 0.95v 349.745n 0.95v 349.755n 0.0v 354.745n 0.0v 354.755n 0.0v 359.745n 0.0v 359.755n 0.0v 364.745n 0.0v 364.755n 0.0v 369.745n 0.0v 369.755n 0.0v 374.745n 0.0v 374.755n 0.95v 379.745n 0.95v 379.755n 0.0v 384.745n 0.0v 384.755n 0.0v 389.745n 0.0v 389.755n 0.0v 394.745n 0.0v 394.755n 0.0v 399.745n 0.0v 399.755n 0.0v 404.745n 0.0v 404.755n 0.0v 409.745n 0.0v 409.755n 0.0v 414.745n 0.0v 414.755n 0.0v 419.745n 0.0v 419.755n 0.95v 424.745n 0.95v 424.755n 0.95v 429.745n 0.95v 429.755n 0.0v 434.745n 0.0v 434.755n 0.0v 439.745n 0.0v 439.755n 0.0v 444.745n 0.0v 444.755n 0.95v 449.745n 0.95v 449.755n 0.0v 454.745n 0.0v 454.755n 0.0v 459.745n 0.0v 459.755n 0.0v 464.745n 0.0v 464.755n 0.95v 469.745n 0.95v 469.755n 0.95v 474.745n 0.95v 474.755n 0.95v 479.745n 0.95v 479.755n 0.95v 484.745n 0.95v 484.755n 0.0v 489.745n 0.0v 489.755n 0.0v 494.745n 0.0v 494.755n 0.95v 499.745n 0.95v 499.755n 0.0v 504.745n 0.0v 504.755n 0.0v 509.745n 0.0v 509.755n 0.0v 514.745n 0.0v 514.755n 0.0v 519.745n 0.0v 519.755n 0.95v 524.745n 0.95v 524.755n 0.95v 529.745n 0.95v 529.755n 0.95v 534.745n 0.95v 534.755n 0.95v 539.745n 0.95v 539.755n 0.95v 544.745n 0.95v 544.755n 0.0v 549.745n 0.0v 549.755n 0.0v 554.745n 0.0v 554.755n 0.0v 559.745n 0.0v 559.755n 0.0v 564.745n 0.0v 564.755n 0.0v 569.745n 0.0v 569.755n 0.0v 574.745n 0.0v 574.755n 0.95v 579.745n 0.95v 579.755n 0.0v 584.745n 0.0v 584.755n 0.0v 589.745n 0.0v 589.755n 0.0v 594.745n 0.0v 594.755n 0.0v 599.745n 0.0v 599.755n 0.0v 604.745n 0.0v 604.755n 0.0v 609.745n 0.0v 609.755n 0.0v 614.745n 0.0v 614.755n 0.0v 619.745n 0.0v 619.755n 0.0v 624.745n 0.0v 624.755n 0.0v 629.745n 0.0v 629.755n 0.95v 634.745n 0.95v 634.755n 0.0v 639.745n 0.0v 639.755n 0.95v 644.745n 0.95v 644.755n 0.0v 649.745n 0.0v 649.755n 0.0v 654.745n 0.0v 654.755n 0.0v 659.745n 0.0v 659.755n 0.0v 664.745n 0.0v 664.755n 0.0v 669.745n 0.0v 669.755n 0.0v 674.745n 0.0v 674.755n 0.95v 679.745n 0.95v 679.755n 0.0v 684.745n 0.0v 684.755n 0.0v 689.745n 0.0v 689.755n 0.0v 694.745n 0.0v 694.755n 0.0v 699.745n 0.0v 699.755n 0.95v 704.745n 0.95v 704.755n 0.0v 709.745n 0.0v 709.755n 0.0v 714.745n 0.0v 714.755n 0.0v 719.745n 0.0v 719.755n 0.95v 724.745n 0.95v 724.755n 0.0v 729.745n 0.0v 729.755n 0.0v 734.745n 0.0v 734.755n 0.0v 739.745n 0.0v 739.755n 0.0v 744.745n 0.0v 744.755n 0.95v 749.745n 0.95v 749.755n 0.0v 754.745n 0.0v 754.755n 0.0v 759.745n 0.0v 759.755n 0.95v 764.745n 0.95v 764.755n 0.95v 769.745n 0.95v 769.755n 0.95v 774.745n 0.95v 774.755n 0.95v 779.745n 0.95v 779.755n 0.95v 784.745n 0.95v 784.755n 0.95v 789.745n 0.95v 789.755n 0.0v 794.745n 0.0v 794.755n 0.0v 799.745n 0.0v 799.755n 0.0v 804.745n 0.0v 804.755n 0.0v 809.745n 0.0v 809.755n 0.0v 814.745n 0.0v 814.755n 0.95v 819.745n 0.95v 819.755n 0.0v 824.745n 0.0v 824.755n 0.0v 829.745n 0.0v 829.755n 0.0v 834.745n 0.0v 834.755n 0.0v 839.745n 0.0v 839.755n 0.95v 844.745n 0.95v 844.755n 0.0v 849.745n 0.0v 849.755n 0.95v 854.745n 0.95v 854.755n 0.95v 859.745n 0.95v 859.755n 0.95v 864.745n 0.95v 864.755n 0.95v 869.745n 0.95v 869.755n 0.0v 874.745n 0.0v 874.755n 0.95v 879.745n 0.95v 879.755n 0.95v 884.745n 0.95v 884.755n 0.0v 889.745n 0.0v 889.755n 0.0v 894.745n 0.0v 894.755n 0.95v 899.745n 0.95v 899.755n 0.0v 904.745n 0.0v 904.755n 0.0v 909.745n 0.0v 909.755n 0.0v 914.745n 0.0v 914.755n 0.95v 919.745n 0.95v 919.755n 0.0v 924.745n 0.0v 924.755n 0.0v 929.745n 0.0v 929.755n 0.0v 934.745n 0.0v 934.755n 0.0v 939.745n 0.0v 939.755n 0.0v 944.745n 0.0v 944.755n 0.0v 949.745n 0.0v 949.755n 0.95v 954.745n 0.95v 954.755n 0.0v 959.745n 0.0v 959.755n 0.95v 964.745n 0.95v 964.755n 0.0v 969.745n 0.0v 969.755n 0.0v 974.745n 0.0v 974.755n 0.0v 979.745n 0.0v 979.755n 0.0v 984.745n 0.0v 984.755n 0.0v 989.745n 0.0v 989.755n 0.0v 994.745n 0.0v 994.755n 0.0v 999.745n 0.0v 999.755n 0.0v 1004.745n 0.0v 1004.755n 0.0v 1009.745n 0.0v 1009.755n 0.0v 1014.745n 0.0v 1014.755n 0.0v 1019.745n 0.0v 1019.755n 0.0v 1024.745n 0.0v 1024.755n 0.0v )
* (time, data): [(0, 0), (5, 1), (10, 0), (15, 0), (20, 0), (25, 1), (30, 1), (35, 1), (40, 1), (45, 1), (50, 1), (55, 1), (60, 0), (65, 1), (70, 1), (75, 1), (80, 1), (85, 1), (90, 1), (95, 0), (100, 0), (105, 0), (110, 0), (115, 0), (120, 0), (125, 0), (130, 0), (135, 1), (140, 1), (145, 1), (150, 1), (155, 0), (160, 1), (165, 1), (170, 1), (175, 0), (180, 0), (185, 1), (190, 1), (195, 1), (200, 1), (205, 0), (210, 1), (215, 1), (220, 1), (225, 1), (230, 1), (235, 1), (240, 1), (245, 0), (250, 0), (255, 0), (260, 0), (265, 0), (270, 1), (275, 1), (280, 1), (285, 1), (290, 1), (295, 1), (300, 1), (305, 0), (310, 1), (315, 1), (320, 1), (325, 1), (330, 1), (335, 1), (340, 1), (345, 1), (350, 0), (355, 0), (360, 1), (365, 0), (370, 0), (375, 1), (380, 0), (385, 0), (390, 1), (395, 0), (400, 0), (405, 0), (410, 0), (415, 0), (420, 1), (425, 1), (430, 0), (435, 0), (440, 0), (445, 1), (450, 0), (455, 0), (460, 0), (465, 1), (470, 1), (475, 1), (480, 1), (485, 0), (490, 0), (495, 1), (500, 0), (505, 0), (510, 0), (515, 0), (520, 1), (525, 1), (530, 1), (535, 1), (540, 1), (545, 0), (550, 0), (555, 0), (560, 0), (565, 0), (570, 0), (575, 1), (580, 0), (585, 0), (590, 0), (595, 0), (600, 1), (605, 0), (610, 0), (615, 0), (620, 0), (625, 0), (630, 1), (635, 0), (640, 1), (645, 0), (650, 0), (655, 0), (660, 0), (665, 0), (670, 0), (675, 1), (680, 0), (685, 0), (690, 0), (695, 0), (700, 1), (705, 0), (710, 0), (715, 0), (720, 1), (725, 0), (730, 0), (735, 1), (740, 0), (745, 1), (750, 1), (755, 1), (760, 1), (765, 1), (770, 1), (775, 1), (780, 1), (785, 1), (790, 0), (795, 0), (800, 0), (805, 0), (810, 0), (815, 1), (820, 0), (825, 0), (830, 1), (835, 0), (840, 1), (845, 0), (850, 1), (855, 1), (860, 1), (865, 1), (870, 0), (875, 1), (880, 1), (885, 0), (890, 0), (895, 1), (900, 0), (905, 0), (910, 0), (915, 1), (920, 0), (925, 0), (930, 0), (935, 0), (940, 0), (945, 0), (950, 1), (955, 0), (960, 1), (965, 0), (970, 0), (975, 0), (980, 0), (985, 0), (990, 0), (995, 0), (1000, 0), (1005, 0), (1010, 0), (1015, 0), (1020, 1), (1025, 1)]
Va0_3  a0_3  0 PWL (0n 0.0v 4.745n 0.0v 4.755n 0.95v 9.745n 0.95v 9.755n 0.0v 14.745n 0.0v 14.755n 0.0v 19.745n 0.0v 19.755n 0.0v 24.745n 0.0v 24.755n 0.95v 29.745n 0.95v 29.755n 0.95v 34.745n 0.95v 34.755n 0.95v 39.745n 0.95v 39.755n 0.95v 44.745n 0.95v 44.755n 0.95v 49.745n 0.95v 49.755n 0.95v 54.745n 0.95v 54.755n 0.95v 59.745n 0.95v 59.755n 0.0v 64.745n 0.0v 64.755n 0.95v 69.745n 0.95v 69.755n 0.95v 74.745n 0.95v 74.755n 0.95v 79.745n 0.95v 79.755n 0.95v 84.745n 0.95v 84.755n 0.95v 89.745n 0.95v 89.755n 0.95v 94.745n 0.95v 94.755n 0.0v 99.745n 0.0v 99.755n 0.0v 104.745n 0.0v 104.755n 0.0v 109.745n 0.0v 109.755n 0.0v 114.745n 0.0v 114.755n 0.0v 119.745n 0.0v 119.755n 0.0v 124.745n 0.0v 124.755n 0.0v 129.745n 0.0v 129.755n 0.0v 134.745n 0.0v 134.755n 0.95v 139.745n 0.95v 139.755n 0.95v 144.745n 0.95v 144.755n 0.95v 149.745n 0.95v 149.755n 0.95v 154.745n 0.95v 154.755n 0.0v 159.745n 0.0v 159.755n 0.95v 164.745n 0.95v 164.755n 0.95v 169.745n 0.95v 169.755n 0.95v 174.745n 0.95v 174.755n 0.0v 179.745n 0.0v 179.755n 0.0v 184.745n 0.0v 184.755n 0.95v 189.745n 0.95v 189.755n 0.95v 194.745n 0.95v 194.755n 0.95v 199.745n 0.95v 199.755n 0.95v 204.745n 0.95v 204.755n 0.0v 209.745n 0.0v 209.755n 0.95v 214.745n 0.95v 214.755n 0.95v 219.745n 0.95v 219.755n 0.95v 224.745n 0.95v 224.755n 0.95v 229.745n 0.95v 229.755n 0.95v 234.745n 0.95v 234.755n 0.95v 239.745n 0.95v 239.755n 0.95v 244.745n 0.95v 244.755n 0.0v 249.745n 0.0v 249.755n 0.0v 254.745n 0.0v 254.755n 0.0v 259.745n 0.0v 259.755n 0.0v 264.745n 0.0v 264.755n 0.0v 269.745n 0.0v 269.755n 0.95v 274.745n 0.95v 274.755n 0.95v 279.745n 0.95v 279.755n 0.95v 284.745n 0.95v 284.755n 0.95v 289.745n 0.95v 289.755n 0.95v 294.745n 0.95v 294.755n 0.95v 299.745n 0.95v 299.755n 0.95v 304.745n 0.95v 304.755n 0.0v 309.745n 0.0v 309.755n 0.95v 314.745n 0.95v 314.755n 0.95v 319.745n 0.95v 319.755n 0.95v 324.745n 0.95v 324.755n 0.95v 329.745n 0.95v 329.755n 0.95v 334.745n 0.95v 334.755n 0.95v 339.745n 0.95v 339.755n 0.95v 344.745n 0.95v 344.755n 0.95v 349.745n 0.95v 349.755n 0.0v 354.745n 0.0v 354.755n 0.0v 359.745n 0.0v 359.755n 0.95v 364.745n 0.95v 364.755n 0.0v 369.745n 0.0v 369.755n 0.0v 374.745n 0.0v 374.755n 0.95v 379.745n 0.95v 379.755n 0.0v 384.745n 0.0v 384.755n 0.0v 389.745n 0.0v 389.755n 0.95v 394.745n 0.95v 394.755n 0.0v 399.745n 0.0v 399.755n 0.0v 404.745n 0.0v 404.755n 0.0v 409.745n 0.0v 409.755n 0.0v 414.745n 0.0v 414.755n 0.0v 419.745n 0.0v 419.755n 0.95v 424.745n 0.95v 424.755n 0.95v 429.745n 0.95v 429.755n 0.0v 434.745n 0.0v 434.755n 0.0v 439.745n 0.0v 439.755n 0.0v 444.745n 0.0v 444.755n 0.95v 449.745n 0.95v 449.755n 0.0v 454.745n 0.0v 454.755n 0.0v 459.745n 0.0v 459.755n 0.0v 464.745n 0.0v 464.755n 0.95v 469.745n 0.95v 469.755n 0.95v 474.745n 0.95v 474.755n 0.95v 479.745n 0.95v 479.755n 0.95v 484.745n 0.95v 484.755n 0.0v 489.745n 0.0v 489.755n 0.0v 494.745n 0.0v 494.755n 0.95v 499.745n 0.95v 499.755n 0.0v 504.745n 0.0v 504.755n 0.0v 509.745n 0.0v 509.755n 0.0v 514.745n 0.0v 514.755n 0.0v 519.745n 0.0v 519.755n 0.95v 524.745n 0.95v 524.755n 0.95v 529.745n 0.95v 529.755n 0.95v 534.745n 0.95v 534.755n 0.95v 539.745n 0.95v 539.755n 0.95v 544.745n 0.95v 544.755n 0.0v 549.745n 0.0v 549.755n 0.0v 554.745n 0.0v 554.755n 0.0v 559.745n 0.0v 559.755n 0.0v 564.745n 0.0v 564.755n 0.0v 569.745n 0.0v 569.755n 0.0v 574.745n 0.0v 574.755n 0.95v 579.745n 0.95v 579.755n 0.0v 584.745n 0.0v 584.755n 0.0v 589.745n 0.0v 589.755n 0.0v 594.745n 0.0v 594.755n 0.0v 599.745n 0.0v 599.755n 0.95v 604.745n 0.95v 604.755n 0.0v 609.745n 0.0v 609.755n 0.0v 614.745n 0.0v 614.755n 0.0v 619.745n 0.0v 619.755n 0.0v 624.745n 0.0v 624.755n 0.0v 629.745n 0.0v 629.755n 0.95v 634.745n 0.95v 634.755n 0.0v 639.745n 0.0v 639.755n 0.95v 644.745n 0.95v 644.755n 0.0v 649.745n 0.0v 649.755n 0.0v 654.745n 0.0v 654.755n 0.0v 659.745n 0.0v 659.755n 0.0v 664.745n 0.0v 664.755n 0.0v 669.745n 0.0v 669.755n 0.0v 674.745n 0.0v 674.755n 0.95v 679.745n 0.95v 679.755n 0.0v 684.745n 0.0v 684.755n 0.0v 689.745n 0.0v 689.755n 0.0v 694.745n 0.0v 694.755n 0.0v 699.745n 0.0v 699.755n 0.95v 704.745n 0.95v 704.755n 0.0v 709.745n 0.0v 709.755n 0.0v 714.745n 0.0v 714.755n 0.0v 719.745n 0.0v 719.755n 0.95v 724.745n 0.95v 724.755n 0.0v 729.745n 0.0v 729.755n 0.0v 734.745n 0.0v 734.755n 0.95v 739.745n 0.95v 739.755n 0.0v 744.745n 0.0v 744.755n 0.95v 749.745n 0.95v 749.755n 0.95v 754.745n 0.95v 754.755n 0.95v 759.745n 0.95v 759.755n 0.95v 764.745n 0.95v 764.755n 0.95v 769.745n 0.95v 769.755n 0.95v 774.745n 0.95v 774.755n 0.95v 779.745n 0.95v 779.755n 0.95v 784.745n 0.95v 784.755n 0.95v 789.745n 0.95v 789.755n 0.0v 794.745n 0.0v 794.755n 0.0v 799.745n 0.0v 799.755n 0.0v 804.745n 0.0v 804.755n 0.0v 809.745n 0.0v 809.755n 0.0v 814.745n 0.0v 814.755n 0.95v 819.745n 0.95v 819.755n 0.0v 824.745n 0.0v 824.755n 0.0v 829.745n 0.0v 829.755n 0.95v 834.745n 0.95v 834.755n 0.0v 839.745n 0.0v 839.755n 0.95v 844.745n 0.95v 844.755n 0.0v 849.745n 0.0v 849.755n 0.95v 854.745n 0.95v 854.755n 0.95v 859.745n 0.95v 859.755n 0.95v 864.745n 0.95v 864.755n 0.95v 869.745n 0.95v 869.755n 0.0v 874.745n 0.0v 874.755n 0.95v 879.745n 0.95v 879.755n 0.95v 884.745n 0.95v 884.755n 0.0v 889.745n 0.0v 889.755n 0.0v 894.745n 0.0v 894.755n 0.95v 899.745n 0.95v 899.755n 0.0v 904.745n 0.0v 904.755n 0.0v 909.745n 0.0v 909.755n 0.0v 914.745n 0.0v 914.755n 0.95v 919.745n 0.95v 919.755n 0.0v 924.745n 0.0v 924.755n 0.0v 929.745n 0.0v 929.755n 0.0v 934.745n 0.0v 934.755n 0.0v 939.745n 0.0v 939.755n 0.0v 944.745n 0.0v 944.755n 0.0v 949.745n 0.0v 949.755n 0.95v 954.745n 0.95v 954.755n 0.0v 959.745n 0.0v 959.755n 0.95v 964.745n 0.95v 964.755n 0.0v 969.745n 0.0v 969.755n 0.0v 974.745n 0.0v 974.755n 0.0v 979.745n 0.0v 979.755n 0.0v 984.745n 0.0v 984.755n 0.0v 989.745n 0.0v 989.755n 0.0v 994.745n 0.0v 994.755n 0.0v 999.745n 0.0v 999.755n 0.0v 1004.745n 0.0v 1004.755n 0.0v 1009.745n 0.0v 1009.755n 0.0v 1014.745n 0.0v 1014.755n 0.0v 1019.745n 0.0v 1019.755n 0.95v 1024.745n 0.95v 1024.755n 0.95v )
* (time, data): [(0, 0), (5, 1), (10, 0), (15, 0), (20, 0), (25, 1), (30, 1), (35, 1), (40, 1), (45, 1), (50, 1), (55, 1), (60, 0), (65, 1), (70, 1), (75, 1), (80, 1), (85, 1), (90, 1), (95, 0), (100, 0), (105, 0), (110, 0), (115, 0), (120, 0), (125, 0), (130, 0), (135, 1), (140, 1), (145, 1), (150, 1), (155, 0), (160, 1), (165, 1), (170, 1), (175, 0), (180, 0), (185, 1), (190, 1), (195, 1), (200, 1), (205, 0), (210, 1), (215, 1), (220, 1), (225, 1), (230, 1), (235, 1), (240, 1), (245, 0), (250, 0), (255, 0), (260, 0), (265, 0), (270, 1), (275, 1), (280, 1), (285, 1), (290, 1), (295, 1), (300, 1), (305, 0), (310, 1), (315, 1), (320, 1), (325, 1), (330, 1), (335, 1), (340, 1), (345, 1), (350, 0), (355, 0), (360, 1), (365, 0), (370, 0), (375, 1), (380, 0), (385, 0), (390, 1), (395, 0), (400, 0), (405, 0), (410, 0), (415, 0), (420, 1), (425, 1), (430, 0), (435, 0), (440, 0), (445, 1), (450, 0), (455, 0), (460, 0), (465, 1), (470, 1), (475, 1), (480, 1), (485, 0), (490, 0), (495, 1), (500, 0), (505, 0), (510, 0), (515, 0), (520, 1), (525, 1), (530, 1), (535, 1), (540, 1), (545, 0), (550, 0), (555, 0), (560, 0), (565, 0), (570, 0), (575, 1), (580, 0), (585, 0), (590, 0), (595, 0), (600, 1), (605, 0), (610, 0), (615, 0), (620, 0), (625, 0), (630, 1), (635, 0), (640, 1), (645, 0), (650, 0), (655, 0), (660, 0), (665, 0), (670, 0), (675, 1), (680, 0), (685, 0), (690, 0), (695, 0), (700, 1), (705, 0), (710, 0), (715, 0), (720, 1), (725, 0), (730, 0), (735, 1), (740, 0), (745, 1), (750, 1), (755, 1), (760, 1), (765, 1), (770, 1), (775, 1), (780, 1), (785, 1), (790, 0), (795, 0), (800, 0), (805, 0), (810, 0), (815, 1), (820, 0), (825, 0), (830, 1), (835, 0), (840, 1), (845, 0), (850, 1), (855, 1), (860, 1), (865, 1), (870, 0), (875, 1), (880, 1), (885, 0), (890, 0), (895, 1), (900, 0), (905, 0), (910, 0), (915, 1), (920, 0), (925, 0), (930, 0), (935, 0), (940, 0), (945, 0), (950, 1), (955, 0), (960, 1), (965, 0), (970, 0), (975, 0), (980, 0), (985, 0), (990, 0), (995, 0), (1000, 0), (1005, 0), (1010, 0), (1015, 0), (1020, 1), (1025, 1)]
Va0_4  a0_4  0 PWL (0n 0.0v 4.745n 0.0v 4.755n 0.95v 9.745n 0.95v 9.755n 0.0v 14.745n 0.0v 14.755n 0.0v 19.745n 0.0v 19.755n 0.0v 24.745n 0.0v 24.755n 0.95v 29.745n 0.95v 29.755n 0.95v 34.745n 0.95v 34.755n 0.95v 39.745n 0.95v 39.755n 0.95v 44.745n 0.95v 44.755n 0.95v 49.745n 0.95v 49.755n 0.95v 54.745n 0.95v 54.755n 0.95v 59.745n 0.95v 59.755n 0.0v 64.745n 0.0v 64.755n 0.95v 69.745n 0.95v 69.755n 0.95v 74.745n 0.95v 74.755n 0.95v 79.745n 0.95v 79.755n 0.95v 84.745n 0.95v 84.755n 0.95v 89.745n 0.95v 89.755n 0.95v 94.745n 0.95v 94.755n 0.0v 99.745n 0.0v 99.755n 0.0v 104.745n 0.0v 104.755n 0.0v 109.745n 0.0v 109.755n 0.0v 114.745n 0.0v 114.755n 0.0v 119.745n 0.0v 119.755n 0.0v 124.745n 0.0v 124.755n 0.0v 129.745n 0.0v 129.755n 0.0v 134.745n 0.0v 134.755n 0.95v 139.745n 0.95v 139.755n 0.95v 144.745n 0.95v 144.755n 0.95v 149.745n 0.95v 149.755n 0.95v 154.745n 0.95v 154.755n 0.0v 159.745n 0.0v 159.755n 0.95v 164.745n 0.95v 164.755n 0.95v 169.745n 0.95v 169.755n 0.95v 174.745n 0.95v 174.755n 0.0v 179.745n 0.0v 179.755n 0.0v 184.745n 0.0v 184.755n 0.95v 189.745n 0.95v 189.755n 0.95v 194.745n 0.95v 194.755n 0.95v 199.745n 0.95v 199.755n 0.95v 204.745n 0.95v 204.755n 0.0v 209.745n 0.0v 209.755n 0.95v 214.745n 0.95v 214.755n 0.95v 219.745n 0.95v 219.755n 0.95v 224.745n 0.95v 224.755n 0.95v 229.745n 0.95v 229.755n 0.95v 234.745n 0.95v 234.755n 0.95v 239.745n 0.95v 239.755n 0.95v 244.745n 0.95v 244.755n 0.0v 249.745n 0.0v 249.755n 0.0v 254.745n 0.0v 254.755n 0.0v 259.745n 0.0v 259.755n 0.0v 264.745n 0.0v 264.755n 0.0v 269.745n 0.0v 269.755n 0.95v 274.745n 0.95v 274.755n 0.95v 279.745n 0.95v 279.755n 0.95v 284.745n 0.95v 284.755n 0.95v 289.745n 0.95v 289.755n 0.95v 294.745n 0.95v 294.755n 0.95v 299.745n 0.95v 299.755n 0.95v 304.745n 0.95v 304.755n 0.0v 309.745n 0.0v 309.755n 0.95v 314.745n 0.95v 314.755n 0.95v 319.745n 0.95v 319.755n 0.95v 324.745n 0.95v 324.755n 0.95v 329.745n 0.95v 329.755n 0.95v 334.745n 0.95v 334.755n 0.95v 339.745n 0.95v 339.755n 0.95v 344.745n 0.95v 344.755n 0.95v 349.745n 0.95v 349.755n 0.0v 354.745n 0.0v 354.755n 0.0v 359.745n 0.0v 359.755n 0.95v 364.745n 0.95v 364.755n 0.0v 369.745n 0.0v 369.755n 0.0v 374.745n 0.0v 374.755n 0.95v 379.745n 0.95v 379.755n 0.0v 384.745n 0.0v 384.755n 0.0v 389.745n 0.0v 389.755n 0.95v 394.745n 0.95v 394.755n 0.0v 399.745n 0.0v 399.755n 0.0v 404.745n 0.0v 404.755n 0.0v 409.745n 0.0v 409.755n 0.0v 414.745n 0.0v 414.755n 0.0v 419.745n 0.0v 419.755n 0.95v 424.745n 0.95v 424.755n 0.95v 429.745n 0.95v 429.755n 0.0v 434.745n 0.0v 434.755n 0.0v 439.745n 0.0v 439.755n 0.0v 444.745n 0.0v 444.755n 0.95v 449.745n 0.95v 449.755n 0.0v 454.745n 0.0v 454.755n 0.0v 459.745n 0.0v 459.755n 0.0v 464.745n 0.0v 464.755n 0.95v 469.745n 0.95v 469.755n 0.95v 474.745n 0.95v 474.755n 0.95v 479.745n 0.95v 479.755n 0.95v 484.745n 0.95v 484.755n 0.0v 489.745n 0.0v 489.755n 0.0v 494.745n 0.0v 494.755n 0.95v 499.745n 0.95v 499.755n 0.0v 504.745n 0.0v 504.755n 0.0v 509.745n 0.0v 509.755n 0.0v 514.745n 0.0v 514.755n 0.0v 519.745n 0.0v 519.755n 0.95v 524.745n 0.95v 524.755n 0.95v 529.745n 0.95v 529.755n 0.95v 534.745n 0.95v 534.755n 0.95v 539.745n 0.95v 539.755n 0.95v 544.745n 0.95v 544.755n 0.0v 549.745n 0.0v 549.755n 0.0v 554.745n 0.0v 554.755n 0.0v 559.745n 0.0v 559.755n 0.0v 564.745n 0.0v 564.755n 0.0v 569.745n 0.0v 569.755n 0.0v 574.745n 0.0v 574.755n 0.95v 579.745n 0.95v 579.755n 0.0v 584.745n 0.0v 584.755n 0.0v 589.745n 0.0v 589.755n 0.0v 594.745n 0.0v 594.755n 0.0v 599.745n 0.0v 599.755n 0.95v 604.745n 0.95v 604.755n 0.0v 609.745n 0.0v 609.755n 0.0v 614.745n 0.0v 614.755n 0.0v 619.745n 0.0v 619.755n 0.0v 624.745n 0.0v 624.755n 0.0v 629.745n 0.0v 629.755n 0.95v 634.745n 0.95v 634.755n 0.0v 639.745n 0.0v 639.755n 0.95v 644.745n 0.95v 644.755n 0.0v 649.745n 0.0v 649.755n 0.0v 654.745n 0.0v 654.755n 0.0v 659.745n 0.0v 659.755n 0.0v 664.745n 0.0v 664.755n 0.0v 669.745n 0.0v 669.755n 0.0v 674.745n 0.0v 674.755n 0.95v 679.745n 0.95v 679.755n 0.0v 684.745n 0.0v 684.755n 0.0v 689.745n 0.0v 689.755n 0.0v 694.745n 0.0v 694.755n 0.0v 699.745n 0.0v 699.755n 0.95v 704.745n 0.95v 704.755n 0.0v 709.745n 0.0v 709.755n 0.0v 714.745n 0.0v 714.755n 0.0v 719.745n 0.0v 719.755n 0.95v 724.745n 0.95v 724.755n 0.0v 729.745n 0.0v 729.755n 0.0v 734.745n 0.0v 734.755n 0.95v 739.745n 0.95v 739.755n 0.0v 744.745n 0.0v 744.755n 0.95v 749.745n 0.95v 749.755n 0.95v 754.745n 0.95v 754.755n 0.95v 759.745n 0.95v 759.755n 0.95v 764.745n 0.95v 764.755n 0.95v 769.745n 0.95v 769.755n 0.95v 774.745n 0.95v 774.755n 0.95v 779.745n 0.95v 779.755n 0.95v 784.745n 0.95v 784.755n 0.95v 789.745n 0.95v 789.755n 0.0v 794.745n 0.0v 794.755n 0.0v 799.745n 0.0v 799.755n 0.0v 804.745n 0.0v 804.755n 0.0v 809.745n 0.0v 809.755n 0.0v 814.745n 0.0v 814.755n 0.95v 819.745n 0.95v 819.755n 0.0v 824.745n 0.0v 824.755n 0.0v 829.745n 0.0v 829.755n 0.95v 834.745n 0.95v 834.755n 0.0v 839.745n 0.0v 839.755n 0.95v 844.745n 0.95v 844.755n 0.0v 849.745n 0.0v 849.755n 0.95v 854.745n 0.95v 854.755n 0.95v 859.745n 0.95v 859.755n 0.95v 864.745n 0.95v 864.755n 0.95v 869.745n 0.95v 869.755n 0.0v 874.745n 0.0v 874.755n 0.95v 879.745n 0.95v 879.755n 0.95v 884.745n 0.95v 884.755n 0.0v 889.745n 0.0v 889.755n 0.0v 894.745n 0.0v 894.755n 0.95v 899.745n 0.95v 899.755n 0.0v 904.745n 0.0v 904.755n 0.0v 909.745n 0.0v 909.755n 0.0v 914.745n 0.0v 914.755n 0.95v 919.745n 0.95v 919.755n 0.0v 924.745n 0.0v 924.755n 0.0v 929.745n 0.0v 929.755n 0.0v 934.745n 0.0v 934.755n 0.0v 939.745n 0.0v 939.755n 0.0v 944.745n 0.0v 944.755n 0.0v 949.745n 0.0v 949.755n 0.95v 954.745n 0.95v 954.755n 0.0v 959.745n 0.0v 959.755n 0.95v 964.745n 0.95v 964.755n 0.0v 969.745n 0.0v 969.755n 0.0v 974.745n 0.0v 974.755n 0.0v 979.745n 0.0v 979.755n 0.0v 984.745n 0.0v 984.755n 0.0v 989.745n 0.0v 989.755n 0.0v 994.745n 0.0v 994.755n 0.0v 999.745n 0.0v 999.755n 0.0v 1004.745n 0.0v 1004.755n 0.0v 1009.745n 0.0v 1009.755n 0.0v 1014.745n 0.0v 1014.755n 0.0v 1019.745n 0.0v 1019.755n 0.95v 1024.745n 0.95v 1024.755n 0.95v )
* (time, data): [(0, 0), (5, 1), (10, 0), (15, 0), (20, 0), (25, 1), (30, 1), (35, 1), (40, 1), (45, 1), (50, 1), (55, 1), (60, 0), (65, 1), (70, 1), (75, 1), (80, 1), (85, 1), (90, 1), (95, 0), (100, 0), (105, 0), (110, 0), (115, 0), (120, 0), (125, 0), (130, 0), (135, 1), (140, 1), (145, 1), (150, 1), (155, 0), (160, 1), (165, 1), (170, 1), (175, 0), (180, 0), (185, 1), (190, 1), (195, 1), (200, 1), (205, 0), (210, 1), (215, 1), (220, 1), (225, 1), (230, 1), (235, 1), (240, 1), (245, 0), (250, 0), (255, 0), (260, 0), (265, 0), (270, 1), (275, 1), (280, 1), (285, 1), (290, 1), (295, 1), (300, 1), (305, 0), (310, 1), (315, 1), (320, 1), (325, 1), (330, 1), (335, 1), (340, 1), (345, 1), (350, 0), (355, 0), (360, 1), (365, 0), (370, 0), (375, 1), (380, 0), (385, 0), (390, 1), (395, 0), (400, 0), (405, 0), (410, 0), (415, 0), (420, 1), (425, 1), (430, 0), (435, 0), (440, 0), (445, 1), (450, 0), (455, 0), (460, 0), (465, 1), (470, 1), (475, 1), (480, 1), (485, 0), (490, 0), (495, 1), (500, 0), (505, 0), (510, 0), (515, 0), (520, 1), (525, 1), (530, 1), (535, 1), (540, 1), (545, 0), (550, 0), (555, 0), (560, 0), (565, 0), (570, 0), (575, 1), (580, 0), (585, 0), (590, 0), (595, 0), (600, 1), (605, 0), (610, 0), (615, 0), (620, 0), (625, 0), (630, 1), (635, 0), (640, 1), (645, 0), (650, 0), (655, 0), (660, 0), (665, 0), (670, 0), (675, 1), (680, 0), (685, 0), (690, 0), (695, 0), (700, 1), (705, 0), (710, 0), (715, 0), (720, 1), (725, 0), (730, 0), (735, 1), (740, 0), (745, 1), (750, 1), (755, 1), (760, 1), (765, 1), (770, 1), (775, 1), (780, 1), (785, 1), (790, 0), (795, 0), (800, 0), (805, 0), (810, 0), (815, 1), (820, 0), (825, 0), (830, 1), (835, 0), (840, 1), (845, 0), (850, 1), (855, 1), (860, 1), (865, 1), (870, 0), (875, 1), (880, 1), (885, 0), (890, 0), (895, 1), (900, 0), (905, 0), (910, 0), (915, 1), (920, 0), (925, 0), (930, 0), (935, 0), (940, 0), (945, 0), (950, 1), (955, 0), (960, 1), (965, 0), (970, 0), (975, 0), (980, 0), (985, 0), (990, 0), (995, 0), (1000, 0), (1005, 0), (1010, 0), (1015, 0), (1020, 1), (1025, 1)]
Va0_5  a0_5  0 PWL (0n 0.0v 4.745n 0.0v 4.755n 0.95v 9.745n 0.95v 9.755n 0.0v 14.745n 0.0v 14.755n 0.0v 19.745n 0.0v 19.755n 0.0v 24.745n 0.0v 24.755n 0.95v 29.745n 0.95v 29.755n 0.95v 34.745n 0.95v 34.755n 0.95v 39.745n 0.95v 39.755n 0.95v 44.745n 0.95v 44.755n 0.95v 49.745n 0.95v 49.755n 0.95v 54.745n 0.95v 54.755n 0.95v 59.745n 0.95v 59.755n 0.0v 64.745n 0.0v 64.755n 0.95v 69.745n 0.95v 69.755n 0.95v 74.745n 0.95v 74.755n 0.95v 79.745n 0.95v 79.755n 0.95v 84.745n 0.95v 84.755n 0.95v 89.745n 0.95v 89.755n 0.95v 94.745n 0.95v 94.755n 0.0v 99.745n 0.0v 99.755n 0.0v 104.745n 0.0v 104.755n 0.0v 109.745n 0.0v 109.755n 0.0v 114.745n 0.0v 114.755n 0.0v 119.745n 0.0v 119.755n 0.0v 124.745n 0.0v 124.755n 0.0v 129.745n 0.0v 129.755n 0.0v 134.745n 0.0v 134.755n 0.95v 139.745n 0.95v 139.755n 0.95v 144.745n 0.95v 144.755n 0.95v 149.745n 0.95v 149.755n 0.95v 154.745n 0.95v 154.755n 0.0v 159.745n 0.0v 159.755n 0.95v 164.745n 0.95v 164.755n 0.95v 169.745n 0.95v 169.755n 0.95v 174.745n 0.95v 174.755n 0.0v 179.745n 0.0v 179.755n 0.0v 184.745n 0.0v 184.755n 0.95v 189.745n 0.95v 189.755n 0.95v 194.745n 0.95v 194.755n 0.95v 199.745n 0.95v 199.755n 0.95v 204.745n 0.95v 204.755n 0.0v 209.745n 0.0v 209.755n 0.95v 214.745n 0.95v 214.755n 0.95v 219.745n 0.95v 219.755n 0.95v 224.745n 0.95v 224.755n 0.95v 229.745n 0.95v 229.755n 0.95v 234.745n 0.95v 234.755n 0.95v 239.745n 0.95v 239.755n 0.95v 244.745n 0.95v 244.755n 0.0v 249.745n 0.0v 249.755n 0.0v 254.745n 0.0v 254.755n 0.0v 259.745n 0.0v 259.755n 0.0v 264.745n 0.0v 264.755n 0.0v 269.745n 0.0v 269.755n 0.95v 274.745n 0.95v 274.755n 0.95v 279.745n 0.95v 279.755n 0.95v 284.745n 0.95v 284.755n 0.95v 289.745n 0.95v 289.755n 0.95v 294.745n 0.95v 294.755n 0.95v 299.745n 0.95v 299.755n 0.95v 304.745n 0.95v 304.755n 0.0v 309.745n 0.0v 309.755n 0.95v 314.745n 0.95v 314.755n 0.95v 319.745n 0.95v 319.755n 0.95v 324.745n 0.95v 324.755n 0.95v 329.745n 0.95v 329.755n 0.95v 334.745n 0.95v 334.755n 0.95v 339.745n 0.95v 339.755n 0.95v 344.745n 0.95v 344.755n 0.95v 349.745n 0.95v 349.755n 0.0v 354.745n 0.0v 354.755n 0.0v 359.745n 0.0v 359.755n 0.95v 364.745n 0.95v 364.755n 0.0v 369.745n 0.0v 369.755n 0.0v 374.745n 0.0v 374.755n 0.95v 379.745n 0.95v 379.755n 0.0v 384.745n 0.0v 384.755n 0.0v 389.745n 0.0v 389.755n 0.95v 394.745n 0.95v 394.755n 0.0v 399.745n 0.0v 399.755n 0.0v 404.745n 0.0v 404.755n 0.0v 409.745n 0.0v 409.755n 0.0v 414.745n 0.0v 414.755n 0.0v 419.745n 0.0v 419.755n 0.95v 424.745n 0.95v 424.755n 0.95v 429.745n 0.95v 429.755n 0.0v 434.745n 0.0v 434.755n 0.0v 439.745n 0.0v 439.755n 0.0v 444.745n 0.0v 444.755n 0.95v 449.745n 0.95v 449.755n 0.0v 454.745n 0.0v 454.755n 0.0v 459.745n 0.0v 459.755n 0.0v 464.745n 0.0v 464.755n 0.95v 469.745n 0.95v 469.755n 0.95v 474.745n 0.95v 474.755n 0.95v 479.745n 0.95v 479.755n 0.95v 484.745n 0.95v 484.755n 0.0v 489.745n 0.0v 489.755n 0.0v 494.745n 0.0v 494.755n 0.95v 499.745n 0.95v 499.755n 0.0v 504.745n 0.0v 504.755n 0.0v 509.745n 0.0v 509.755n 0.0v 514.745n 0.0v 514.755n 0.0v 519.745n 0.0v 519.755n 0.95v 524.745n 0.95v 524.755n 0.95v 529.745n 0.95v 529.755n 0.95v 534.745n 0.95v 534.755n 0.95v 539.745n 0.95v 539.755n 0.95v 544.745n 0.95v 544.755n 0.0v 549.745n 0.0v 549.755n 0.0v 554.745n 0.0v 554.755n 0.0v 559.745n 0.0v 559.755n 0.0v 564.745n 0.0v 564.755n 0.0v 569.745n 0.0v 569.755n 0.0v 574.745n 0.0v 574.755n 0.95v 579.745n 0.95v 579.755n 0.0v 584.745n 0.0v 584.755n 0.0v 589.745n 0.0v 589.755n 0.0v 594.745n 0.0v 594.755n 0.0v 599.745n 0.0v 599.755n 0.95v 604.745n 0.95v 604.755n 0.0v 609.745n 0.0v 609.755n 0.0v 614.745n 0.0v 614.755n 0.0v 619.745n 0.0v 619.755n 0.0v 624.745n 0.0v 624.755n 0.0v 629.745n 0.0v 629.755n 0.95v 634.745n 0.95v 634.755n 0.0v 639.745n 0.0v 639.755n 0.95v 644.745n 0.95v 644.755n 0.0v 649.745n 0.0v 649.755n 0.0v 654.745n 0.0v 654.755n 0.0v 659.745n 0.0v 659.755n 0.0v 664.745n 0.0v 664.755n 0.0v 669.745n 0.0v 669.755n 0.0v 674.745n 0.0v 674.755n 0.95v 679.745n 0.95v 679.755n 0.0v 684.745n 0.0v 684.755n 0.0v 689.745n 0.0v 689.755n 0.0v 694.745n 0.0v 694.755n 0.0v 699.745n 0.0v 699.755n 0.95v 704.745n 0.95v 704.755n 0.0v 709.745n 0.0v 709.755n 0.0v 714.745n 0.0v 714.755n 0.0v 719.745n 0.0v 719.755n 0.95v 724.745n 0.95v 724.755n 0.0v 729.745n 0.0v 729.755n 0.0v 734.745n 0.0v 734.755n 0.95v 739.745n 0.95v 739.755n 0.0v 744.745n 0.0v 744.755n 0.95v 749.745n 0.95v 749.755n 0.95v 754.745n 0.95v 754.755n 0.95v 759.745n 0.95v 759.755n 0.95v 764.745n 0.95v 764.755n 0.95v 769.745n 0.95v 769.755n 0.95v 774.745n 0.95v 774.755n 0.95v 779.745n 0.95v 779.755n 0.95v 784.745n 0.95v 784.755n 0.95v 789.745n 0.95v 789.755n 0.0v 794.745n 0.0v 794.755n 0.0v 799.745n 0.0v 799.755n 0.0v 804.745n 0.0v 804.755n 0.0v 809.745n 0.0v 809.755n 0.0v 814.745n 0.0v 814.755n 0.95v 819.745n 0.95v 819.755n 0.0v 824.745n 0.0v 824.755n 0.0v 829.745n 0.0v 829.755n 0.95v 834.745n 0.95v 834.755n 0.0v 839.745n 0.0v 839.755n 0.95v 844.745n 0.95v 844.755n 0.0v 849.745n 0.0v 849.755n 0.95v 854.745n 0.95v 854.755n 0.95v 859.745n 0.95v 859.755n 0.95v 864.745n 0.95v 864.755n 0.95v 869.745n 0.95v 869.755n 0.0v 874.745n 0.0v 874.755n 0.95v 879.745n 0.95v 879.755n 0.95v 884.745n 0.95v 884.755n 0.0v 889.745n 0.0v 889.755n 0.0v 894.745n 0.0v 894.755n 0.95v 899.745n 0.95v 899.755n 0.0v 904.745n 0.0v 904.755n 0.0v 909.745n 0.0v 909.755n 0.0v 914.745n 0.0v 914.755n 0.95v 919.745n 0.95v 919.755n 0.0v 924.745n 0.0v 924.755n 0.0v 929.745n 0.0v 929.755n 0.0v 934.745n 0.0v 934.755n 0.0v 939.745n 0.0v 939.755n 0.0v 944.745n 0.0v 944.755n 0.0v 949.745n 0.0v 949.755n 0.95v 954.745n 0.95v 954.755n 0.0v 959.745n 0.0v 959.755n 0.95v 964.745n 0.95v 964.755n 0.0v 969.745n 0.0v 969.755n 0.0v 974.745n 0.0v 974.755n 0.0v 979.745n 0.0v 979.755n 0.0v 984.745n 0.0v 984.755n 0.0v 989.745n 0.0v 989.755n 0.0v 994.745n 0.0v 994.755n 0.0v 999.745n 0.0v 999.755n 0.0v 1004.745n 0.0v 1004.755n 0.0v 1009.745n 0.0v 1009.755n 0.0v 1014.745n 0.0v 1014.755n 0.0v 1019.745n 0.0v 1019.755n 0.95v 1024.745n 0.95v 1024.755n 0.95v )
* (time, data): [(0, 0), (5, 1), (10, 0), (15, 0), (20, 0), (25, 1), (30, 1), (35, 1), (40, 1), (45, 1), (50, 1), (55, 1), (60, 0), (65, 1), (70, 1), (75, 1), (80, 1), (85, 1), (90, 1), (95, 0), (100, 0), (105, 0), (110, 0), (115, 0), (120, 0), (125, 0), (130, 0), (135, 1), (140, 1), (145, 1), (150, 1), (155, 0), (160, 1), (165, 1), (170, 1), (175, 0), (180, 0), (185, 1), (190, 1), (195, 1), (200, 1), (205, 0), (210, 1), (215, 1), (220, 1), (225, 1), (230, 1), (235, 1), (240, 1), (245, 0), (250, 0), (255, 0), (260, 0), (265, 0), (270, 1), (275, 1), (280, 1), (285, 1), (290, 1), (295, 1), (300, 1), (305, 0), (310, 1), (315, 1), (320, 1), (325, 1), (330, 1), (335, 1), (340, 1), (345, 1), (350, 0), (355, 0), (360, 1), (365, 0), (370, 0), (375, 1), (380, 0), (385, 0), (390, 1), (395, 0), (400, 0), (405, 0), (410, 0), (415, 0), (420, 1), (425, 1), (430, 0), (435, 0), (440, 0), (445, 1), (450, 0), (455, 0), (460, 0), (465, 1), (470, 1), (475, 1), (480, 1), (485, 0), (490, 0), (495, 1), (500, 0), (505, 0), (510, 0), (515, 0), (520, 1), (525, 1), (530, 1), (535, 1), (540, 1), (545, 0), (550, 0), (555, 0), (560, 0), (565, 0), (570, 0), (575, 1), (580, 0), (585, 0), (590, 0), (595, 0), (600, 1), (605, 0), (610, 0), (615, 0), (620, 0), (625, 0), (630, 1), (635, 0), (640, 1), (645, 0), (650, 0), (655, 0), (660, 0), (665, 0), (670, 0), (675, 1), (680, 0), (685, 0), (690, 0), (695, 0), (700, 1), (705, 0), (710, 0), (715, 0), (720, 1), (725, 0), (730, 0), (735, 1), (740, 0), (745, 1), (750, 1), (755, 1), (760, 1), (765, 1), (770, 1), (775, 1), (780, 1), (785, 1), (790, 0), (795, 0), (800, 0), (805, 0), (810, 0), (815, 1), (820, 0), (825, 0), (830, 1), (835, 0), (840, 1), (845, 0), (850, 1), (855, 1), (860, 1), (865, 1), (870, 0), (875, 1), (880, 1), (885, 0), (890, 0), (895, 1), (900, 0), (905, 0), (910, 0), (915, 1), (920, 0), (925, 0), (930, 0), (935, 0), (940, 0), (945, 0), (950, 1), (955, 0), (960, 1), (965, 0), (970, 0), (975, 0), (980, 0), (985, 0), (990, 0), (995, 0), (1000, 0), (1005, 0), (1010, 0), (1015, 0), (1020, 1), (1025, 1)]
Va0_6  a0_6  0 PWL (0n 0.0v 4.745n 0.0v 4.755n 0.95v 9.745n 0.95v 9.755n 0.0v 14.745n 0.0v 14.755n 0.0v 19.745n 0.0v 19.755n 0.0v 24.745n 0.0v 24.755n 0.95v 29.745n 0.95v 29.755n 0.95v 34.745n 0.95v 34.755n 0.95v 39.745n 0.95v 39.755n 0.95v 44.745n 0.95v 44.755n 0.95v 49.745n 0.95v 49.755n 0.95v 54.745n 0.95v 54.755n 0.95v 59.745n 0.95v 59.755n 0.0v 64.745n 0.0v 64.755n 0.95v 69.745n 0.95v 69.755n 0.95v 74.745n 0.95v 74.755n 0.95v 79.745n 0.95v 79.755n 0.95v 84.745n 0.95v 84.755n 0.95v 89.745n 0.95v 89.755n 0.95v 94.745n 0.95v 94.755n 0.0v 99.745n 0.0v 99.755n 0.0v 104.745n 0.0v 104.755n 0.0v 109.745n 0.0v 109.755n 0.0v 114.745n 0.0v 114.755n 0.0v 119.745n 0.0v 119.755n 0.0v 124.745n 0.0v 124.755n 0.0v 129.745n 0.0v 129.755n 0.0v 134.745n 0.0v 134.755n 0.95v 139.745n 0.95v 139.755n 0.95v 144.745n 0.95v 144.755n 0.95v 149.745n 0.95v 149.755n 0.95v 154.745n 0.95v 154.755n 0.0v 159.745n 0.0v 159.755n 0.95v 164.745n 0.95v 164.755n 0.95v 169.745n 0.95v 169.755n 0.95v 174.745n 0.95v 174.755n 0.0v 179.745n 0.0v 179.755n 0.0v 184.745n 0.0v 184.755n 0.95v 189.745n 0.95v 189.755n 0.95v 194.745n 0.95v 194.755n 0.95v 199.745n 0.95v 199.755n 0.95v 204.745n 0.95v 204.755n 0.0v 209.745n 0.0v 209.755n 0.95v 214.745n 0.95v 214.755n 0.95v 219.745n 0.95v 219.755n 0.95v 224.745n 0.95v 224.755n 0.95v 229.745n 0.95v 229.755n 0.95v 234.745n 0.95v 234.755n 0.95v 239.745n 0.95v 239.755n 0.95v 244.745n 0.95v 244.755n 0.0v 249.745n 0.0v 249.755n 0.0v 254.745n 0.0v 254.755n 0.0v 259.745n 0.0v 259.755n 0.0v 264.745n 0.0v 264.755n 0.0v 269.745n 0.0v 269.755n 0.95v 274.745n 0.95v 274.755n 0.95v 279.745n 0.95v 279.755n 0.95v 284.745n 0.95v 284.755n 0.95v 289.745n 0.95v 289.755n 0.95v 294.745n 0.95v 294.755n 0.95v 299.745n 0.95v 299.755n 0.95v 304.745n 0.95v 304.755n 0.0v 309.745n 0.0v 309.755n 0.95v 314.745n 0.95v 314.755n 0.95v 319.745n 0.95v 319.755n 0.95v 324.745n 0.95v 324.755n 0.95v 329.745n 0.95v 329.755n 0.95v 334.745n 0.95v 334.755n 0.95v 339.745n 0.95v 339.755n 0.95v 344.745n 0.95v 344.755n 0.95v 349.745n 0.95v 349.755n 0.0v 354.745n 0.0v 354.755n 0.0v 359.745n 0.0v 359.755n 0.95v 364.745n 0.95v 364.755n 0.0v 369.745n 0.0v 369.755n 0.0v 374.745n 0.0v 374.755n 0.95v 379.745n 0.95v 379.755n 0.0v 384.745n 0.0v 384.755n 0.0v 389.745n 0.0v 389.755n 0.95v 394.745n 0.95v 394.755n 0.0v 399.745n 0.0v 399.755n 0.0v 404.745n 0.0v 404.755n 0.0v 409.745n 0.0v 409.755n 0.0v 414.745n 0.0v 414.755n 0.0v 419.745n 0.0v 419.755n 0.95v 424.745n 0.95v 424.755n 0.95v 429.745n 0.95v 429.755n 0.0v 434.745n 0.0v 434.755n 0.0v 439.745n 0.0v 439.755n 0.0v 444.745n 0.0v 444.755n 0.95v 449.745n 0.95v 449.755n 0.0v 454.745n 0.0v 454.755n 0.0v 459.745n 0.0v 459.755n 0.0v 464.745n 0.0v 464.755n 0.95v 469.745n 0.95v 469.755n 0.95v 474.745n 0.95v 474.755n 0.95v 479.745n 0.95v 479.755n 0.95v 484.745n 0.95v 484.755n 0.0v 489.745n 0.0v 489.755n 0.0v 494.745n 0.0v 494.755n 0.95v 499.745n 0.95v 499.755n 0.0v 504.745n 0.0v 504.755n 0.0v 509.745n 0.0v 509.755n 0.0v 514.745n 0.0v 514.755n 0.0v 519.745n 0.0v 519.755n 0.95v 524.745n 0.95v 524.755n 0.95v 529.745n 0.95v 529.755n 0.95v 534.745n 0.95v 534.755n 0.95v 539.745n 0.95v 539.755n 0.95v 544.745n 0.95v 544.755n 0.0v 549.745n 0.0v 549.755n 0.0v 554.745n 0.0v 554.755n 0.0v 559.745n 0.0v 559.755n 0.0v 564.745n 0.0v 564.755n 0.0v 569.745n 0.0v 569.755n 0.0v 574.745n 0.0v 574.755n 0.95v 579.745n 0.95v 579.755n 0.0v 584.745n 0.0v 584.755n 0.0v 589.745n 0.0v 589.755n 0.0v 594.745n 0.0v 594.755n 0.0v 599.745n 0.0v 599.755n 0.95v 604.745n 0.95v 604.755n 0.0v 609.745n 0.0v 609.755n 0.0v 614.745n 0.0v 614.755n 0.0v 619.745n 0.0v 619.755n 0.0v 624.745n 0.0v 624.755n 0.0v 629.745n 0.0v 629.755n 0.95v 634.745n 0.95v 634.755n 0.0v 639.745n 0.0v 639.755n 0.95v 644.745n 0.95v 644.755n 0.0v 649.745n 0.0v 649.755n 0.0v 654.745n 0.0v 654.755n 0.0v 659.745n 0.0v 659.755n 0.0v 664.745n 0.0v 664.755n 0.0v 669.745n 0.0v 669.755n 0.0v 674.745n 0.0v 674.755n 0.95v 679.745n 0.95v 679.755n 0.0v 684.745n 0.0v 684.755n 0.0v 689.745n 0.0v 689.755n 0.0v 694.745n 0.0v 694.755n 0.0v 699.745n 0.0v 699.755n 0.95v 704.745n 0.95v 704.755n 0.0v 709.745n 0.0v 709.755n 0.0v 714.745n 0.0v 714.755n 0.0v 719.745n 0.0v 719.755n 0.95v 724.745n 0.95v 724.755n 0.0v 729.745n 0.0v 729.755n 0.0v 734.745n 0.0v 734.755n 0.95v 739.745n 0.95v 739.755n 0.0v 744.745n 0.0v 744.755n 0.95v 749.745n 0.95v 749.755n 0.95v 754.745n 0.95v 754.755n 0.95v 759.745n 0.95v 759.755n 0.95v 764.745n 0.95v 764.755n 0.95v 769.745n 0.95v 769.755n 0.95v 774.745n 0.95v 774.755n 0.95v 779.745n 0.95v 779.755n 0.95v 784.745n 0.95v 784.755n 0.95v 789.745n 0.95v 789.755n 0.0v 794.745n 0.0v 794.755n 0.0v 799.745n 0.0v 799.755n 0.0v 804.745n 0.0v 804.755n 0.0v 809.745n 0.0v 809.755n 0.0v 814.745n 0.0v 814.755n 0.95v 819.745n 0.95v 819.755n 0.0v 824.745n 0.0v 824.755n 0.0v 829.745n 0.0v 829.755n 0.95v 834.745n 0.95v 834.755n 0.0v 839.745n 0.0v 839.755n 0.95v 844.745n 0.95v 844.755n 0.0v 849.745n 0.0v 849.755n 0.95v 854.745n 0.95v 854.755n 0.95v 859.745n 0.95v 859.755n 0.95v 864.745n 0.95v 864.755n 0.95v 869.745n 0.95v 869.755n 0.0v 874.745n 0.0v 874.755n 0.95v 879.745n 0.95v 879.755n 0.95v 884.745n 0.95v 884.755n 0.0v 889.745n 0.0v 889.755n 0.0v 894.745n 0.0v 894.755n 0.95v 899.745n 0.95v 899.755n 0.0v 904.745n 0.0v 904.755n 0.0v 909.745n 0.0v 909.755n 0.0v 914.745n 0.0v 914.755n 0.95v 919.745n 0.95v 919.755n 0.0v 924.745n 0.0v 924.755n 0.0v 929.745n 0.0v 929.755n 0.0v 934.745n 0.0v 934.755n 0.0v 939.745n 0.0v 939.755n 0.0v 944.745n 0.0v 944.755n 0.0v 949.745n 0.0v 949.755n 0.95v 954.745n 0.95v 954.755n 0.0v 959.745n 0.0v 959.755n 0.95v 964.745n 0.95v 964.755n 0.0v 969.745n 0.0v 969.755n 0.0v 974.745n 0.0v 974.755n 0.0v 979.745n 0.0v 979.755n 0.0v 984.745n 0.0v 984.755n 0.0v 989.745n 0.0v 989.755n 0.0v 994.745n 0.0v 994.755n 0.0v 999.745n 0.0v 999.755n 0.0v 1004.745n 0.0v 1004.755n 0.0v 1009.745n 0.0v 1009.755n 0.0v 1014.745n 0.0v 1014.755n 0.0v 1019.745n 0.0v 1019.755n 0.95v 1024.745n 0.95v 1024.755n 0.95v )

 * Generation of control signals
* (time, data): [(0, 1), (5, 0), (10, 0), (15, 0), (20, 0), (25, 0), (30, 0), (35, 0), (40, 0), (45, 0), (50, 1), (55, 1), (60, 0), (65, 0), (70, 0), (75, 0), (80, 0), (85, 1), (90, 0), (95, 0), (100, 1), (105, 1), (110, 1), (115, 0), (120, 1), (125, 0), (130, 1), (135, 0), (140, 0), (145, 0), (150, 0), (155, 0), (160, 0), (165, 0), (170, 0), (175, 0), (180, 1), (185, 0), (190, 0), (195, 0), (200, 0), (205, 0), (210, 0), (215, 0), (220, 0), (225, 0), (230, 0), (235, 1), (240, 1), (245, 0), (250, 1), (255, 1), (260, 0), (265, 1), (270, 0), (275, 0), (280, 1), (285, 1), (290, 1), (295, 0), (300, 0), (305, 0), (310, 0), (315, 0), (320, 0), (325, 0), (330, 1), (335, 0), (340, 0), (345, 0), (350, 0), (355, 0), (360, 0), (365, 0), (370, 1), (375, 0), (380, 0), (385, 0), (390, 0), (395, 0), (400, 0), (405, 0), (410, 1), (415, 0), (420, 0), (425, 0), (430, 0), (435, 1), (440, 0), (445, 0), (450, 0), (455, 0), (460, 1), (465, 0), (470, 0), (475, 0), (480, 1), (485, 0), (490, 0), (495, 0), (500, 0), (505, 0), (510, 0), (515, 0), (520, 0), (525, 0), (530, 0), (535, 0), (540, 1), (545, 0), (550, 0), (555, 0), (560, 0), (565, 0), (570, 0), (575, 0), (580, 0), (585, 0), (590, 1), (595, 1), (600, 0), (605, 0), (610, 0), (615, 0), (620, 0), (625, 1), (630, 0), (635, 0), (640, 0), (645, 0), (650, 1), (655, 0), (660, 0), (665, 0), (670, 0), (675, 0), (680, 0), (685, 1), (690, 1), (695, 1), (700, 0), (705, 0), (710, 1), (715, 0), (720, 0), (725, 0), (730, 1), (735, 0), (740, 0), (745, 0), (750, 0), (755, 0), (760, 0), (765, 1), (770, 0), (775, 0), (780, 0), (785, 0), (790, 0), (795, 0), (800, 1), (805, 1), (810, 0), (815, 0), (820, 0), (825, 0), (830, 0), (835, 0), (840, 0), (845, 0), (850, 0), (855, 1), (860, 0), (865, 0), (870, 0), (875, 0), (880, 0), (885, 0), (890, 0), (895, 0), (900, 0), (905, 0), (910, 0), (915, 0), (920, 0), (925, 1), (930, 1), (935, 0), (940, 0), (945, 0), (950, 0), (955, 0), (960, 0), (965, 0), (970, 0), (975, 1), (980, 1), (985, 1), (990, 1), (995, 1), (1000, 0), (1005, 1), (1010, 0), (1015, 0), (1020, 0), (1025, 1)]
VCSB0 CSB0 0 PWL (0n 0.95v 4.745n 0.95v 4.755n 0.0v 9.745n 0.0v 9.755n 0.0v 14.745n 0.0v 14.755n 0.0v 19.745n 0.0v 19.755n 0.0v 24.745n 0.0v 24.755n 0.0v 29.745n 0.0v 29.755n 0.0v 34.745n 0.0v 34.755n 0.0v 39.745n 0.0v 39.755n 0.0v 44.745n 0.0v 44.755n 0.0v 49.745n 0.0v 49.755n 0.95v 54.745n 0.95v 54.755n 0.95v 59.745n 0.95v 59.755n 0.0v 64.745n 0.0v 64.755n 0.0v 69.745n 0.0v 69.755n 0.0v 74.745n 0.0v 74.755n 0.0v 79.745n 0.0v 79.755n 0.0v 84.745n 0.0v 84.755n 0.95v 89.745n 0.95v 89.755n 0.0v 94.745n 0.0v 94.755n 0.0v 99.745n 0.0v 99.755n 0.95v 104.745n 0.95v 104.755n 0.95v 109.745n 0.95v 109.755n 0.95v 114.745n 0.95v 114.755n 0.0v 119.745n 0.0v 119.755n 0.95v 124.745n 0.95v 124.755n 0.0v 129.745n 0.0v 129.755n 0.95v 134.745n 0.95v 134.755n 0.0v 139.745n 0.0v 139.755n 0.0v 144.745n 0.0v 144.755n 0.0v 149.745n 0.0v 149.755n 0.0v 154.745n 0.0v 154.755n 0.0v 159.745n 0.0v 159.755n 0.0v 164.745n 0.0v 164.755n 0.0v 169.745n 0.0v 169.755n 0.0v 174.745n 0.0v 174.755n 0.0v 179.745n 0.0v 179.755n 0.95v 184.745n 0.95v 184.755n 0.0v 189.745n 0.0v 189.755n 0.0v 194.745n 0.0v 194.755n 0.0v 199.745n 0.0v 199.755n 0.0v 204.745n 0.0v 204.755n 0.0v 209.745n 0.0v 209.755n 0.0v 214.745n 0.0v 214.755n 0.0v 219.745n 0.0v 219.755n 0.0v 224.745n 0.0v 224.755n 0.0v 229.745n 0.0v 229.755n 0.0v 234.745n 0.0v 234.755n 0.95v 239.745n 0.95v 239.755n 0.95v 244.745n 0.95v 244.755n 0.0v 249.745n 0.0v 249.755n 0.95v 254.745n 0.95v 254.755n 0.95v 259.745n 0.95v 259.755n 0.0v 264.745n 0.0v 264.755n 0.95v 269.745n 0.95v 269.755n 0.0v 274.745n 0.0v 274.755n 0.0v 279.745n 0.0v 279.755n 0.95v 284.745n 0.95v 284.755n 0.95v 289.745n 0.95v 289.755n 0.95v 294.745n 0.95v 294.755n 0.0v 299.745n 0.0v 299.755n 0.0v 304.745n 0.0v 304.755n 0.0v 309.745n 0.0v 309.755n 0.0v 314.745n 0.0v 314.755n 0.0v 319.745n 0.0v 319.755n 0.0v 324.745n 0.0v 324.755n 0.0v 329.745n 0.0v 329.755n 0.95v 334.745n 0.95v 334.755n 0.0v 339.745n 0.0v 339.755n 0.0v 344.745n 0.0v 344.755n 0.0v 349.745n 0.0v 349.755n 0.0v 354.745n 0.0v 354.755n 0.0v 359.745n 0.0v 359.755n 0.0v 364.745n 0.0v 364.755n 0.0v 369.745n 0.0v 369.755n 0.95v 374.745n 0.95v 374.755n 0.0v 379.745n 0.0v 379.755n 0.0v 384.745n 0.0v 384.755n 0.0v 389.745n 0.0v 389.755n 0.0v 394.745n 0.0v 394.755n 0.0v 399.745n 0.0v 399.755n 0.0v 404.745n 0.0v 404.755n 0.0v 409.745n 0.0v 409.755n 0.95v 414.745n 0.95v 414.755n 0.0v 419.745n 0.0v 419.755n 0.0v 424.745n 0.0v 424.755n 0.0v 429.745n 0.0v 429.755n 0.0v 434.745n 0.0v 434.755n 0.95v 439.745n 0.95v 439.755n 0.0v 444.745n 0.0v 444.755n 0.0v 449.745n 0.0v 449.755n 0.0v 454.745n 0.0v 454.755n 0.0v 459.745n 0.0v 459.755n 0.95v 464.745n 0.95v 464.755n 0.0v 469.745n 0.0v 469.755n 0.0v 474.745n 0.0v 474.755n 0.0v 479.745n 0.0v 479.755n 0.95v 484.745n 0.95v 484.755n 0.0v 489.745n 0.0v 489.755n 0.0v 494.745n 0.0v 494.755n 0.0v 499.745n 0.0v 499.755n 0.0v 504.745n 0.0v 504.755n 0.0v 509.745n 0.0v 509.755n 0.0v 514.745n 0.0v 514.755n 0.0v 519.745n 0.0v 519.755n 0.0v 524.745n 0.0v 524.755n 0.0v 529.745n 0.0v 529.755n 0.0v 534.745n 0.0v 534.755n 0.0v 539.745n 0.0v 539.755n 0.95v 544.745n 0.95v 544.755n 0.0v 549.745n 0.0v 549.755n 0.0v 554.745n 0.0v 554.755n 0.0v 559.745n 0.0v 559.755n 0.0v 564.745n 0.0v 564.755n 0.0v 569.745n 0.0v 569.755n 0.0v 574.745n 0.0v 574.755n 0.0v 579.745n 0.0v 579.755n 0.0v 584.745n 0.0v 584.755n 0.0v 589.745n 0.0v 589.755n 0.95v 594.745n 0.95v 594.755n 0.95v 599.745n 0.95v 599.755n 0.0v 604.745n 0.0v 604.755n 0.0v 609.745n 0.0v 609.755n 0.0v 614.745n 0.0v 614.755n 0.0v 619.745n 0.0v 619.755n 0.0v 624.745n 0.0v 624.755n 0.95v 629.745n 0.95v 629.755n 0.0v 634.745n 0.0v 634.755n 0.0v 639.745n 0.0v 639.755n 0.0v 644.745n 0.0v 644.755n 0.0v 649.745n 0.0v 649.755n 0.95v 654.745n 0.95v 654.755n 0.0v 659.745n 0.0v 659.755n 0.0v 664.745n 0.0v 664.755n 0.0v 669.745n 0.0v 669.755n 0.0v 674.745n 0.0v 674.755n 0.0v 679.745n 0.0v 679.755n 0.0v 684.745n 0.0v 684.755n 0.95v 689.745n 0.95v 689.755n 0.95v 694.745n 0.95v 694.755n 0.95v 699.745n 0.95v 699.755n 0.0v 704.745n 0.0v 704.755n 0.0v 709.745n 0.0v 709.755n 0.95v 714.745n 0.95v 714.755n 0.0v 719.745n 0.0v 719.755n 0.0v 724.745n 0.0v 724.755n 0.0v 729.745n 0.0v 729.755n 0.95v 734.745n 0.95v 734.755n 0.0v 739.745n 0.0v 739.755n 0.0v 744.745n 0.0v 744.755n 0.0v 749.745n 0.0v 749.755n 0.0v 754.745n 0.0v 754.755n 0.0v 759.745n 0.0v 759.755n 0.0v 764.745n 0.0v 764.755n 0.95v 769.745n 0.95v 769.755n 0.0v 774.745n 0.0v 774.755n 0.0v 779.745n 0.0v 779.755n 0.0v 784.745n 0.0v 784.755n 0.0v 789.745n 0.0v 789.755n 0.0v 794.745n 0.0v 794.755n 0.0v 799.745n 0.0v 799.755n 0.95v 804.745n 0.95v 804.755n 0.95v 809.745n 0.95v 809.755n 0.0v 814.745n 0.0v 814.755n 0.0v 819.745n 0.0v 819.755n 0.0v 824.745n 0.0v 824.755n 0.0v 829.745n 0.0v 829.755n 0.0v 834.745n 0.0v 834.755n 0.0v 839.745n 0.0v 839.755n 0.0v 844.745n 0.0v 844.755n 0.0v 849.745n 0.0v 849.755n 0.0v 854.745n 0.0v 854.755n 0.95v 859.745n 0.95v 859.755n 0.0v 864.745n 0.0v 864.755n 0.0v 869.745n 0.0v 869.755n 0.0v 874.745n 0.0v 874.755n 0.0v 879.745n 0.0v 879.755n 0.0v 884.745n 0.0v 884.755n 0.0v 889.745n 0.0v 889.755n 0.0v 894.745n 0.0v 894.755n 0.0v 899.745n 0.0v 899.755n 0.0v 904.745n 0.0v 904.755n 0.0v 909.745n 0.0v 909.755n 0.0v 914.745n 0.0v 914.755n 0.0v 919.745n 0.0v 919.755n 0.0v 924.745n 0.0v 924.755n 0.95v 929.745n 0.95v 929.755n 0.95v 934.745n 0.95v 934.755n 0.0v 939.745n 0.0v 939.755n 0.0v 944.745n 0.0v 944.755n 0.0v 949.745n 0.0v 949.755n 0.0v 954.745n 0.0v 954.755n 0.0v 959.745n 0.0v 959.755n 0.0v 964.745n 0.0v 964.755n 0.0v 969.745n 0.0v 969.755n 0.0v 974.745n 0.0v 974.755n 0.95v 979.745n 0.95v 979.755n 0.95v 984.745n 0.95v 984.755n 0.95v 989.745n 0.95v 989.755n 0.95v 994.745n 0.95v 994.755n 0.95v 999.745n 0.95v 999.755n 0.0v 1004.745n 0.0v 1004.755n 0.95v 1009.745n 0.95v 1009.755n 0.0v 1014.745n 0.0v 1014.755n 0.0v 1019.745n 0.0v 1019.755n 0.0v 1024.745n 0.0v 1024.755n 0.95v )
* (time, data): [(0, 1), (5, 0), (10, 0), (15, 0), (20, 1), (25, 0), (30, 0), (35, 1), (40, 0), (45, 0), (50, 1), (55, 1), (60, 0), (65, 0), (70, 1), (75, 0), (80, 1), (85, 1), (90, 1), (95, 0), (100, 1), (105, 1), (110, 1), (115, 1), (120, 1), (125, 1), (130, 1), (135, 0), (140, 0), (145, 0), (150, 0), (155, 1), (160, 1), (165, 0), (170, 1), (175, 1), (180, 1), (185, 0), (190, 1), (195, 1), (200, 1), (205, 1), (210, 0), (215, 1), (220, 0), (225, 0), (230, 0), (235, 1), (240, 1), (245, 0), (250, 1), (255, 1), (260, 1), (265, 1), (270, 0), (275, 1), (280, 1), (285, 1), (290, 1), (295, 1), (300, 1), (305, 0), (310, 1), (315, 1), (320, 0), (325, 1), (330, 1), (335, 1), (340, 1), (345, 1), (350, 1), (355, 1), (360, 1), (365, 0), (370, 1), (375, 0), (380, 0), (385, 1), (390, 1), (395, 1), (400, 0), (405, 1), (410, 1), (415, 1), (420, 0), (425, 1), (430, 1), (435, 1), (440, 0), (445, 0), (450, 0), (455, 1), (460, 1), (465, 0), (470, 1), (475, 1), (480, 1), (485, 1), (490, 1), (495, 1), (500, 1), (505, 0), (510, 0), (515, 0), (520, 1), (525, 1), (530, 1), (535, 0), (540, 1), (545, 1), (550, 0), (555, 1), (560, 0), (565, 0), (570, 1), (575, 0), (580, 0), (585, 1), (590, 1), (595, 1), (600, 1), (605, 0), (610, 1), (615, 0), (620, 1), (625, 1), (630, 0), (635, 0), (640, 0), (645, 1), (650, 1), (655, 0), (660, 1), (665, 1), (670, 0), (675, 0), (680, 1), (685, 1), (690, 1), (695, 1), (700, 0), (705, 0), (710, 1), (715, 1), (720, 1), (725, 1), (730, 1), (735, 0), (740, 1), (745, 0), (750, 1), (755, 1), (760, 1), (765, 1), (770, 0), (775, 1), (780, 1), (785, 1), (790, 1), (795, 1), (800, 1), (805, 1), (810, 0), (815, 0), (820, 1), (825, 1), (830, 1), (835, 1), (840, 1), (845, 1), (850, 1), (855, 1), (860, 1), (865, 1), (870, 0), (875, 1), (880, 0), (885, 0), (890, 0), (895, 0), (900, 0), (905, 1), (910, 1), (915, 0), (920, 1), (925, 1), (930, 1), (935, 1), (940, 0), (945, 1), (950, 1), (955, 0), (960, 1), (965, 0), (970, 1), (975, 1), (980, 1), (985, 1), (990, 1), (995, 1), (1000, 1), (1005, 1), (1010, 0), (1015, 1), (1020, 1), (1025, 1)]
VWEB0 WEB0 0 PWL (0n 0.95v 4.745n 0.95v 4.755n 0.0v 9.745n 0.0v 9.755n 0.0v 14.745n 0.0v 14.755n 0.0v 19.745n 0.0v 19.755n 0.95v 24.745n 0.95v 24.755n 0.0v 29.745n 0.0v 29.755n 0.0v 34.745n 0.0v 34.755n 0.95v 39.745n 0.95v 39.755n 0.0v 44.745n 0.0v 44.755n 0.0v 49.745n 0.0v 49.755n 0.95v 54.745n 0.95v 54.755n 0.95v 59.745n 0.95v 59.755n 0.0v 64.745n 0.0v 64.755n 0.0v 69.745n 0.0v 69.755n 0.95v 74.745n 0.95v 74.755n 0.0v 79.745n 0.0v 79.755n 0.95v 84.745n 0.95v 84.755n 0.95v 89.745n 0.95v 89.755n 0.95v 94.745n 0.95v 94.755n 0.0v 99.745n 0.0v 99.755n 0.95v 104.745n 0.95v 104.755n 0.95v 109.745n 0.95v 109.755n 0.95v 114.745n 0.95v 114.755n 0.95v 119.745n 0.95v 119.755n 0.95v 124.745n 0.95v 124.755n 0.95v 129.745n 0.95v 129.755n 0.95v 134.745n 0.95v 134.755n 0.0v 139.745n 0.0v 139.755n 0.0v 144.745n 0.0v 144.755n 0.0v 149.745n 0.0v 149.755n 0.0v 154.745n 0.0v 154.755n 0.95v 159.745n 0.95v 159.755n 0.95v 164.745n 0.95v 164.755n 0.0v 169.745n 0.0v 169.755n 0.95v 174.745n 0.95v 174.755n 0.95v 179.745n 0.95v 179.755n 0.95v 184.745n 0.95v 184.755n 0.0v 189.745n 0.0v 189.755n 0.95v 194.745n 0.95v 194.755n 0.95v 199.745n 0.95v 199.755n 0.95v 204.745n 0.95v 204.755n 0.95v 209.745n 0.95v 209.755n 0.0v 214.745n 0.0v 214.755n 0.95v 219.745n 0.95v 219.755n 0.0v 224.745n 0.0v 224.755n 0.0v 229.745n 0.0v 229.755n 0.0v 234.745n 0.0v 234.755n 0.95v 239.745n 0.95v 239.755n 0.95v 244.745n 0.95v 244.755n 0.0v 249.745n 0.0v 249.755n 0.95v 254.745n 0.95v 254.755n 0.95v 259.745n 0.95v 259.755n 0.95v 264.745n 0.95v 264.755n 0.95v 269.745n 0.95v 269.755n 0.0v 274.745n 0.0v 274.755n 0.95v 279.745n 0.95v 279.755n 0.95v 284.745n 0.95v 284.755n 0.95v 289.745n 0.95v 289.755n 0.95v 294.745n 0.95v 294.755n 0.95v 299.745n 0.95v 299.755n 0.95v 304.745n 0.95v 304.755n 0.0v 309.745n 0.0v 309.755n 0.95v 314.745n 0.95v 314.755n 0.95v 319.745n 0.95v 319.755n 0.0v 324.745n 0.0v 324.755n 0.95v 329.745n 0.95v 329.755n 0.95v 334.745n 0.95v 334.755n 0.95v 339.745n 0.95v 339.755n 0.95v 344.745n 0.95v 344.755n 0.95v 349.745n 0.95v 349.755n 0.95v 354.745n 0.95v 354.755n 0.95v 359.745n 0.95v 359.755n 0.95v 364.745n 0.95v 364.755n 0.0v 369.745n 0.0v 369.755n 0.95v 374.745n 0.95v 374.755n 0.0v 379.745n 0.0v 379.755n 0.0v 384.745n 0.0v 384.755n 0.95v 389.745n 0.95v 389.755n 0.95v 394.745n 0.95v 394.755n 0.95v 399.745n 0.95v 399.755n 0.0v 404.745n 0.0v 404.755n 0.95v 409.745n 0.95v 409.755n 0.95v 414.745n 0.95v 414.755n 0.95v 419.745n 0.95v 419.755n 0.0v 424.745n 0.0v 424.755n 0.95v 429.745n 0.95v 429.755n 0.95v 434.745n 0.95v 434.755n 0.95v 439.745n 0.95v 439.755n 0.0v 444.745n 0.0v 444.755n 0.0v 449.745n 0.0v 449.755n 0.0v 454.745n 0.0v 454.755n 0.95v 459.745n 0.95v 459.755n 0.95v 464.745n 0.95v 464.755n 0.0v 469.745n 0.0v 469.755n 0.95v 474.745n 0.95v 474.755n 0.95v 479.745n 0.95v 479.755n 0.95v 484.745n 0.95v 484.755n 0.95v 489.745n 0.95v 489.755n 0.95v 494.745n 0.95v 494.755n 0.95v 499.745n 0.95v 499.755n 0.95v 504.745n 0.95v 504.755n 0.0v 509.745n 0.0v 509.755n 0.0v 514.745n 0.0v 514.755n 0.0v 519.745n 0.0v 519.755n 0.95v 524.745n 0.95v 524.755n 0.95v 529.745n 0.95v 529.755n 0.95v 534.745n 0.95v 534.755n 0.0v 539.745n 0.0v 539.755n 0.95v 544.745n 0.95v 544.755n 0.95v 549.745n 0.95v 549.755n 0.0v 554.745n 0.0v 554.755n 0.95v 559.745n 0.95v 559.755n 0.0v 564.745n 0.0v 564.755n 0.0v 569.745n 0.0v 569.755n 0.95v 574.745n 0.95v 574.755n 0.0v 579.745n 0.0v 579.755n 0.0v 584.745n 0.0v 584.755n 0.95v 589.745n 0.95v 589.755n 0.95v 594.745n 0.95v 594.755n 0.95v 599.745n 0.95v 599.755n 0.95v 604.745n 0.95v 604.755n 0.0v 609.745n 0.0v 609.755n 0.95v 614.745n 0.95v 614.755n 0.0v 619.745n 0.0v 619.755n 0.95v 624.745n 0.95v 624.755n 0.95v 629.745n 0.95v 629.755n 0.0v 634.745n 0.0v 634.755n 0.0v 639.745n 0.0v 639.755n 0.0v 644.745n 0.0v 644.755n 0.95v 649.745n 0.95v 649.755n 0.95v 654.745n 0.95v 654.755n 0.0v 659.745n 0.0v 659.755n 0.95v 664.745n 0.95v 664.755n 0.95v 669.745n 0.95v 669.755n 0.0v 674.745n 0.0v 674.755n 0.0v 679.745n 0.0v 679.755n 0.95v 684.745n 0.95v 684.755n 0.95v 689.745n 0.95v 689.755n 0.95v 694.745n 0.95v 694.755n 0.95v 699.745n 0.95v 699.755n 0.0v 704.745n 0.0v 704.755n 0.0v 709.745n 0.0v 709.755n 0.95v 714.745n 0.95v 714.755n 0.95v 719.745n 0.95v 719.755n 0.95v 724.745n 0.95v 724.755n 0.95v 729.745n 0.95v 729.755n 0.95v 734.745n 0.95v 734.755n 0.0v 739.745n 0.0v 739.755n 0.95v 744.745n 0.95v 744.755n 0.0v 749.745n 0.0v 749.755n 0.95v 754.745n 0.95v 754.755n 0.95v 759.745n 0.95v 759.755n 0.95v 764.745n 0.95v 764.755n 0.95v 769.745n 0.95v 769.755n 0.0v 774.745n 0.0v 774.755n 0.95v 779.745n 0.95v 779.755n 0.95v 784.745n 0.95v 784.755n 0.95v 789.745n 0.95v 789.755n 0.95v 794.745n 0.95v 794.755n 0.95v 799.745n 0.95v 799.755n 0.95v 804.745n 0.95v 804.755n 0.95v 809.745n 0.95v 809.755n 0.0v 814.745n 0.0v 814.755n 0.0v 819.745n 0.0v 819.755n 0.95v 824.745n 0.95v 824.755n 0.95v 829.745n 0.95v 829.755n 0.95v 834.745n 0.95v 834.755n 0.95v 839.745n 0.95v 839.755n 0.95v 844.745n 0.95v 844.755n 0.95v 849.745n 0.95v 849.755n 0.95v 854.745n 0.95v 854.755n 0.95v 859.745n 0.95v 859.755n 0.95v 864.745n 0.95v 864.755n 0.95v 869.745n 0.95v 869.755n 0.0v 874.745n 0.0v 874.755n 0.95v 879.745n 0.95v 879.755n 0.0v 884.745n 0.0v 884.755n 0.0v 889.745n 0.0v 889.755n 0.0v 894.745n 0.0v 894.755n 0.0v 899.745n 0.0v 899.755n 0.0v 904.745n 0.0v 904.755n 0.95v 909.745n 0.95v 909.755n 0.95v 914.745n 0.95v 914.755n 0.0v 919.745n 0.0v 919.755n 0.95v 924.745n 0.95v 924.755n 0.95v 929.745n 0.95v 929.755n 0.95v 934.745n 0.95v 934.755n 0.95v 939.745n 0.95v 939.755n 0.0v 944.745n 0.0v 944.755n 0.95v 949.745n 0.95v 949.755n 0.95v 954.745n 0.95v 954.755n 0.0v 959.745n 0.0v 959.755n 0.95v 964.745n 0.95v 964.755n 0.0v 969.745n 0.0v 969.755n 0.95v 974.745n 0.95v 974.755n 0.95v 979.745n 0.95v 979.755n 0.95v 984.745n 0.95v 984.755n 0.95v 989.745n 0.95v 989.755n 0.95v 994.745n 0.95v 994.755n 0.95v 999.745n 0.95v 999.755n 0.95v 1004.745n 0.95v 1004.755n 0.95v 1009.745n 0.95v 1009.755n 0.0v 1014.745n 0.0v 1014.755n 0.95v 1019.745n 0.95v 1019.755n 0.95v 1024.745n 0.95v 1024.755n 0.95v )
* PULSE: period=5
Vclk0 clk0 0 PULSE (0 0.95 4.995n 0.01n 0.01n 2.49n 5n)

 * Generation of dout measurements
* CHECK dout0_0 vdout0_0ck4 = 0 time = 25
* CHECK dout0_1 vdout0_1ck4 = 0 time = 25
* CHECK dout0_2 vdout0_2ck4 = 0 time = 25
* CHECK dout0_3 vdout0_3ck4 = 0.95 time = 25
* CHECK dout0_4 vdout0_4ck4 = 0 time = 25
* CHECK dout0_5 vdout0_5ck4 = 0.95 time = 25
* CHECK dout0_6 vdout0_6ck4 = 0.95 time = 25
* CHECK dout0_7 vdout0_7ck4 = 0.95 time = 25
* CHECK dout0_8 vdout0_8ck4 = 0 time = 25
* CHECK dout0_9 vdout0_9ck4 = 0.95 time = 25
* CHECK dout0_10 vdout0_10ck4 = 0 time = 25
* CHECK dout0_11 vdout0_11ck4 = 0 time = 25
* CHECK dout0_12 vdout0_12ck4 = 0.95 time = 25
* CHECK dout0_13 vdout0_13ck4 = 0.95 time = 25
* CHECK dout0_14 vdout0_14ck4 = 0 time = 25
* CHECK dout0_15 vdout0_15ck4 = 0.95 time = 25
* CHECK dout0_16 vdout0_16ck4 = 0.95 time = 25
* CHECK dout0_17 vdout0_17ck4 = 0.95 time = 25
* CHECK dout0_18 vdout0_18ck4 = 0.95 time = 25
* CHECK dout0_19 vdout0_19ck4 = 0.95 time = 25
* CHECK dout0_0 vdout0_0ck7 = 0 time = 40
* CHECK dout0_1 vdout0_1ck7 = 0.95 time = 40
* CHECK dout0_2 vdout0_2ck7 = 0.95 time = 40
* CHECK dout0_3 vdout0_3ck7 = 0.95 time = 40
* CHECK dout0_4 vdout0_4ck7 = 0.95 time = 40
* CHECK dout0_5 vdout0_5ck7 = 0.95 time = 40
* CHECK dout0_6 vdout0_6ck7 = 0.95 time = 40
* CHECK dout0_7 vdout0_7ck7 = 0 time = 40
* CHECK dout0_8 vdout0_8ck7 = 0.95 time = 40
* CHECK dout0_9 vdout0_9ck7 = 0 time = 40
* CHECK dout0_10 vdout0_10ck7 = 0 time = 40
* CHECK dout0_11 vdout0_11ck7 = 0 time = 40
* CHECK dout0_12 vdout0_12ck7 = 0.95 time = 40
* CHECK dout0_13 vdout0_13ck7 = 0.95 time = 40
* CHECK dout0_14 vdout0_14ck7 = 0 time = 40
* CHECK dout0_15 vdout0_15ck7 = 0 time = 40
* CHECK dout0_16 vdout0_16ck7 = 0 time = 40
* CHECK dout0_17 vdout0_17ck7 = 0 time = 40
* CHECK dout0_18 vdout0_18ck7 = 0.95 time = 40
* CHECK dout0_19 vdout0_19ck7 = 0.95 time = 40
* CHECK dout0_0 vdout0_0ck14 = 0.95 time = 75
* CHECK dout0_1 vdout0_1ck14 = 0.95 time = 75
* CHECK dout0_2 vdout0_2ck14 = 0 time = 75
* CHECK dout0_3 vdout0_3ck14 = 0.95 time = 75
* CHECK dout0_4 vdout0_4ck14 = 0.95 time = 75
* CHECK dout0_5 vdout0_5ck14 = 0 time = 75
* CHECK dout0_6 vdout0_6ck14 = 0 time = 75
* CHECK dout0_7 vdout0_7ck14 = 0.95 time = 75
* CHECK dout0_8 vdout0_8ck14 = 0 time = 75
* CHECK dout0_9 vdout0_9ck14 = 0.95 time = 75
* CHECK dout0_10 vdout0_10ck14 = 0 time = 75
* CHECK dout0_11 vdout0_11ck14 = 0 time = 75
* CHECK dout0_12 vdout0_12ck14 = 0.95 time = 75
* CHECK dout0_13 vdout0_13ck14 = 0.95 time = 75
* CHECK dout0_14 vdout0_14ck14 = 0.95 time = 75
* CHECK dout0_15 vdout0_15ck14 = 0.95 time = 75
* CHECK dout0_16 vdout0_16ck14 = 0 time = 75
* CHECK dout0_17 vdout0_17ck14 = 0 time = 75
* CHECK dout0_18 vdout0_18ck14 = 0.95 time = 75
* CHECK dout0_19 vdout0_19ck14 = 0.95 time = 75
* CHECK dout0_0 vdout0_0ck16 = 0 time = 85
* CHECK dout0_1 vdout0_1ck16 = 0 time = 85
* CHECK dout0_2 vdout0_2ck16 = 0.95 time = 85
* CHECK dout0_3 vdout0_3ck16 = 0.95 time = 85
* CHECK dout0_4 vdout0_4ck16 = 0.95 time = 85
* CHECK dout0_5 vdout0_5ck16 = 0.95 time = 85
* CHECK dout0_6 vdout0_6ck16 = 0.95 time = 85
* CHECK dout0_7 vdout0_7ck16 = 0 time = 85
* CHECK dout0_8 vdout0_8ck16 = 0 time = 85
* CHECK dout0_9 vdout0_9ck16 = 0.95 time = 85
* CHECK dout0_10 vdout0_10ck16 = 0.95 time = 85
* CHECK dout0_11 vdout0_11ck16 = 0 time = 85
* CHECK dout0_12 vdout0_12ck16 = 0 time = 85
* CHECK dout0_13 vdout0_13ck16 = 0 time = 85
* CHECK dout0_14 vdout0_14ck16 = 0.95 time = 85
* CHECK dout0_15 vdout0_15ck16 = 0 time = 85
* CHECK dout0_16 vdout0_16ck16 = 0.95 time = 85
* CHECK dout0_17 vdout0_17ck16 = 0.95 time = 85
* CHECK dout0_18 vdout0_18ck16 = 0.95 time = 85
* CHECK dout0_19 vdout0_19ck16 = 0 time = 85
* CHECK dout0_0 vdout0_0ck18 = 0.95 time = 95
* CHECK dout0_1 vdout0_1ck18 = 0 time = 95
* CHECK dout0_2 vdout0_2ck18 = 0.95 time = 95
* CHECK dout0_3 vdout0_3ck18 = 0.95 time = 95
* CHECK dout0_4 vdout0_4ck18 = 0.95 time = 95
* CHECK dout0_5 vdout0_5ck18 = 0.95 time = 95
* CHECK dout0_6 vdout0_6ck18 = 0 time = 95
* CHECK dout0_7 vdout0_7ck18 = 0.95 time = 95
* CHECK dout0_8 vdout0_8ck18 = 0 time = 95
* CHECK dout0_9 vdout0_9ck18 = 0 time = 95
* CHECK dout0_10 vdout0_10ck18 = 0.95 time = 95
* CHECK dout0_11 vdout0_11ck18 = 0 time = 95
* CHECK dout0_12 vdout0_12ck18 = 0 time = 95
* CHECK dout0_13 vdout0_13ck18 = 0 time = 95
* CHECK dout0_14 vdout0_14ck18 = 0 time = 95
* CHECK dout0_15 vdout0_15ck18 = 0.95 time = 95
* CHECK dout0_16 vdout0_16ck18 = 0.95 time = 95
* CHECK dout0_17 vdout0_17ck18 = 0 time = 95
* CHECK dout0_18 vdout0_18ck18 = 0.95 time = 95
* CHECK dout0_19 vdout0_19ck18 = 0.95 time = 95
* CHECK dout0_0 vdout0_0ck23 = 0 time = 120
* CHECK dout0_1 vdout0_1ck23 = 0.95 time = 120
* CHECK dout0_2 vdout0_2ck23 = 0 time = 120
* CHECK dout0_3 vdout0_3ck23 = 0 time = 120
* CHECK dout0_4 vdout0_4ck23 = 0.95 time = 120
* CHECK dout0_5 vdout0_5ck23 = 0.95 time = 120
* CHECK dout0_6 vdout0_6ck23 = 0 time = 120
* CHECK dout0_7 vdout0_7ck23 = 0 time = 120
* CHECK dout0_8 vdout0_8ck23 = 0.95 time = 120
* CHECK dout0_9 vdout0_9ck23 = 0.95 time = 120
* CHECK dout0_10 vdout0_10ck23 = 0 time = 120
* CHECK dout0_11 vdout0_11ck23 = 0 time = 120
* CHECK dout0_12 vdout0_12ck23 = 0 time = 120
* CHECK dout0_13 vdout0_13ck23 = 0 time = 120
* CHECK dout0_14 vdout0_14ck23 = 0 time = 120
* CHECK dout0_15 vdout0_15ck23 = 0 time = 120
* CHECK dout0_16 vdout0_16ck23 = 0 time = 120
* CHECK dout0_17 vdout0_17ck23 = 0.95 time = 120
* CHECK dout0_18 vdout0_18ck23 = 0.95 time = 120
* CHECK dout0_19 vdout0_19ck23 = 0 time = 120
* CHECK dout0_0 vdout0_0ck25 = 0 time = 130
* CHECK dout0_1 vdout0_1ck25 = 0.95 time = 130
* CHECK dout0_2 vdout0_2ck25 = 0 time = 130
* CHECK dout0_3 vdout0_3ck25 = 0 time = 130
* CHECK dout0_4 vdout0_4ck25 = 0.95 time = 130
* CHECK dout0_5 vdout0_5ck25 = 0.95 time = 130
* CHECK dout0_6 vdout0_6ck25 = 0 time = 130
* CHECK dout0_7 vdout0_7ck25 = 0 time = 130
* CHECK dout0_8 vdout0_8ck25 = 0.95 time = 130
* CHECK dout0_9 vdout0_9ck25 = 0.95 time = 130
* CHECK dout0_10 vdout0_10ck25 = 0 time = 130
* CHECK dout0_11 vdout0_11ck25 = 0 time = 130
* CHECK dout0_12 vdout0_12ck25 = 0 time = 130
* CHECK dout0_13 vdout0_13ck25 = 0 time = 130
* CHECK dout0_14 vdout0_14ck25 = 0 time = 130
* CHECK dout0_15 vdout0_15ck25 = 0 time = 130
* CHECK dout0_16 vdout0_16ck25 = 0 time = 130
* CHECK dout0_17 vdout0_17ck25 = 0.95 time = 130
* CHECK dout0_18 vdout0_18ck25 = 0.95 time = 130
* CHECK dout0_19 vdout0_19ck25 = 0 time = 130
* CHECK dout0_0 vdout0_0ck31 = 0 time = 160
* CHECK dout0_1 vdout0_1ck31 = 0.95 time = 160
* CHECK dout0_2 vdout0_2ck31 = 0 time = 160
* CHECK dout0_3 vdout0_3ck31 = 0 time = 160
* CHECK dout0_4 vdout0_4ck31 = 0.95 time = 160
* CHECK dout0_5 vdout0_5ck31 = 0.95 time = 160
* CHECK dout0_6 vdout0_6ck31 = 0 time = 160
* CHECK dout0_7 vdout0_7ck31 = 0 time = 160
* CHECK dout0_8 vdout0_8ck31 = 0.95 time = 160
* CHECK dout0_9 vdout0_9ck31 = 0.95 time = 160
* CHECK dout0_10 vdout0_10ck31 = 0 time = 160
* CHECK dout0_11 vdout0_11ck31 = 0 time = 160
* CHECK dout0_12 vdout0_12ck31 = 0 time = 160
* CHECK dout0_13 vdout0_13ck31 = 0 time = 160
* CHECK dout0_14 vdout0_14ck31 = 0 time = 160
* CHECK dout0_15 vdout0_15ck31 = 0 time = 160
* CHECK dout0_16 vdout0_16ck31 = 0 time = 160
* CHECK dout0_17 vdout0_17ck31 = 0.95 time = 160
* CHECK dout0_18 vdout0_18ck31 = 0.95 time = 160
* CHECK dout0_19 vdout0_19ck31 = 0 time = 160
* CHECK dout0_0 vdout0_0ck32 = 0 time = 165
* CHECK dout0_1 vdout0_1ck32 = 0 time = 165
* CHECK dout0_2 vdout0_2ck32 = 0.95 time = 165
* CHECK dout0_3 vdout0_3ck32 = 0 time = 165
* CHECK dout0_4 vdout0_4ck32 = 0 time = 165
* CHECK dout0_5 vdout0_5ck32 = 0.95 time = 165
* CHECK dout0_6 vdout0_6ck32 = 0.95 time = 165
* CHECK dout0_7 vdout0_7ck32 = 0.95 time = 165
* CHECK dout0_8 vdout0_8ck32 = 0.95 time = 165
* CHECK dout0_9 vdout0_9ck32 = 0 time = 165
* CHECK dout0_10 vdout0_10ck32 = 0.95 time = 165
* CHECK dout0_11 vdout0_11ck32 = 0.95 time = 165
* CHECK dout0_12 vdout0_12ck32 = 0.95 time = 165
* CHECK dout0_13 vdout0_13ck32 = 0 time = 165
* CHECK dout0_14 vdout0_14ck32 = 0 time = 165
* CHECK dout0_15 vdout0_15ck32 = 0.95 time = 165
* CHECK dout0_16 vdout0_16ck32 = 0 time = 165
* CHECK dout0_17 vdout0_17ck32 = 0.95 time = 165
* CHECK dout0_18 vdout0_18ck32 = 0.95 time = 165
* CHECK dout0_19 vdout0_19ck32 = 0 time = 165
* CHECK dout0_0 vdout0_0ck34 = 0 time = 175
* CHECK dout0_1 vdout0_1ck34 = 0 time = 175
* CHECK dout0_2 vdout0_2ck34 = 0 time = 175
* CHECK dout0_3 vdout0_3ck34 = 0.95 time = 175
* CHECK dout0_4 vdout0_4ck34 = 0 time = 175
* CHECK dout0_5 vdout0_5ck34 = 0.95 time = 175
* CHECK dout0_6 vdout0_6ck34 = 0.95 time = 175
* CHECK dout0_7 vdout0_7ck34 = 0.95 time = 175
* CHECK dout0_8 vdout0_8ck34 = 0 time = 175
* CHECK dout0_9 vdout0_9ck34 = 0 time = 175
* CHECK dout0_10 vdout0_10ck34 = 0.95 time = 175
* CHECK dout0_11 vdout0_11ck34 = 0.95 time = 175
* CHECK dout0_12 vdout0_12ck34 = 0.95 time = 175
* CHECK dout0_13 vdout0_13ck34 = 0.95 time = 175
* CHECK dout0_14 vdout0_14ck34 = 0.95 time = 175
* CHECK dout0_15 vdout0_15ck34 = 0.95 time = 175
* CHECK dout0_16 vdout0_16ck34 = 0.95 time = 175
* CHECK dout0_17 vdout0_17ck34 = 0 time = 175
* CHECK dout0_18 vdout0_18ck34 = 0 time = 175
* CHECK dout0_19 vdout0_19ck34 = 0 time = 175
* CHECK dout0_0 vdout0_0ck35 = 0 time = 180
* CHECK dout0_1 vdout0_1ck35 = 0.95 time = 180
* CHECK dout0_2 vdout0_2ck35 = 0 time = 180
* CHECK dout0_3 vdout0_3ck35 = 0 time = 180
* CHECK dout0_4 vdout0_4ck35 = 0.95 time = 180
* CHECK dout0_5 vdout0_5ck35 = 0.95 time = 180
* CHECK dout0_6 vdout0_6ck35 = 0 time = 180
* CHECK dout0_7 vdout0_7ck35 = 0 time = 180
* CHECK dout0_8 vdout0_8ck35 = 0.95 time = 180
* CHECK dout0_9 vdout0_9ck35 = 0.95 time = 180
* CHECK dout0_10 vdout0_10ck35 = 0 time = 180
* CHECK dout0_11 vdout0_11ck35 = 0 time = 180
* CHECK dout0_12 vdout0_12ck35 = 0 time = 180
* CHECK dout0_13 vdout0_13ck35 = 0 time = 180
* CHECK dout0_14 vdout0_14ck35 = 0 time = 180
* CHECK dout0_15 vdout0_15ck35 = 0 time = 180
* CHECK dout0_16 vdout0_16ck35 = 0 time = 180
* CHECK dout0_17 vdout0_17ck35 = 0.95 time = 180
* CHECK dout0_18 vdout0_18ck35 = 0.95 time = 180
* CHECK dout0_19 vdout0_19ck35 = 0 time = 180
* CHECK dout0_0 vdout0_0ck38 = 0.95 time = 195
* CHECK dout0_1 vdout0_1ck38 = 0.95 time = 195
* CHECK dout0_2 vdout0_2ck38 = 0 time = 195
* CHECK dout0_3 vdout0_3ck38 = 0 time = 195
* CHECK dout0_4 vdout0_4ck38 = 0.95 time = 195
* CHECK dout0_5 vdout0_5ck38 = 0 time = 195
* CHECK dout0_6 vdout0_6ck38 = 0.95 time = 195
* CHECK dout0_7 vdout0_7ck38 = 0 time = 195
* CHECK dout0_8 vdout0_8ck38 = 0.95 time = 195
* CHECK dout0_9 vdout0_9ck38 = 0 time = 195
* CHECK dout0_10 vdout0_10ck38 = 0 time = 195
* CHECK dout0_11 vdout0_11ck38 = 0 time = 195
* CHECK dout0_12 vdout0_12ck38 = 0 time = 195
* CHECK dout0_13 vdout0_13ck38 = 0 time = 195
* CHECK dout0_14 vdout0_14ck38 = 0 time = 195
* CHECK dout0_15 vdout0_15ck38 = 0.95 time = 195
* CHECK dout0_16 vdout0_16ck38 = 0.95 time = 195
* CHECK dout0_17 vdout0_17ck38 = 0.95 time = 195
* CHECK dout0_18 vdout0_18ck38 = 0 time = 195
* CHECK dout0_19 vdout0_19ck38 = 0 time = 195
* CHECK dout0_0 vdout0_0ck39 = 0 time = 200
* CHECK dout0_1 vdout0_1ck39 = 0.95 time = 200
* CHECK dout0_2 vdout0_2ck39 = 0 time = 200
* CHECK dout0_3 vdout0_3ck39 = 0 time = 200
* CHECK dout0_4 vdout0_4ck39 = 0 time = 200
* CHECK dout0_5 vdout0_5ck39 = 0 time = 200
* CHECK dout0_6 vdout0_6ck39 = 0 time = 200
* CHECK dout0_7 vdout0_7ck39 = 0.95 time = 200
* CHECK dout0_8 vdout0_8ck39 = 0 time = 200
* CHECK dout0_9 vdout0_9ck39 = 0.95 time = 200
* CHECK dout0_10 vdout0_10ck39 = 0 time = 200
* CHECK dout0_11 vdout0_11ck39 = 0.95 time = 200
* CHECK dout0_12 vdout0_12ck39 = 0 time = 200
* CHECK dout0_13 vdout0_13ck39 = 0.95 time = 200
* CHECK dout0_14 vdout0_14ck39 = 0.95 time = 200
* CHECK dout0_15 vdout0_15ck39 = 0.95 time = 200
* CHECK dout0_16 vdout0_16ck39 = 0 time = 200
* CHECK dout0_17 vdout0_17ck39 = 0 time = 200
* CHECK dout0_18 vdout0_18ck39 = 0 time = 200
* CHECK dout0_19 vdout0_19ck39 = 0 time = 200
* CHECK dout0_0 vdout0_0ck40 = 0.95 time = 205
* CHECK dout0_1 vdout0_1ck40 = 0.95 time = 205
* CHECK dout0_2 vdout0_2ck40 = 0 time = 205
* CHECK dout0_3 vdout0_3ck40 = 0 time = 205
* CHECK dout0_4 vdout0_4ck40 = 0.95 time = 205
* CHECK dout0_5 vdout0_5ck40 = 0 time = 205
* CHECK dout0_6 vdout0_6ck40 = 0.95 time = 205
* CHECK dout0_7 vdout0_7ck40 = 0 time = 205
* CHECK dout0_8 vdout0_8ck40 = 0.95 time = 205
* CHECK dout0_9 vdout0_9ck40 = 0 time = 205
* CHECK dout0_10 vdout0_10ck40 = 0 time = 205
* CHECK dout0_11 vdout0_11ck40 = 0 time = 205
* CHECK dout0_12 vdout0_12ck40 = 0 time = 205
* CHECK dout0_13 vdout0_13ck40 = 0 time = 205
* CHECK dout0_14 vdout0_14ck40 = 0 time = 205
* CHECK dout0_15 vdout0_15ck40 = 0.95 time = 205
* CHECK dout0_16 vdout0_16ck40 = 0.95 time = 205
* CHECK dout0_17 vdout0_17ck40 = 0.95 time = 205
* CHECK dout0_18 vdout0_18ck40 = 0 time = 205
* CHECK dout0_19 vdout0_19ck40 = 0 time = 205
* CHECK dout0_0 vdout0_0ck41 = 0 time = 210
* CHECK dout0_1 vdout0_1ck41 = 0.95 time = 210
* CHECK dout0_2 vdout0_2ck41 = 0 time = 210
* CHECK dout0_3 vdout0_3ck41 = 0 time = 210
* CHECK dout0_4 vdout0_4ck41 = 0.95 time = 210
* CHECK dout0_5 vdout0_5ck41 = 0.95 time = 210
* CHECK dout0_6 vdout0_6ck41 = 0 time = 210
* CHECK dout0_7 vdout0_7ck41 = 0 time = 210
* CHECK dout0_8 vdout0_8ck41 = 0.95 time = 210
* CHECK dout0_9 vdout0_9ck41 = 0.95 time = 210
* CHECK dout0_10 vdout0_10ck41 = 0 time = 210
* CHECK dout0_11 vdout0_11ck41 = 0 time = 210
* CHECK dout0_12 vdout0_12ck41 = 0 time = 210
* CHECK dout0_13 vdout0_13ck41 = 0 time = 210
* CHECK dout0_14 vdout0_14ck41 = 0 time = 210
* CHECK dout0_15 vdout0_15ck41 = 0 time = 210
* CHECK dout0_16 vdout0_16ck41 = 0 time = 210
* CHECK dout0_17 vdout0_17ck41 = 0.95 time = 210
* CHECK dout0_18 vdout0_18ck41 = 0.95 time = 210
* CHECK dout0_19 vdout0_19ck41 = 0 time = 210
* CHECK dout0_0 vdout0_0ck43 = 0 time = 220
* CHECK dout0_1 vdout0_1ck43 = 0.95 time = 220
* CHECK dout0_2 vdout0_2ck43 = 0.95 time = 220
* CHECK dout0_3 vdout0_3ck43 = 0 time = 220
* CHECK dout0_4 vdout0_4ck43 = 0.95 time = 220
* CHECK dout0_5 vdout0_5ck43 = 0.95 time = 220
* CHECK dout0_6 vdout0_6ck43 = 0 time = 220
* CHECK dout0_7 vdout0_7ck43 = 0.95 time = 220
* CHECK dout0_8 vdout0_8ck43 = 0 time = 220
* CHECK dout0_9 vdout0_9ck43 = 0.95 time = 220
* CHECK dout0_10 vdout0_10ck43 = 0.95 time = 220
* CHECK dout0_11 vdout0_11ck43 = 0.95 time = 220
* CHECK dout0_12 vdout0_12ck43 = 0 time = 220
* CHECK dout0_13 vdout0_13ck43 = 0 time = 220
* CHECK dout0_14 vdout0_14ck43 = 0 time = 220
* CHECK dout0_15 vdout0_15ck43 = 0.95 time = 220
* CHECK dout0_16 vdout0_16ck43 = 0.95 time = 220
* CHECK dout0_17 vdout0_17ck43 = 0.95 time = 220
* CHECK dout0_18 vdout0_18ck43 = 0.95 time = 220
* CHECK dout0_19 vdout0_19ck43 = 0.95 time = 220
* CHECK dout0_0 vdout0_0ck52 = 0 time = 265
* CHECK dout0_1 vdout0_1ck52 = 0.95 time = 265
* CHECK dout0_2 vdout0_2ck52 = 0 time = 265
* CHECK dout0_3 vdout0_3ck52 = 0 time = 265
* CHECK dout0_4 vdout0_4ck52 = 0.95 time = 265
* CHECK dout0_5 vdout0_5ck52 = 0.95 time = 265
* CHECK dout0_6 vdout0_6ck52 = 0 time = 265
* CHECK dout0_7 vdout0_7ck52 = 0 time = 265
* CHECK dout0_8 vdout0_8ck52 = 0.95 time = 265
* CHECK dout0_9 vdout0_9ck52 = 0.95 time = 265
* CHECK dout0_10 vdout0_10ck52 = 0 time = 265
* CHECK dout0_11 vdout0_11ck52 = 0 time = 265
* CHECK dout0_12 vdout0_12ck52 = 0 time = 265
* CHECK dout0_13 vdout0_13ck52 = 0 time = 265
* CHECK dout0_14 vdout0_14ck52 = 0 time = 265
* CHECK dout0_15 vdout0_15ck52 = 0 time = 265
* CHECK dout0_16 vdout0_16ck52 = 0 time = 265
* CHECK dout0_17 vdout0_17ck52 = 0.95 time = 265
* CHECK dout0_18 vdout0_18ck52 = 0.95 time = 265
* CHECK dout0_19 vdout0_19ck52 = 0 time = 265
* CHECK dout0_0 vdout0_0ck55 = 0 time = 280
* CHECK dout0_1 vdout0_1ck55 = 0 time = 280
* CHECK dout0_2 vdout0_2ck55 = 0 time = 280
* CHECK dout0_3 vdout0_3ck55 = 0 time = 280
* CHECK dout0_4 vdout0_4ck55 = 0 time = 280
* CHECK dout0_5 vdout0_5ck55 = 0 time = 280
* CHECK dout0_6 vdout0_6ck55 = 0.95 time = 280
* CHECK dout0_7 vdout0_7ck55 = 0 time = 280
* CHECK dout0_8 vdout0_8ck55 = 0.95 time = 280
* CHECK dout0_9 vdout0_9ck55 = 0.95 time = 280
* CHECK dout0_10 vdout0_10ck55 = 0.95 time = 280
* CHECK dout0_11 vdout0_11ck55 = 0 time = 280
* CHECK dout0_12 vdout0_12ck55 = 0 time = 280
* CHECK dout0_13 vdout0_13ck55 = 0.95 time = 280
* CHECK dout0_14 vdout0_14ck55 = 0.95 time = 280
* CHECK dout0_15 vdout0_15ck55 = 0.95 time = 280
* CHECK dout0_16 vdout0_16ck55 = 0 time = 280
* CHECK dout0_17 vdout0_17ck55 = 0.95 time = 280
* CHECK dout0_18 vdout0_18ck55 = 0.95 time = 280
* CHECK dout0_19 vdout0_19ck55 = 0.95 time = 280
* CHECK dout0_0 vdout0_0ck59 = 0 time = 300
* CHECK dout0_1 vdout0_1ck59 = 0.95 time = 300
* CHECK dout0_2 vdout0_2ck59 = 0.95 time = 300
* CHECK dout0_3 vdout0_3ck59 = 0 time = 300
* CHECK dout0_4 vdout0_4ck59 = 0.95 time = 300
* CHECK dout0_5 vdout0_5ck59 = 0.95 time = 300
* CHECK dout0_6 vdout0_6ck59 = 0 time = 300
* CHECK dout0_7 vdout0_7ck59 = 0.95 time = 300
* CHECK dout0_8 vdout0_8ck59 = 0 time = 300
* CHECK dout0_9 vdout0_9ck59 = 0.95 time = 300
* CHECK dout0_10 vdout0_10ck59 = 0.95 time = 300
* CHECK dout0_11 vdout0_11ck59 = 0.95 time = 300
* CHECK dout0_12 vdout0_12ck59 = 0 time = 300
* CHECK dout0_13 vdout0_13ck59 = 0 time = 300
* CHECK dout0_14 vdout0_14ck59 = 0 time = 300
* CHECK dout0_15 vdout0_15ck59 = 0.95 time = 300
* CHECK dout0_16 vdout0_16ck59 = 0.95 time = 300
* CHECK dout0_17 vdout0_17ck59 = 0.95 time = 300
* CHECK dout0_18 vdout0_18ck59 = 0.95 time = 300
* CHECK dout0_19 vdout0_19ck59 = 0.95 time = 300
* CHECK dout0_0 vdout0_0ck60 = 0 time = 305
* CHECK dout0_1 vdout0_1ck60 = 0 time = 305
* CHECK dout0_2 vdout0_2ck60 = 0.95 time = 305
* CHECK dout0_3 vdout0_3ck60 = 0.95 time = 305
* CHECK dout0_4 vdout0_4ck60 = 0 time = 305
* CHECK dout0_5 vdout0_5ck60 = 0 time = 305
* CHECK dout0_6 vdout0_6ck60 = 0.95 time = 305
* CHECK dout0_7 vdout0_7ck60 = 0 time = 305
* CHECK dout0_8 vdout0_8ck60 = 0 time = 305
* CHECK dout0_9 vdout0_9ck60 = 0 time = 305
* CHECK dout0_10 vdout0_10ck60 = 0.95 time = 305
* CHECK dout0_11 vdout0_11ck60 = 0 time = 305
* CHECK dout0_12 vdout0_12ck60 = 0.95 time = 305
* CHECK dout0_13 vdout0_13ck60 = 0.95 time = 305
* CHECK dout0_14 vdout0_14ck60 = 0 time = 305
* CHECK dout0_15 vdout0_15ck60 = 0 time = 305
* CHECK dout0_16 vdout0_16ck60 = 0.95 time = 305
* CHECK dout0_17 vdout0_17ck60 = 0 time = 305
* CHECK dout0_18 vdout0_18ck60 = 0 time = 305
* CHECK dout0_19 vdout0_19ck60 = 0.95 time = 305
* CHECK dout0_0 vdout0_0ck62 = 0 time = 315
* CHECK dout0_1 vdout0_1ck62 = 0 time = 315
* CHECK dout0_2 vdout0_2ck62 = 0 time = 315
* CHECK dout0_3 vdout0_3ck62 = 0 time = 315
* CHECK dout0_4 vdout0_4ck62 = 0 time = 315
* CHECK dout0_5 vdout0_5ck62 = 0 time = 315
* CHECK dout0_6 vdout0_6ck62 = 0.95 time = 315
* CHECK dout0_7 vdout0_7ck62 = 0 time = 315
* CHECK dout0_8 vdout0_8ck62 = 0.95 time = 315
* CHECK dout0_9 vdout0_9ck62 = 0.95 time = 315
* CHECK dout0_10 vdout0_10ck62 = 0.95 time = 315
* CHECK dout0_11 vdout0_11ck62 = 0 time = 315
* CHECK dout0_12 vdout0_12ck62 = 0 time = 315
* CHECK dout0_13 vdout0_13ck62 = 0.95 time = 315
* CHECK dout0_14 vdout0_14ck62 = 0.95 time = 315
* CHECK dout0_15 vdout0_15ck62 = 0.95 time = 315
* CHECK dout0_16 vdout0_16ck62 = 0 time = 315
* CHECK dout0_17 vdout0_17ck62 = 0.95 time = 315
* CHECK dout0_18 vdout0_18ck62 = 0.95 time = 315
* CHECK dout0_19 vdout0_19ck62 = 0.95 time = 315
* CHECK dout0_0 vdout0_0ck63 = 0 time = 320
* CHECK dout0_1 vdout0_1ck63 = 0.95 time = 320
* CHECK dout0_2 vdout0_2ck63 = 0.95 time = 320
* CHECK dout0_3 vdout0_3ck63 = 0 time = 320
* CHECK dout0_4 vdout0_4ck63 = 0.95 time = 320
* CHECK dout0_5 vdout0_5ck63 = 0.95 time = 320
* CHECK dout0_6 vdout0_6ck63 = 0 time = 320
* CHECK dout0_7 vdout0_7ck63 = 0.95 time = 320
* CHECK dout0_8 vdout0_8ck63 = 0 time = 320
* CHECK dout0_9 vdout0_9ck63 = 0.95 time = 320
* CHECK dout0_10 vdout0_10ck63 = 0.95 time = 320
* CHECK dout0_11 vdout0_11ck63 = 0.95 time = 320
* CHECK dout0_12 vdout0_12ck63 = 0 time = 320
* CHECK dout0_13 vdout0_13ck63 = 0 time = 320
* CHECK dout0_14 vdout0_14ck63 = 0 time = 320
* CHECK dout0_15 vdout0_15ck63 = 0.95 time = 320
* CHECK dout0_16 vdout0_16ck63 = 0.95 time = 320
* CHECK dout0_17 vdout0_17ck63 = 0.95 time = 320
* CHECK dout0_18 vdout0_18ck63 = 0.95 time = 320
* CHECK dout0_19 vdout0_19ck63 = 0.95 time = 320
* CHECK dout0_0 vdout0_0ck65 = 0 time = 330
* CHECK dout0_1 vdout0_1ck65 = 0 time = 330
* CHECK dout0_2 vdout0_2ck65 = 0.95 time = 330
* CHECK dout0_3 vdout0_3ck65 = 0.95 time = 330
* CHECK dout0_4 vdout0_4ck65 = 0 time = 330
* CHECK dout0_5 vdout0_5ck65 = 0 time = 330
* CHECK dout0_6 vdout0_6ck65 = 0.95 time = 330
* CHECK dout0_7 vdout0_7ck65 = 0 time = 330
* CHECK dout0_8 vdout0_8ck65 = 0 time = 330
* CHECK dout0_9 vdout0_9ck65 = 0 time = 330
* CHECK dout0_10 vdout0_10ck65 = 0.95 time = 330
* CHECK dout0_11 vdout0_11ck65 = 0 time = 330
* CHECK dout0_12 vdout0_12ck65 = 0.95 time = 330
* CHECK dout0_13 vdout0_13ck65 = 0.95 time = 330
* CHECK dout0_14 vdout0_14ck65 = 0 time = 330
* CHECK dout0_15 vdout0_15ck65 = 0 time = 330
* CHECK dout0_16 vdout0_16ck65 = 0.95 time = 330
* CHECK dout0_17 vdout0_17ck65 = 0 time = 330
* CHECK dout0_18 vdout0_18ck65 = 0 time = 330
* CHECK dout0_19 vdout0_19ck65 = 0.95 time = 330
* CHECK dout0_0 vdout0_0ck67 = 0 time = 340
* CHECK dout0_1 vdout0_1ck67 = 0 time = 340
* CHECK dout0_2 vdout0_2ck67 = 0 time = 340
* CHECK dout0_3 vdout0_3ck67 = 0.95 time = 340
* CHECK dout0_4 vdout0_4ck67 = 0.95 time = 340
* CHECK dout0_5 vdout0_5ck67 = 0 time = 340
* CHECK dout0_6 vdout0_6ck67 = 0.95 time = 340
* CHECK dout0_7 vdout0_7ck67 = 0 time = 340
* CHECK dout0_8 vdout0_8ck67 = 0 time = 340
* CHECK dout0_9 vdout0_9ck67 = 0 time = 340
* CHECK dout0_10 vdout0_10ck67 = 0.95 time = 340
* CHECK dout0_11 vdout0_11ck67 = 0 time = 340
* CHECK dout0_12 vdout0_12ck67 = 0 time = 340
* CHECK dout0_13 vdout0_13ck67 = 0.95 time = 340
* CHECK dout0_14 vdout0_14ck67 = 0.95 time = 340
* CHECK dout0_15 vdout0_15ck67 = 0.95 time = 340
* CHECK dout0_16 vdout0_16ck67 = 0.95 time = 340
* CHECK dout0_17 vdout0_17ck67 = 0 time = 340
* CHECK dout0_18 vdout0_18ck67 = 0 time = 340
* CHECK dout0_19 vdout0_19ck67 = 0 time = 340
* CHECK dout0_0 vdout0_0ck68 = 0 time = 345
* CHECK dout0_1 vdout0_1ck68 = 0 time = 345
* CHECK dout0_2 vdout0_2ck68 = 0 time = 345
* CHECK dout0_3 vdout0_3ck68 = 0 time = 345
* CHECK dout0_4 vdout0_4ck68 = 0 time = 345
* CHECK dout0_5 vdout0_5ck68 = 0 time = 345
* CHECK dout0_6 vdout0_6ck68 = 0.95 time = 345
* CHECK dout0_7 vdout0_7ck68 = 0 time = 345
* CHECK dout0_8 vdout0_8ck68 = 0.95 time = 345
* CHECK dout0_9 vdout0_9ck68 = 0.95 time = 345
* CHECK dout0_10 vdout0_10ck68 = 0.95 time = 345
* CHECK dout0_11 vdout0_11ck68 = 0 time = 345
* CHECK dout0_12 vdout0_12ck68 = 0 time = 345
* CHECK dout0_13 vdout0_13ck68 = 0.95 time = 345
* CHECK dout0_14 vdout0_14ck68 = 0.95 time = 345
* CHECK dout0_15 vdout0_15ck68 = 0.95 time = 345
* CHECK dout0_16 vdout0_16ck68 = 0 time = 345
* CHECK dout0_17 vdout0_17ck68 = 0.95 time = 345
* CHECK dout0_18 vdout0_18ck68 = 0.95 time = 345
* CHECK dout0_19 vdout0_19ck68 = 0.95 time = 345
* CHECK dout0_0 vdout0_0ck69 = 0 time = 350
* CHECK dout0_1 vdout0_1ck69 = 0 time = 350
* CHECK dout0_2 vdout0_2ck69 = 0.95 time = 350
* CHECK dout0_3 vdout0_3ck69 = 0.95 time = 350
* CHECK dout0_4 vdout0_4ck69 = 0 time = 350
* CHECK dout0_5 vdout0_5ck69 = 0 time = 350
* CHECK dout0_6 vdout0_6ck69 = 0.95 time = 350
* CHECK dout0_7 vdout0_7ck69 = 0 time = 350
* CHECK dout0_8 vdout0_8ck69 = 0 time = 350
* CHECK dout0_9 vdout0_9ck69 = 0 time = 350
* CHECK dout0_10 vdout0_10ck69 = 0.95 time = 350
* CHECK dout0_11 vdout0_11ck69 = 0 time = 350
* CHECK dout0_12 vdout0_12ck69 = 0.95 time = 350
* CHECK dout0_13 vdout0_13ck69 = 0.95 time = 350
* CHECK dout0_14 vdout0_14ck69 = 0 time = 350
* CHECK dout0_15 vdout0_15ck69 = 0 time = 350
* CHECK dout0_16 vdout0_16ck69 = 0.95 time = 350
* CHECK dout0_17 vdout0_17ck69 = 0 time = 350
* CHECK dout0_18 vdout0_18ck69 = 0 time = 350
* CHECK dout0_19 vdout0_19ck69 = 0.95 time = 350
* CHECK dout0_0 vdout0_0ck70 = 0 time = 355
* CHECK dout0_1 vdout0_1ck70 = 0.95 time = 355
* CHECK dout0_2 vdout0_2ck70 = 0 time = 355
* CHECK dout0_3 vdout0_3ck70 = 0 time = 355
* CHECK dout0_4 vdout0_4ck70 = 0.95 time = 355
* CHECK dout0_5 vdout0_5ck70 = 0.95 time = 355
* CHECK dout0_6 vdout0_6ck70 = 0 time = 355
* CHECK dout0_7 vdout0_7ck70 = 0 time = 355
* CHECK dout0_8 vdout0_8ck70 = 0.95 time = 355
* CHECK dout0_9 vdout0_9ck70 = 0.95 time = 355
* CHECK dout0_10 vdout0_10ck70 = 0 time = 355
* CHECK dout0_11 vdout0_11ck70 = 0 time = 355
* CHECK dout0_12 vdout0_12ck70 = 0 time = 355
* CHECK dout0_13 vdout0_13ck70 = 0 time = 355
* CHECK dout0_14 vdout0_14ck70 = 0 time = 355
* CHECK dout0_15 vdout0_15ck70 = 0 time = 355
* CHECK dout0_16 vdout0_16ck70 = 0 time = 355
* CHECK dout0_17 vdout0_17ck70 = 0.95 time = 355
* CHECK dout0_18 vdout0_18ck70 = 0.95 time = 355
* CHECK dout0_19 vdout0_19ck70 = 0 time = 355
* CHECK dout0_0 vdout0_0ck71 = 0 time = 360
* CHECK dout0_1 vdout0_1ck71 = 0.95 time = 360
* CHECK dout0_2 vdout0_2ck71 = 0 time = 360
* CHECK dout0_3 vdout0_3ck71 = 0 time = 360
* CHECK dout0_4 vdout0_4ck71 = 0.95 time = 360
* CHECK dout0_5 vdout0_5ck71 = 0.95 time = 360
* CHECK dout0_6 vdout0_6ck71 = 0 time = 360
* CHECK dout0_7 vdout0_7ck71 = 0 time = 360
* CHECK dout0_8 vdout0_8ck71 = 0.95 time = 360
* CHECK dout0_9 vdout0_9ck71 = 0.95 time = 360
* CHECK dout0_10 vdout0_10ck71 = 0 time = 360
* CHECK dout0_11 vdout0_11ck71 = 0 time = 360
* CHECK dout0_12 vdout0_12ck71 = 0 time = 360
* CHECK dout0_13 vdout0_13ck71 = 0 time = 360
* CHECK dout0_14 vdout0_14ck71 = 0 time = 360
* CHECK dout0_15 vdout0_15ck71 = 0 time = 360
* CHECK dout0_16 vdout0_16ck71 = 0 time = 360
* CHECK dout0_17 vdout0_17ck71 = 0.95 time = 360
* CHECK dout0_18 vdout0_18ck71 = 0.95 time = 360
* CHECK dout0_19 vdout0_19ck71 = 0 time = 360
* CHECK dout0_0 vdout0_0ck72 = 0 time = 365
* CHECK dout0_1 vdout0_1ck72 = 0 time = 365
* CHECK dout0_2 vdout0_2ck72 = 0 time = 365
* CHECK dout0_3 vdout0_3ck72 = 0.95 time = 365
* CHECK dout0_4 vdout0_4ck72 = 0.95 time = 365
* CHECK dout0_5 vdout0_5ck72 = 0 time = 365
* CHECK dout0_6 vdout0_6ck72 = 0.95 time = 365
* CHECK dout0_7 vdout0_7ck72 = 0 time = 365
* CHECK dout0_8 vdout0_8ck72 = 0 time = 365
* CHECK dout0_9 vdout0_9ck72 = 0 time = 365
* CHECK dout0_10 vdout0_10ck72 = 0.95 time = 365
* CHECK dout0_11 vdout0_11ck72 = 0 time = 365
* CHECK dout0_12 vdout0_12ck72 = 0 time = 365
* CHECK dout0_13 vdout0_13ck72 = 0.95 time = 365
* CHECK dout0_14 vdout0_14ck72 = 0.95 time = 365
* CHECK dout0_15 vdout0_15ck72 = 0.95 time = 365
* CHECK dout0_16 vdout0_16ck72 = 0.95 time = 365
* CHECK dout0_17 vdout0_17ck72 = 0 time = 365
* CHECK dout0_18 vdout0_18ck72 = 0 time = 365
* CHECK dout0_19 vdout0_19ck72 = 0 time = 365
* CHECK dout0_0 vdout0_0ck77 = 0.95 time = 390
* CHECK dout0_1 vdout0_1ck77 = 0 time = 390
* CHECK dout0_2 vdout0_2ck77 = 0.95 time = 390
* CHECK dout0_3 vdout0_3ck77 = 0 time = 390
* CHECK dout0_4 vdout0_4ck77 = 0.95 time = 390
* CHECK dout0_5 vdout0_5ck77 = 0 time = 390
* CHECK dout0_6 vdout0_6ck77 = 0 time = 390
* CHECK dout0_7 vdout0_7ck77 = 0 time = 390
* CHECK dout0_8 vdout0_8ck77 = 0.95 time = 390
* CHECK dout0_9 vdout0_9ck77 = 0 time = 390
* CHECK dout0_10 vdout0_10ck77 = 0.95 time = 390
* CHECK dout0_11 vdout0_11ck77 = 0.95 time = 390
* CHECK dout0_12 vdout0_12ck77 = 0 time = 390
* CHECK dout0_13 vdout0_13ck77 = 0.95 time = 390
* CHECK dout0_14 vdout0_14ck77 = 0 time = 390
* CHECK dout0_15 vdout0_15ck77 = 0.95 time = 390
* CHECK dout0_16 vdout0_16ck77 = 0.95 time = 390
* CHECK dout0_17 vdout0_17ck77 = 0 time = 390
* CHECK dout0_18 vdout0_18ck77 = 0.95 time = 390
* CHECK dout0_19 vdout0_19ck77 = 0 time = 390
* CHECK dout0_0 vdout0_0ck78 = 0 time = 395
* CHECK dout0_1 vdout0_1ck78 = 0 time = 395
* CHECK dout0_2 vdout0_2ck78 = 0 time = 395
* CHECK dout0_3 vdout0_3ck78 = 0.95 time = 395
* CHECK dout0_4 vdout0_4ck78 = 0.95 time = 395
* CHECK dout0_5 vdout0_5ck78 = 0 time = 395
* CHECK dout0_6 vdout0_6ck78 = 0.95 time = 395
* CHECK dout0_7 vdout0_7ck78 = 0 time = 395
* CHECK dout0_8 vdout0_8ck78 = 0 time = 395
* CHECK dout0_9 vdout0_9ck78 = 0 time = 395
* CHECK dout0_10 vdout0_10ck78 = 0.95 time = 395
* CHECK dout0_11 vdout0_11ck78 = 0 time = 395
* CHECK dout0_12 vdout0_12ck78 = 0 time = 395
* CHECK dout0_13 vdout0_13ck78 = 0.95 time = 395
* CHECK dout0_14 vdout0_14ck78 = 0.95 time = 395
* CHECK dout0_15 vdout0_15ck78 = 0.95 time = 395
* CHECK dout0_16 vdout0_16ck78 = 0.95 time = 395
* CHECK dout0_17 vdout0_17ck78 = 0 time = 395
* CHECK dout0_18 vdout0_18ck78 = 0 time = 395
* CHECK dout0_19 vdout0_19ck78 = 0 time = 395
* CHECK dout0_0 vdout0_0ck79 = 0 time = 400
* CHECK dout0_1 vdout0_1ck79 = 0.95 time = 400
* CHECK dout0_2 vdout0_2ck79 = 0 time = 400
* CHECK dout0_3 vdout0_3ck79 = 0 time = 400
* CHECK dout0_4 vdout0_4ck79 = 0.95 time = 400
* CHECK dout0_5 vdout0_5ck79 = 0.95 time = 400
* CHECK dout0_6 vdout0_6ck79 = 0 time = 400
* CHECK dout0_7 vdout0_7ck79 = 0 time = 400
* CHECK dout0_8 vdout0_8ck79 = 0.95 time = 400
* CHECK dout0_9 vdout0_9ck79 = 0.95 time = 400
* CHECK dout0_10 vdout0_10ck79 = 0 time = 400
* CHECK dout0_11 vdout0_11ck79 = 0 time = 400
* CHECK dout0_12 vdout0_12ck79 = 0 time = 400
* CHECK dout0_13 vdout0_13ck79 = 0 time = 400
* CHECK dout0_14 vdout0_14ck79 = 0 time = 400
* CHECK dout0_15 vdout0_15ck79 = 0 time = 400
* CHECK dout0_16 vdout0_16ck79 = 0 time = 400
* CHECK dout0_17 vdout0_17ck79 = 0.95 time = 400
* CHECK dout0_18 vdout0_18ck79 = 0.95 time = 400
* CHECK dout0_19 vdout0_19ck79 = 0 time = 400
* CHECK dout0_0 vdout0_0ck81 = 0 time = 410
* CHECK dout0_1 vdout0_1ck81 = 0 time = 410
* CHECK dout0_2 vdout0_2ck81 = 0 time = 410
* CHECK dout0_3 vdout0_3ck81 = 0.95 time = 410
* CHECK dout0_4 vdout0_4ck81 = 0.95 time = 410
* CHECK dout0_5 vdout0_5ck81 = 0 time = 410
* CHECK dout0_6 vdout0_6ck81 = 0 time = 410
* CHECK dout0_7 vdout0_7ck81 = 0.95 time = 410
* CHECK dout0_8 vdout0_8ck81 = 0.95 time = 410
* CHECK dout0_9 vdout0_9ck81 = 0 time = 410
* CHECK dout0_10 vdout0_10ck81 = 0.95 time = 410
* CHECK dout0_11 vdout0_11ck81 = 0 time = 410
* CHECK dout0_12 vdout0_12ck81 = 0 time = 410
* CHECK dout0_13 vdout0_13ck81 = 0.95 time = 410
* CHECK dout0_14 vdout0_14ck81 = 0 time = 410
* CHECK dout0_15 vdout0_15ck81 = 0 time = 410
* CHECK dout0_16 vdout0_16ck81 = 0.95 time = 410
* CHECK dout0_17 vdout0_17ck81 = 0 time = 410
* CHECK dout0_18 vdout0_18ck81 = 0 time = 410
* CHECK dout0_19 vdout0_19ck81 = 0.95 time = 410
* CHECK dout0_0 vdout0_0ck83 = 0 time = 420
* CHECK dout0_1 vdout0_1ck83 = 0.95 time = 420
* CHECK dout0_2 vdout0_2ck83 = 0 time = 420
* CHECK dout0_3 vdout0_3ck83 = 0 time = 420
* CHECK dout0_4 vdout0_4ck83 = 0.95 time = 420
* CHECK dout0_5 vdout0_5ck83 = 0.95 time = 420
* CHECK dout0_6 vdout0_6ck83 = 0 time = 420
* CHECK dout0_7 vdout0_7ck83 = 0 time = 420
* CHECK dout0_8 vdout0_8ck83 = 0.95 time = 420
* CHECK dout0_9 vdout0_9ck83 = 0.95 time = 420
* CHECK dout0_10 vdout0_10ck83 = 0 time = 420
* CHECK dout0_11 vdout0_11ck83 = 0 time = 420
* CHECK dout0_12 vdout0_12ck83 = 0 time = 420
* CHECK dout0_13 vdout0_13ck83 = 0 time = 420
* CHECK dout0_14 vdout0_14ck83 = 0 time = 420
* CHECK dout0_15 vdout0_15ck83 = 0 time = 420
* CHECK dout0_16 vdout0_16ck83 = 0 time = 420
* CHECK dout0_17 vdout0_17ck83 = 0.95 time = 420
* CHECK dout0_18 vdout0_18ck83 = 0.95 time = 420
* CHECK dout0_19 vdout0_19ck83 = 0 time = 420
* CHECK dout0_0 vdout0_0ck85 = 0.95 time = 430
* CHECK dout0_1 vdout0_1ck85 = 0.95 time = 430
* CHECK dout0_2 vdout0_2ck85 = 0.95 time = 430
* CHECK dout0_3 vdout0_3ck85 = 0.95 time = 430
* CHECK dout0_4 vdout0_4ck85 = 0 time = 430
* CHECK dout0_5 vdout0_5ck85 = 0.95 time = 430
* CHECK dout0_6 vdout0_6ck85 = 0 time = 430
* CHECK dout0_7 vdout0_7ck85 = 0 time = 430
* CHECK dout0_8 vdout0_8ck85 = 0 time = 430
* CHECK dout0_9 vdout0_9ck85 = 0 time = 430
* CHECK dout0_10 vdout0_10ck85 = 0 time = 430
* CHECK dout0_11 vdout0_11ck85 = 0 time = 430
* CHECK dout0_12 vdout0_12ck85 = 0 time = 430
* CHECK dout0_13 vdout0_13ck85 = 0.95 time = 430
* CHECK dout0_14 vdout0_14ck85 = 0 time = 430
* CHECK dout0_15 vdout0_15ck85 = 0 time = 430
* CHECK dout0_16 vdout0_16ck85 = 0.95 time = 430
* CHECK dout0_17 vdout0_17ck85 = 0.95 time = 430
* CHECK dout0_18 vdout0_18ck85 = 0 time = 430
* CHECK dout0_19 vdout0_19ck85 = 0.95 time = 430
* CHECK dout0_0 vdout0_0ck86 = 0 time = 435
* CHECK dout0_1 vdout0_1ck86 = 0.95 time = 435
* CHECK dout0_2 vdout0_2ck86 = 0 time = 435
* CHECK dout0_3 vdout0_3ck86 = 0 time = 435
* CHECK dout0_4 vdout0_4ck86 = 0.95 time = 435
* CHECK dout0_5 vdout0_5ck86 = 0.95 time = 435
* CHECK dout0_6 vdout0_6ck86 = 0 time = 435
* CHECK dout0_7 vdout0_7ck86 = 0 time = 435
* CHECK dout0_8 vdout0_8ck86 = 0.95 time = 435
* CHECK dout0_9 vdout0_9ck86 = 0.95 time = 435
* CHECK dout0_10 vdout0_10ck86 = 0 time = 435
* CHECK dout0_11 vdout0_11ck86 = 0 time = 435
* CHECK dout0_12 vdout0_12ck86 = 0 time = 435
* CHECK dout0_13 vdout0_13ck86 = 0 time = 435
* CHECK dout0_14 vdout0_14ck86 = 0 time = 435
* CHECK dout0_15 vdout0_15ck86 = 0 time = 435
* CHECK dout0_16 vdout0_16ck86 = 0 time = 435
* CHECK dout0_17 vdout0_17ck86 = 0.95 time = 435
* CHECK dout0_18 vdout0_18ck86 = 0.95 time = 435
* CHECK dout0_19 vdout0_19ck86 = 0 time = 435
* CHECK dout0_0 vdout0_0ck91 = 0 time = 460
* CHECK dout0_1 vdout0_1ck91 = 0 time = 460
* CHECK dout0_2 vdout0_2ck91 = 0.95 time = 460
* CHECK dout0_3 vdout0_3ck91 = 0 time = 460
* CHECK dout0_4 vdout0_4ck91 = 0 time = 460
* CHECK dout0_5 vdout0_5ck91 = 0.95 time = 460
* CHECK dout0_6 vdout0_6ck91 = 0.95 time = 460
* CHECK dout0_7 vdout0_7ck91 = 0 time = 460
* CHECK dout0_8 vdout0_8ck91 = 0 time = 460
* CHECK dout0_9 vdout0_9ck91 = 0.95 time = 460
* CHECK dout0_10 vdout0_10ck91 = 0 time = 460
* CHECK dout0_11 vdout0_11ck91 = 0 time = 460
* CHECK dout0_12 vdout0_12ck91 = 0.95 time = 460
* CHECK dout0_13 vdout0_13ck91 = 0 time = 460
* CHECK dout0_14 vdout0_14ck91 = 0.95 time = 460
* CHECK dout0_15 vdout0_15ck91 = 0.95 time = 460
* CHECK dout0_16 vdout0_16ck91 = 0 time = 460
* CHECK dout0_17 vdout0_17ck91 = 0.95 time = 460
* CHECK dout0_18 vdout0_18ck91 = 0.95 time = 460
* CHECK dout0_19 vdout0_19ck91 = 0 time = 460
* CHECK dout0_0 vdout0_0ck94 = 0 time = 475
* CHECK dout0_1 vdout0_1ck94 = 0 time = 475
* CHECK dout0_2 vdout0_2ck94 = 0 time = 475
* CHECK dout0_3 vdout0_3ck94 = 0 time = 475
* CHECK dout0_4 vdout0_4ck94 = 0 time = 475
* CHECK dout0_5 vdout0_5ck94 = 0 time = 475
* CHECK dout0_6 vdout0_6ck94 = 0.95 time = 475
* CHECK dout0_7 vdout0_7ck94 = 0.95 time = 475
* CHECK dout0_8 vdout0_8ck94 = 0.95 time = 475
* CHECK dout0_9 vdout0_9ck94 = 0 time = 475
* CHECK dout0_10 vdout0_10ck94 = 0 time = 475
* CHECK dout0_11 vdout0_11ck94 = 0 time = 475
* CHECK dout0_12 vdout0_12ck94 = 0.95 time = 475
* CHECK dout0_13 vdout0_13ck94 = 0 time = 475
* CHECK dout0_14 vdout0_14ck94 = 0.95 time = 475
* CHECK dout0_15 vdout0_15ck94 = 0.95 time = 475
* CHECK dout0_16 vdout0_16ck94 = 0.95 time = 475
* CHECK dout0_17 vdout0_17ck94 = 0 time = 475
* CHECK dout0_18 vdout0_18ck94 = 0 time = 475
* CHECK dout0_19 vdout0_19ck94 = 0 time = 475
* CHECK dout0_0 vdout0_0ck95 = 0.95 time = 480
* CHECK dout0_1 vdout0_1ck95 = 0 time = 480
* CHECK dout0_2 vdout0_2ck95 = 0 time = 480
* CHECK dout0_3 vdout0_3ck95 = 0.95 time = 480
* CHECK dout0_4 vdout0_4ck95 = 0.95 time = 480
* CHECK dout0_5 vdout0_5ck95 = 0 time = 480
* CHECK dout0_6 vdout0_6ck95 = 0 time = 480
* CHECK dout0_7 vdout0_7ck95 = 0 time = 480
* CHECK dout0_8 vdout0_8ck95 = 0.95 time = 480
* CHECK dout0_9 vdout0_9ck95 = 0.95 time = 480
* CHECK dout0_10 vdout0_10ck95 = 0.95 time = 480
* CHECK dout0_11 vdout0_11ck95 = 0 time = 480
* CHECK dout0_12 vdout0_12ck95 = 0 time = 480
* CHECK dout0_13 vdout0_13ck95 = 0 time = 480
* CHECK dout0_14 vdout0_14ck95 = 0.95 time = 480
* CHECK dout0_15 vdout0_15ck95 = 0.95 time = 480
* CHECK dout0_16 vdout0_16ck95 = 0 time = 480
* CHECK dout0_17 vdout0_17ck95 = 0.95 time = 480
* CHECK dout0_18 vdout0_18ck95 = 0.95 time = 480
* CHECK dout0_19 vdout0_19ck95 = 0.95 time = 480
* CHECK dout0_0 vdout0_0ck97 = 0 time = 490
* CHECK dout0_1 vdout0_1ck97 = 0.95 time = 490
* CHECK dout0_2 vdout0_2ck97 = 0 time = 490
* CHECK dout0_3 vdout0_3ck97 = 0 time = 490
* CHECK dout0_4 vdout0_4ck97 = 0.95 time = 490
* CHECK dout0_5 vdout0_5ck97 = 0.95 time = 490
* CHECK dout0_6 vdout0_6ck97 = 0 time = 490
* CHECK dout0_7 vdout0_7ck97 = 0 time = 490
* CHECK dout0_8 vdout0_8ck97 = 0.95 time = 490
* CHECK dout0_9 vdout0_9ck97 = 0.95 time = 490
* CHECK dout0_10 vdout0_10ck97 = 0 time = 490
* CHECK dout0_11 vdout0_11ck97 = 0 time = 490
* CHECK dout0_12 vdout0_12ck97 = 0 time = 490
* CHECK dout0_13 vdout0_13ck97 = 0 time = 490
* CHECK dout0_14 vdout0_14ck97 = 0 time = 490
* CHECK dout0_15 vdout0_15ck97 = 0 time = 490
* CHECK dout0_16 vdout0_16ck97 = 0 time = 490
* CHECK dout0_17 vdout0_17ck97 = 0.95 time = 490
* CHECK dout0_18 vdout0_18ck97 = 0.95 time = 490
* CHECK dout0_19 vdout0_19ck97 = 0 time = 490
* CHECK dout0_0 vdout0_0ck98 = 0.95 time = 495
* CHECK dout0_1 vdout0_1ck98 = 0 time = 495
* CHECK dout0_2 vdout0_2ck98 = 0 time = 495
* CHECK dout0_3 vdout0_3ck98 = 0 time = 495
* CHECK dout0_4 vdout0_4ck98 = 0.95 time = 495
* CHECK dout0_5 vdout0_5ck98 = 0.95 time = 495
* CHECK dout0_6 vdout0_6ck98 = 0 time = 495
* CHECK dout0_7 vdout0_7ck98 = 0 time = 495
* CHECK dout0_8 vdout0_8ck98 = 0.95 time = 495
* CHECK dout0_9 vdout0_9ck98 = 0 time = 495
* CHECK dout0_10 vdout0_10ck98 = 0.95 time = 495
* CHECK dout0_11 vdout0_11ck98 = 0 time = 495
* CHECK dout0_12 vdout0_12ck98 = 0.95 time = 495
* CHECK dout0_13 vdout0_13ck98 = 0 time = 495
* CHECK dout0_14 vdout0_14ck98 = 0 time = 495
* CHECK dout0_15 vdout0_15ck98 = 0 time = 495
* CHECK dout0_16 vdout0_16ck98 = 0 time = 495
* CHECK dout0_17 vdout0_17ck98 = 0 time = 495
* CHECK dout0_18 vdout0_18ck98 = 0 time = 495
* CHECK dout0_19 vdout0_19ck98 = 0.95 time = 495
* CHECK dout0_0 vdout0_0ck99 = 0 time = 500
* CHECK dout0_1 vdout0_1ck99 = 0 time = 500
* CHECK dout0_2 vdout0_2ck99 = 0.95 time = 500
* CHECK dout0_3 vdout0_3ck99 = 0 time = 500
* CHECK dout0_4 vdout0_4ck99 = 0 time = 500
* CHECK dout0_5 vdout0_5ck99 = 0.95 time = 500
* CHECK dout0_6 vdout0_6ck99 = 0.95 time = 500
* CHECK dout0_7 vdout0_7ck99 = 0.95 time = 500
* CHECK dout0_8 vdout0_8ck99 = 0 time = 500
* CHECK dout0_9 vdout0_9ck99 = 0 time = 500
* CHECK dout0_10 vdout0_10ck99 = 0.95 time = 500
* CHECK dout0_11 vdout0_11ck99 = 0 time = 500
* CHECK dout0_12 vdout0_12ck99 = 0.95 time = 500
* CHECK dout0_13 vdout0_13ck99 = 0.95 time = 500
* CHECK dout0_14 vdout0_14ck99 = 0 time = 500
* CHECK dout0_15 vdout0_15ck99 = 0 time = 500
* CHECK dout0_16 vdout0_16ck99 = 0 time = 500
* CHECK dout0_17 vdout0_17ck99 = 0 time = 500
* CHECK dout0_18 vdout0_18ck99 = 0 time = 500
* CHECK dout0_19 vdout0_19ck99 = 0 time = 500
* CHECK dout0_0 vdout0_0ck100 = 0 time = 505
* CHECK dout0_1 vdout0_1ck100 = 0.95 time = 505
* CHECK dout0_2 vdout0_2ck100 = 0 time = 505
* CHECK dout0_3 vdout0_3ck100 = 0 time = 505
* CHECK dout0_4 vdout0_4ck100 = 0.95 time = 505
* CHECK dout0_5 vdout0_5ck100 = 0.95 time = 505
* CHECK dout0_6 vdout0_6ck100 = 0 time = 505
* CHECK dout0_7 vdout0_7ck100 = 0 time = 505
* CHECK dout0_8 vdout0_8ck100 = 0.95 time = 505
* CHECK dout0_9 vdout0_9ck100 = 0.95 time = 505
* CHECK dout0_10 vdout0_10ck100 = 0 time = 505
* CHECK dout0_11 vdout0_11ck100 = 0 time = 505
* CHECK dout0_12 vdout0_12ck100 = 0 time = 505
* CHECK dout0_13 vdout0_13ck100 = 0 time = 505
* CHECK dout0_14 vdout0_14ck100 = 0 time = 505
* CHECK dout0_15 vdout0_15ck100 = 0 time = 505
* CHECK dout0_16 vdout0_16ck100 = 0 time = 505
* CHECK dout0_17 vdout0_17ck100 = 0.95 time = 505
* CHECK dout0_18 vdout0_18ck100 = 0.95 time = 505
* CHECK dout0_19 vdout0_19ck100 = 0 time = 505
* CHECK dout0_0 vdout0_0ck104 = 0 time = 525
* CHECK dout0_1 vdout0_1ck104 = 0 time = 525
* CHECK dout0_2 vdout0_2ck104 = 0 time = 525
* CHECK dout0_3 vdout0_3ck104 = 0 time = 525
* CHECK dout0_4 vdout0_4ck104 = 0 time = 525
* CHECK dout0_5 vdout0_5ck104 = 0 time = 525
* CHECK dout0_6 vdout0_6ck104 = 0.95 time = 525
* CHECK dout0_7 vdout0_7ck104 = 0.95 time = 525
* CHECK dout0_8 vdout0_8ck104 = 0.95 time = 525
* CHECK dout0_9 vdout0_9ck104 = 0 time = 525
* CHECK dout0_10 vdout0_10ck104 = 0 time = 525
* CHECK dout0_11 vdout0_11ck104 = 0 time = 525
* CHECK dout0_12 vdout0_12ck104 = 0.95 time = 525
* CHECK dout0_13 vdout0_13ck104 = 0 time = 525
* CHECK dout0_14 vdout0_14ck104 = 0.95 time = 525
* CHECK dout0_15 vdout0_15ck104 = 0.95 time = 525
* CHECK dout0_16 vdout0_16ck104 = 0.95 time = 525
* CHECK dout0_17 vdout0_17ck104 = 0 time = 525
* CHECK dout0_18 vdout0_18ck104 = 0 time = 525
* CHECK dout0_19 vdout0_19ck104 = 0 time = 525
* CHECK dout0_0 vdout0_0ck105 = 0 time = 530
* CHECK dout0_1 vdout0_1ck105 = 0 time = 530
* CHECK dout0_2 vdout0_2ck105 = 0 time = 530
* CHECK dout0_3 vdout0_3ck105 = 0 time = 530
* CHECK dout0_4 vdout0_4ck105 = 0 time = 530
* CHECK dout0_5 vdout0_5ck105 = 0 time = 530
* CHECK dout0_6 vdout0_6ck105 = 0.95 time = 530
* CHECK dout0_7 vdout0_7ck105 = 0.95 time = 530
* CHECK dout0_8 vdout0_8ck105 = 0.95 time = 530
* CHECK dout0_9 vdout0_9ck105 = 0 time = 530
* CHECK dout0_10 vdout0_10ck105 = 0 time = 530
* CHECK dout0_11 vdout0_11ck105 = 0 time = 530
* CHECK dout0_12 vdout0_12ck105 = 0.95 time = 530
* CHECK dout0_13 vdout0_13ck105 = 0 time = 530
* CHECK dout0_14 vdout0_14ck105 = 0.95 time = 530
* CHECK dout0_15 vdout0_15ck105 = 0.95 time = 530
* CHECK dout0_16 vdout0_16ck105 = 0.95 time = 530
* CHECK dout0_17 vdout0_17ck105 = 0 time = 530
* CHECK dout0_18 vdout0_18ck105 = 0 time = 530
* CHECK dout0_19 vdout0_19ck105 = 0 time = 530
* CHECK dout0_0 vdout0_0ck106 = 0 time = 535
* CHECK dout0_1 vdout0_1ck106 = 0 time = 535
* CHECK dout0_2 vdout0_2ck106 = 0.95 time = 535
* CHECK dout0_3 vdout0_3ck106 = 0 time = 535
* CHECK dout0_4 vdout0_4ck106 = 0 time = 535
* CHECK dout0_5 vdout0_5ck106 = 0.95 time = 535
* CHECK dout0_6 vdout0_6ck106 = 0.95 time = 535
* CHECK dout0_7 vdout0_7ck106 = 0.95 time = 535
* CHECK dout0_8 vdout0_8ck106 = 0 time = 535
* CHECK dout0_9 vdout0_9ck106 = 0 time = 535
* CHECK dout0_10 vdout0_10ck106 = 0.95 time = 535
* CHECK dout0_11 vdout0_11ck106 = 0 time = 535
* CHECK dout0_12 vdout0_12ck106 = 0.95 time = 535
* CHECK dout0_13 vdout0_13ck106 = 0.95 time = 535
* CHECK dout0_14 vdout0_14ck106 = 0 time = 535
* CHECK dout0_15 vdout0_15ck106 = 0 time = 535
* CHECK dout0_16 vdout0_16ck106 = 0 time = 535
* CHECK dout0_17 vdout0_17ck106 = 0 time = 535
* CHECK dout0_18 vdout0_18ck106 = 0 time = 535
* CHECK dout0_19 vdout0_19ck106 = 0 time = 535
* CHECK dout0_0 vdout0_0ck109 = 0 time = 550
* CHECK dout0_1 vdout0_1ck109 = 0 time = 550
* CHECK dout0_2 vdout0_2ck109 = 0 time = 550
* CHECK dout0_3 vdout0_3ck109 = 0 time = 550
* CHECK dout0_4 vdout0_4ck109 = 0.95 time = 550
* CHECK dout0_5 vdout0_5ck109 = 0.95 time = 550
* CHECK dout0_6 vdout0_6ck109 = 0 time = 550
* CHECK dout0_7 vdout0_7ck109 = 0.95 time = 550
* CHECK dout0_8 vdout0_8ck109 = 0 time = 550
* CHECK dout0_9 vdout0_9ck109 = 0 time = 550
* CHECK dout0_10 vdout0_10ck109 = 0 time = 550
* CHECK dout0_11 vdout0_11ck109 = 0 time = 550
* CHECK dout0_12 vdout0_12ck109 = 0 time = 550
* CHECK dout0_13 vdout0_13ck109 = 0.95 time = 550
* CHECK dout0_14 vdout0_14ck109 = 0.95 time = 550
* CHECK dout0_15 vdout0_15ck109 = 0.95 time = 550
* CHECK dout0_16 vdout0_16ck109 = 0 time = 550
* CHECK dout0_17 vdout0_17ck109 = 0 time = 550
* CHECK dout0_18 vdout0_18ck109 = 0.95 time = 550
* CHECK dout0_19 vdout0_19ck109 = 0.95 time = 550
* CHECK dout0_0 vdout0_0ck111 = 0 time = 560
* CHECK dout0_1 vdout0_1ck111 = 0.95 time = 560
* CHECK dout0_2 vdout0_2ck111 = 0 time = 560
* CHECK dout0_3 vdout0_3ck111 = 0 time = 560
* CHECK dout0_4 vdout0_4ck111 = 0.95 time = 560
* CHECK dout0_5 vdout0_5ck111 = 0.95 time = 560
* CHECK dout0_6 vdout0_6ck111 = 0 time = 560
* CHECK dout0_7 vdout0_7ck111 = 0 time = 560
* CHECK dout0_8 vdout0_8ck111 = 0.95 time = 560
* CHECK dout0_9 vdout0_9ck111 = 0.95 time = 560
* CHECK dout0_10 vdout0_10ck111 = 0 time = 560
* CHECK dout0_11 vdout0_11ck111 = 0 time = 560
* CHECK dout0_12 vdout0_12ck111 = 0 time = 560
* CHECK dout0_13 vdout0_13ck111 = 0 time = 560
* CHECK dout0_14 vdout0_14ck111 = 0 time = 560
* CHECK dout0_15 vdout0_15ck111 = 0 time = 560
* CHECK dout0_16 vdout0_16ck111 = 0 time = 560
* CHECK dout0_17 vdout0_17ck111 = 0.95 time = 560
* CHECK dout0_18 vdout0_18ck111 = 0.95 time = 560
* CHECK dout0_19 vdout0_19ck111 = 0 time = 560
* CHECK dout0_0 vdout0_0ck114 = 0.95 time = 575
* CHECK dout0_1 vdout0_1ck114 = 0.95 time = 575
* CHECK dout0_2 vdout0_2ck114 = 0 time = 575
* CHECK dout0_3 vdout0_3ck114 = 0 time = 575
* CHECK dout0_4 vdout0_4ck114 = 0.95 time = 575
* CHECK dout0_5 vdout0_5ck114 = 0 time = 575
* CHECK dout0_6 vdout0_6ck114 = 0 time = 575
* CHECK dout0_7 vdout0_7ck114 = 0.95 time = 575
* CHECK dout0_8 vdout0_8ck114 = 0 time = 575
* CHECK dout0_9 vdout0_9ck114 = 0.95 time = 575
* CHECK dout0_10 vdout0_10ck114 = 0 time = 575
* CHECK dout0_11 vdout0_11ck114 = 0.95 time = 575
* CHECK dout0_12 vdout0_12ck114 = 0.95 time = 575
* CHECK dout0_13 vdout0_13ck114 = 0 time = 575
* CHECK dout0_14 vdout0_14ck114 = 0.95 time = 575
* CHECK dout0_15 vdout0_15ck114 = 0.95 time = 575
* CHECK dout0_16 vdout0_16ck114 = 0.95 time = 575
* CHECK dout0_17 vdout0_17ck114 = 0.95 time = 575
* CHECK dout0_18 vdout0_18ck114 = 0 time = 575
* CHECK dout0_19 vdout0_19ck114 = 0.95 time = 575
* CHECK dout0_0 vdout0_0ck117 = 0.95 time = 590
* CHECK dout0_1 vdout0_1ck117 = 0 time = 590
* CHECK dout0_2 vdout0_2ck117 = 0.95 time = 590
* CHECK dout0_3 vdout0_3ck117 = 0.95 time = 590
* CHECK dout0_4 vdout0_4ck117 = 0 time = 590
* CHECK dout0_5 vdout0_5ck117 = 0 time = 590
* CHECK dout0_6 vdout0_6ck117 = 0.95 time = 590
* CHECK dout0_7 vdout0_7ck117 = 0.95 time = 590
* CHECK dout0_8 vdout0_8ck117 = 0 time = 590
* CHECK dout0_9 vdout0_9ck117 = 0.95 time = 590
* CHECK dout0_10 vdout0_10ck117 = 0 time = 590
* CHECK dout0_11 vdout0_11ck117 = 0.95 time = 590
* CHECK dout0_12 vdout0_12ck117 = 0.95 time = 590
* CHECK dout0_13 vdout0_13ck117 = 0 time = 590
* CHECK dout0_14 vdout0_14ck117 = 0 time = 590
* CHECK dout0_15 vdout0_15ck117 = 0 time = 590
* CHECK dout0_16 vdout0_16ck117 = 0.95 time = 590
* CHECK dout0_17 vdout0_17ck117 = 0.95 time = 590
* CHECK dout0_18 vdout0_18ck117 = 0 time = 590
* CHECK dout0_19 vdout0_19ck117 = 0.95 time = 590
* CHECK dout0_0 vdout0_0ck120 = 0 time = 605
* CHECK dout0_1 vdout0_1ck120 = 0 time = 605
* CHECK dout0_2 vdout0_2ck120 = 0 time = 605
* CHECK dout0_3 vdout0_3ck120 = 0.95 time = 605
* CHECK dout0_4 vdout0_4ck120 = 0.95 time = 605
* CHECK dout0_5 vdout0_5ck120 = 0 time = 605
* CHECK dout0_6 vdout0_6ck120 = 0.95 time = 605
* CHECK dout0_7 vdout0_7ck120 = 0 time = 605
* CHECK dout0_8 vdout0_8ck120 = 0 time = 605
* CHECK dout0_9 vdout0_9ck120 = 0 time = 605
* CHECK dout0_10 vdout0_10ck120 = 0.95 time = 605
* CHECK dout0_11 vdout0_11ck120 = 0 time = 605
* CHECK dout0_12 vdout0_12ck120 = 0 time = 605
* CHECK dout0_13 vdout0_13ck120 = 0.95 time = 605
* CHECK dout0_14 vdout0_14ck120 = 0.95 time = 605
* CHECK dout0_15 vdout0_15ck120 = 0.95 time = 605
* CHECK dout0_16 vdout0_16ck120 = 0.95 time = 605
* CHECK dout0_17 vdout0_17ck120 = 0 time = 605
* CHECK dout0_18 vdout0_18ck120 = 0 time = 605
* CHECK dout0_19 vdout0_19ck120 = 0 time = 605
* CHECK dout0_0 vdout0_0ck122 = 0 time = 615
* CHECK dout0_1 vdout0_1ck122 = 0.95 time = 615
* CHECK dout0_2 vdout0_2ck122 = 0 time = 615
* CHECK dout0_3 vdout0_3ck122 = 0 time = 615
* CHECK dout0_4 vdout0_4ck122 = 0 time = 615
* CHECK dout0_5 vdout0_5ck122 = 0 time = 615
* CHECK dout0_6 vdout0_6ck122 = 0 time = 615
* CHECK dout0_7 vdout0_7ck122 = 0.95 time = 615
* CHECK dout0_8 vdout0_8ck122 = 0 time = 615
* CHECK dout0_9 vdout0_9ck122 = 0 time = 615
* CHECK dout0_10 vdout0_10ck122 = 0 time = 615
* CHECK dout0_11 vdout0_11ck122 = 0 time = 615
* CHECK dout0_12 vdout0_12ck122 = 0 time = 615
* CHECK dout0_13 vdout0_13ck122 = 0.95 time = 615
* CHECK dout0_14 vdout0_14ck122 = 0.95 time = 615
* CHECK dout0_15 vdout0_15ck122 = 0 time = 615
* CHECK dout0_16 vdout0_16ck122 = 0.95 time = 615
* CHECK dout0_17 vdout0_17ck122 = 0 time = 615
* CHECK dout0_18 vdout0_18ck122 = 0.95 time = 615
* CHECK dout0_19 vdout0_19ck122 = 0 time = 615
* CHECK dout0_0 vdout0_0ck124 = 0.95 time = 625
* CHECK dout0_1 vdout0_1ck124 = 0 time = 625
* CHECK dout0_2 vdout0_2ck124 = 0 time = 625
* CHECK dout0_3 vdout0_3ck124 = 0.95 time = 625
* CHECK dout0_4 vdout0_4ck124 = 0.95 time = 625
* CHECK dout0_5 vdout0_5ck124 = 0.95 time = 625
* CHECK dout0_6 vdout0_6ck124 = 0 time = 625
* CHECK dout0_7 vdout0_7ck124 = 0 time = 625
* CHECK dout0_8 vdout0_8ck124 = 0 time = 625
* CHECK dout0_9 vdout0_9ck124 = 0.95 time = 625
* CHECK dout0_10 vdout0_10ck124 = 0 time = 625
* CHECK dout0_11 vdout0_11ck124 = 0.95 time = 625
* CHECK dout0_12 vdout0_12ck124 = 0.95 time = 625
* CHECK dout0_13 vdout0_13ck124 = 0 time = 625
* CHECK dout0_14 vdout0_14ck124 = 0.95 time = 625
* CHECK dout0_15 vdout0_15ck124 = 0 time = 625
* CHECK dout0_16 vdout0_16ck124 = 0.95 time = 625
* CHECK dout0_17 vdout0_17ck124 = 0.95 time = 625
* CHECK dout0_18 vdout0_18ck124 = 0.95 time = 625
* CHECK dout0_19 vdout0_19ck124 = 0 time = 625
* CHECK dout0_0 vdout0_0ck129 = 0.95 time = 650
* CHECK dout0_1 vdout0_1ck129 = 0 time = 650
* CHECK dout0_2 vdout0_2ck129 = 0.95 time = 650
* CHECK dout0_3 vdout0_3ck129 = 0.95 time = 650
* CHECK dout0_4 vdout0_4ck129 = 0.95 time = 650
* CHECK dout0_5 vdout0_5ck129 = 0.95 time = 650
* CHECK dout0_6 vdout0_6ck129 = 0.95 time = 650
* CHECK dout0_7 vdout0_7ck129 = 0 time = 650
* CHECK dout0_8 vdout0_8ck129 = 0 time = 650
* CHECK dout0_9 vdout0_9ck129 = 0.95 time = 650
* CHECK dout0_10 vdout0_10ck129 = 0 time = 650
* CHECK dout0_11 vdout0_11ck129 = 0.95 time = 650
* CHECK dout0_12 vdout0_12ck129 = 0 time = 650
* CHECK dout0_13 vdout0_13ck129 = 0 time = 650
* CHECK dout0_14 vdout0_14ck129 = 0 time = 650
* CHECK dout0_15 vdout0_15ck129 = 0 time = 650
* CHECK dout0_16 vdout0_16ck129 = 0.95 time = 650
* CHECK dout0_17 vdout0_17ck129 = 0.95 time = 650
* CHECK dout0_18 vdout0_18ck129 = 0.95 time = 650
* CHECK dout0_19 vdout0_19ck129 = 0 time = 650
* CHECK dout0_0 vdout0_0ck132 = 0.95 time = 665
* CHECK dout0_1 vdout0_1ck132 = 0.95 time = 665
* CHECK dout0_2 vdout0_2ck132 = 0 time = 665
* CHECK dout0_3 vdout0_3ck132 = 0 time = 665
* CHECK dout0_4 vdout0_4ck132 = 0 time = 665
* CHECK dout0_5 vdout0_5ck132 = 0.95 time = 665
* CHECK dout0_6 vdout0_6ck132 = 0.95 time = 665
* CHECK dout0_7 vdout0_7ck132 = 0.95 time = 665
* CHECK dout0_8 vdout0_8ck132 = 0 time = 665
* CHECK dout0_9 vdout0_9ck132 = 0 time = 665
* CHECK dout0_10 vdout0_10ck132 = 0.95 time = 665
* CHECK dout0_11 vdout0_11ck132 = 0 time = 665
* CHECK dout0_12 vdout0_12ck132 = 0.95 time = 665
* CHECK dout0_13 vdout0_13ck132 = 0 time = 665
* CHECK dout0_14 vdout0_14ck132 = 0 time = 665
* CHECK dout0_15 vdout0_15ck132 = 0.95 time = 665
* CHECK dout0_16 vdout0_16ck132 = 0 time = 665
* CHECK dout0_17 vdout0_17ck132 = 0.95 time = 665
* CHECK dout0_18 vdout0_18ck132 = 0 time = 665
* CHECK dout0_19 vdout0_19ck132 = 0.95 time = 665
* CHECK dout0_0 vdout0_0ck133 = 0.95 time = 670
* CHECK dout0_1 vdout0_1ck133 = 0 time = 670
* CHECK dout0_2 vdout0_2ck133 = 0.95 time = 670
* CHECK dout0_3 vdout0_3ck133 = 0.95 time = 670
* CHECK dout0_4 vdout0_4ck133 = 0.95 time = 670
* CHECK dout0_5 vdout0_5ck133 = 0.95 time = 670
* CHECK dout0_6 vdout0_6ck133 = 0.95 time = 670
* CHECK dout0_7 vdout0_7ck133 = 0 time = 670
* CHECK dout0_8 vdout0_8ck133 = 0 time = 670
* CHECK dout0_9 vdout0_9ck133 = 0.95 time = 670
* CHECK dout0_10 vdout0_10ck133 = 0 time = 670
* CHECK dout0_11 vdout0_11ck133 = 0.95 time = 670
* CHECK dout0_12 vdout0_12ck133 = 0 time = 670
* CHECK dout0_13 vdout0_13ck133 = 0 time = 670
* CHECK dout0_14 vdout0_14ck133 = 0 time = 670
* CHECK dout0_15 vdout0_15ck133 = 0 time = 670
* CHECK dout0_16 vdout0_16ck133 = 0.95 time = 670
* CHECK dout0_17 vdout0_17ck133 = 0.95 time = 670
* CHECK dout0_18 vdout0_18ck133 = 0.95 time = 670
* CHECK dout0_19 vdout0_19ck133 = 0 time = 670
* CHECK dout0_0 vdout0_0ck136 = 0.95 time = 685
* CHECK dout0_1 vdout0_1ck136 = 0 time = 685
* CHECK dout0_2 vdout0_2ck136 = 0.95 time = 685
* CHECK dout0_3 vdout0_3ck136 = 0.95 time = 685
* CHECK dout0_4 vdout0_4ck136 = 0.95 time = 685
* CHECK dout0_5 vdout0_5ck136 = 0.95 time = 685
* CHECK dout0_6 vdout0_6ck136 = 0.95 time = 685
* CHECK dout0_7 vdout0_7ck136 = 0 time = 685
* CHECK dout0_8 vdout0_8ck136 = 0 time = 685
* CHECK dout0_9 vdout0_9ck136 = 0.95 time = 685
* CHECK dout0_10 vdout0_10ck136 = 0 time = 685
* CHECK dout0_11 vdout0_11ck136 = 0.95 time = 685
* CHECK dout0_12 vdout0_12ck136 = 0 time = 685
* CHECK dout0_13 vdout0_13ck136 = 0 time = 685
* CHECK dout0_14 vdout0_14ck136 = 0 time = 685
* CHECK dout0_15 vdout0_15ck136 = 0 time = 685
* CHECK dout0_16 vdout0_16ck136 = 0.95 time = 685
* CHECK dout0_17 vdout0_17ck136 = 0.95 time = 685
* CHECK dout0_18 vdout0_18ck136 = 0.95 time = 685
* CHECK dout0_19 vdout0_19ck136 = 0 time = 685
* CHECK dout0_0 vdout0_0ck143 = 0.95 time = 720
* CHECK dout0_1 vdout0_1ck143 = 0.95 time = 720
* CHECK dout0_2 vdout0_2ck143 = 0.95 time = 720
* CHECK dout0_3 vdout0_3ck143 = 0 time = 720
* CHECK dout0_4 vdout0_4ck143 = 0.95 time = 720
* CHECK dout0_5 vdout0_5ck143 = 0.95 time = 720
* CHECK dout0_6 vdout0_6ck143 = 0 time = 720
* CHECK dout0_7 vdout0_7ck143 = 0.95 time = 720
* CHECK dout0_8 vdout0_8ck143 = 0.95 time = 720
* CHECK dout0_9 vdout0_9ck143 = 0 time = 720
* CHECK dout0_10 vdout0_10ck143 = 0.95 time = 720
* CHECK dout0_11 vdout0_11ck143 = 0 time = 720
* CHECK dout0_12 vdout0_12ck143 = 0.95 time = 720
* CHECK dout0_13 vdout0_13ck143 = 0 time = 720
* CHECK dout0_14 vdout0_14ck143 = 0.95 time = 720
* CHECK dout0_15 vdout0_15ck143 = 0.95 time = 720
* CHECK dout0_16 vdout0_16ck143 = 0 time = 720
* CHECK dout0_17 vdout0_17ck143 = 0.95 time = 720
* CHECK dout0_18 vdout0_18ck143 = 0 time = 720
* CHECK dout0_19 vdout0_19ck143 = 0 time = 720
* CHECK dout0_0 vdout0_0ck144 = 0 time = 725
* CHECK dout0_1 vdout0_1ck144 = 0 time = 725
* CHECK dout0_2 vdout0_2ck144 = 0.95 time = 725
* CHECK dout0_3 vdout0_3ck144 = 0 time = 725
* CHECK dout0_4 vdout0_4ck144 = 0 time = 725
* CHECK dout0_5 vdout0_5ck144 = 0 time = 725
* CHECK dout0_6 vdout0_6ck144 = 0.95 time = 725
* CHECK dout0_7 vdout0_7ck144 = 0.95 time = 725
* CHECK dout0_8 vdout0_8ck144 = 0.95 time = 725
* CHECK dout0_9 vdout0_9ck144 = 0.95 time = 725
* CHECK dout0_10 vdout0_10ck144 = 0 time = 725
* CHECK dout0_11 vdout0_11ck144 = 0 time = 725
* CHECK dout0_12 vdout0_12ck144 = 0 time = 725
* CHECK dout0_13 vdout0_13ck144 = 0 time = 725
* CHECK dout0_14 vdout0_14ck144 = 0.95 time = 725
* CHECK dout0_15 vdout0_15ck144 = 0 time = 725
* CHECK dout0_16 vdout0_16ck144 = 0.95 time = 725
* CHECK dout0_17 vdout0_17ck144 = 0 time = 725
* CHECK dout0_18 vdout0_18ck144 = 0 time = 725
* CHECK dout0_19 vdout0_19ck144 = 0 time = 725
* CHECK dout0_0 vdout0_0ck145 = 0.95 time = 730
* CHECK dout0_1 vdout0_1ck145 = 0.95 time = 730
* CHECK dout0_2 vdout0_2ck145 = 0.95 time = 730
* CHECK dout0_3 vdout0_3ck145 = 0 time = 730
* CHECK dout0_4 vdout0_4ck145 = 0.95 time = 730
* CHECK dout0_5 vdout0_5ck145 = 0.95 time = 730
* CHECK dout0_6 vdout0_6ck145 = 0 time = 730
* CHECK dout0_7 vdout0_7ck145 = 0.95 time = 730
* CHECK dout0_8 vdout0_8ck145 = 0.95 time = 730
* CHECK dout0_9 vdout0_9ck145 = 0 time = 730
* CHECK dout0_10 vdout0_10ck145 = 0.95 time = 730
* CHECK dout0_11 vdout0_11ck145 = 0 time = 730
* CHECK dout0_12 vdout0_12ck145 = 0.95 time = 730
* CHECK dout0_13 vdout0_13ck145 = 0 time = 730
* CHECK dout0_14 vdout0_14ck145 = 0.95 time = 730
* CHECK dout0_15 vdout0_15ck145 = 0.95 time = 730
* CHECK dout0_16 vdout0_16ck145 = 0 time = 730
* CHECK dout0_17 vdout0_17ck145 = 0.95 time = 730
* CHECK dout0_18 vdout0_18ck145 = 0 time = 730
* CHECK dout0_19 vdout0_19ck145 = 0 time = 730
* CHECK dout0_0 vdout0_0ck148 = 0.95 time = 745
* CHECK dout0_1 vdout0_1ck148 = 0 time = 745
* CHECK dout0_2 vdout0_2ck148 = 0.95 time = 745
* CHECK dout0_3 vdout0_3ck148 = 0.95 time = 745
* CHECK dout0_4 vdout0_4ck148 = 0 time = 745
* CHECK dout0_5 vdout0_5ck148 = 0 time = 745
* CHECK dout0_6 vdout0_6ck148 = 0.95 time = 745
* CHECK dout0_7 vdout0_7ck148 = 0.95 time = 745
* CHECK dout0_8 vdout0_8ck148 = 0 time = 745
* CHECK dout0_9 vdout0_9ck148 = 0.95 time = 745
* CHECK dout0_10 vdout0_10ck148 = 0 time = 745
* CHECK dout0_11 vdout0_11ck148 = 0.95 time = 745
* CHECK dout0_12 vdout0_12ck148 = 0.95 time = 745
* CHECK dout0_13 vdout0_13ck148 = 0 time = 745
* CHECK dout0_14 vdout0_14ck148 = 0 time = 745
* CHECK dout0_15 vdout0_15ck148 = 0 time = 745
* CHECK dout0_16 vdout0_16ck148 = 0.95 time = 745
* CHECK dout0_17 vdout0_17ck148 = 0.95 time = 745
* CHECK dout0_18 vdout0_18ck148 = 0 time = 745
* CHECK dout0_19 vdout0_19ck148 = 0.95 time = 745
* CHECK dout0_0 vdout0_0ck150 = 0.95 time = 755
* CHECK dout0_1 vdout0_1ck150 = 0.95 time = 755
* CHECK dout0_2 vdout0_2ck150 = 0 time = 755
* CHECK dout0_3 vdout0_3ck150 = 0 time = 755
* CHECK dout0_4 vdout0_4ck150 = 0 time = 755
* CHECK dout0_5 vdout0_5ck150 = 0 time = 755
* CHECK dout0_6 vdout0_6ck150 = 0 time = 755
* CHECK dout0_7 vdout0_7ck150 = 0.95 time = 755
* CHECK dout0_8 vdout0_8ck150 = 0 time = 755
* CHECK dout0_9 vdout0_9ck150 = 0.95 time = 755
* CHECK dout0_10 vdout0_10ck150 = 0.95 time = 755
* CHECK dout0_11 vdout0_11ck150 = 0.95 time = 755
* CHECK dout0_12 vdout0_12ck150 = 0.95 time = 755
* CHECK dout0_13 vdout0_13ck150 = 0 time = 755
* CHECK dout0_14 vdout0_14ck150 = 0.95 time = 755
* CHECK dout0_15 vdout0_15ck150 = 0.95 time = 755
* CHECK dout0_16 vdout0_16ck150 = 0 time = 755
* CHECK dout0_17 vdout0_17ck150 = 0 time = 755
* CHECK dout0_18 vdout0_18ck150 = 0 time = 755
* CHECK dout0_19 vdout0_19ck150 = 0 time = 755
* CHECK dout0_0 vdout0_0ck151 = 0.95 time = 760
* CHECK dout0_1 vdout0_1ck151 = 0.95 time = 760
* CHECK dout0_2 vdout0_2ck151 = 0 time = 760
* CHECK dout0_3 vdout0_3ck151 = 0 time = 760
* CHECK dout0_4 vdout0_4ck151 = 0 time = 760
* CHECK dout0_5 vdout0_5ck151 = 0 time = 760
* CHECK dout0_6 vdout0_6ck151 = 0 time = 760
* CHECK dout0_7 vdout0_7ck151 = 0.95 time = 760
* CHECK dout0_8 vdout0_8ck151 = 0 time = 760
* CHECK dout0_9 vdout0_9ck151 = 0.95 time = 760
* CHECK dout0_10 vdout0_10ck151 = 0.95 time = 760
* CHECK dout0_11 vdout0_11ck151 = 0.95 time = 760
* CHECK dout0_12 vdout0_12ck151 = 0.95 time = 760
* CHECK dout0_13 vdout0_13ck151 = 0 time = 760
* CHECK dout0_14 vdout0_14ck151 = 0.95 time = 760
* CHECK dout0_15 vdout0_15ck151 = 0.95 time = 760
* CHECK dout0_16 vdout0_16ck151 = 0 time = 760
* CHECK dout0_17 vdout0_17ck151 = 0 time = 760
* CHECK dout0_18 vdout0_18ck151 = 0 time = 760
* CHECK dout0_19 vdout0_19ck151 = 0 time = 760
* CHECK dout0_0 vdout0_0ck152 = 0.95 time = 765
* CHECK dout0_1 vdout0_1ck152 = 0.95 time = 765
* CHECK dout0_2 vdout0_2ck152 = 0.95 time = 765
* CHECK dout0_3 vdout0_3ck152 = 0.95 time = 765
* CHECK dout0_4 vdout0_4ck152 = 0.95 time = 765
* CHECK dout0_5 vdout0_5ck152 = 0 time = 765
* CHECK dout0_6 vdout0_6ck152 = 0.95 time = 765
* CHECK dout0_7 vdout0_7ck152 = 0 time = 765
* CHECK dout0_8 vdout0_8ck152 = 0.95 time = 765
* CHECK dout0_9 vdout0_9ck152 = 0.95 time = 765
* CHECK dout0_10 vdout0_10ck152 = 0 time = 765
* CHECK dout0_11 vdout0_11ck152 = 0 time = 765
* CHECK dout0_12 vdout0_12ck152 = 0 time = 765
* CHECK dout0_13 vdout0_13ck152 = 0.95 time = 765
* CHECK dout0_14 vdout0_14ck152 = 0.95 time = 765
* CHECK dout0_15 vdout0_15ck152 = 0.95 time = 765
* CHECK dout0_16 vdout0_16ck152 = 0 time = 765
* CHECK dout0_17 vdout0_17ck152 = 0.95 time = 765
* CHECK dout0_18 vdout0_18ck152 = 0 time = 765
* CHECK dout0_19 vdout0_19ck152 = 0 time = 765
* CHECK dout0_0 vdout0_0ck155 = 0 time = 780
* CHECK dout0_1 vdout0_1ck155 = 0 time = 780
* CHECK dout0_2 vdout0_2ck155 = 0.95 time = 780
* CHECK dout0_3 vdout0_3ck155 = 0 time = 780
* CHECK dout0_4 vdout0_4ck155 = 0 time = 780
* CHECK dout0_5 vdout0_5ck155 = 0 time = 780
* CHECK dout0_6 vdout0_6ck155 = 0.95 time = 780
* CHECK dout0_7 vdout0_7ck155 = 0.95 time = 780
* CHECK dout0_8 vdout0_8ck155 = 0.95 time = 780
* CHECK dout0_9 vdout0_9ck155 = 0.95 time = 780
* CHECK dout0_10 vdout0_10ck155 = 0 time = 780
* CHECK dout0_11 vdout0_11ck155 = 0 time = 780
* CHECK dout0_12 vdout0_12ck155 = 0 time = 780
* CHECK dout0_13 vdout0_13ck155 = 0 time = 780
* CHECK dout0_14 vdout0_14ck155 = 0.95 time = 780
* CHECK dout0_15 vdout0_15ck155 = 0 time = 780
* CHECK dout0_16 vdout0_16ck155 = 0.95 time = 780
* CHECK dout0_17 vdout0_17ck155 = 0 time = 780
* CHECK dout0_18 vdout0_18ck155 = 0 time = 780
* CHECK dout0_19 vdout0_19ck155 = 0 time = 780
* CHECK dout0_0 vdout0_0ck156 = 0.95 time = 785
* CHECK dout0_1 vdout0_1ck156 = 0.95 time = 785
* CHECK dout0_2 vdout0_2ck156 = 0 time = 785
* CHECK dout0_3 vdout0_3ck156 = 0 time = 785
* CHECK dout0_4 vdout0_4ck156 = 0.95 time = 785
* CHECK dout0_5 vdout0_5ck156 = 0 time = 785
* CHECK dout0_6 vdout0_6ck156 = 0.95 time = 785
* CHECK dout0_7 vdout0_7ck156 = 0.95 time = 785
* CHECK dout0_8 vdout0_8ck156 = 0 time = 785
* CHECK dout0_9 vdout0_9ck156 = 0.95 time = 785
* CHECK dout0_10 vdout0_10ck156 = 0 time = 785
* CHECK dout0_11 vdout0_11ck156 = 0.95 time = 785
* CHECK dout0_12 vdout0_12ck156 = 0.95 time = 785
* CHECK dout0_13 vdout0_13ck156 = 0 time = 785
* CHECK dout0_14 vdout0_14ck156 = 0.95 time = 785
* CHECK dout0_15 vdout0_15ck156 = 0 time = 785
* CHECK dout0_16 vdout0_16ck156 = 0 time = 785
* CHECK dout0_17 vdout0_17ck156 = 0 time = 785
* CHECK dout0_18 vdout0_18ck156 = 0 time = 785
* CHECK dout0_19 vdout0_19ck156 = 0 time = 785
* CHECK dout0_0 vdout0_0ck157 = 0 time = 790
* CHECK dout0_1 vdout0_1ck157 = 0.95 time = 790
* CHECK dout0_2 vdout0_2ck157 = 0 time = 790
* CHECK dout0_3 vdout0_3ck157 = 0 time = 790
* CHECK dout0_4 vdout0_4ck157 = 0.95 time = 790
* CHECK dout0_5 vdout0_5ck157 = 0 time = 790
* CHECK dout0_6 vdout0_6ck157 = 0.95 time = 790
* CHECK dout0_7 vdout0_7ck157 = 0 time = 790
* CHECK dout0_8 vdout0_8ck157 = 0.95 time = 790
* CHECK dout0_9 vdout0_9ck157 = 0 time = 790
* CHECK dout0_10 vdout0_10ck157 = 0 time = 790
* CHECK dout0_11 vdout0_11ck157 = 0.95 time = 790
* CHECK dout0_12 vdout0_12ck157 = 0 time = 790
* CHECK dout0_13 vdout0_13ck157 = 0 time = 790
* CHECK dout0_14 vdout0_14ck157 = 0.95 time = 790
* CHECK dout0_15 vdout0_15ck157 = 0 time = 790
* CHECK dout0_16 vdout0_16ck157 = 0 time = 790
* CHECK dout0_17 vdout0_17ck157 = 0.95 time = 790
* CHECK dout0_18 vdout0_18ck157 = 0.95 time = 790
* CHECK dout0_19 vdout0_19ck157 = 0.95 time = 790
* CHECK dout0_0 vdout0_0ck158 = 0.95 time = 795
* CHECK dout0_1 vdout0_1ck158 = 0 time = 795
* CHECK dout0_2 vdout0_2ck158 = 0.95 time = 795
* CHECK dout0_3 vdout0_3ck158 = 0.95 time = 795
* CHECK dout0_4 vdout0_4ck158 = 0.95 time = 795
* CHECK dout0_5 vdout0_5ck158 = 0.95 time = 795
* CHECK dout0_6 vdout0_6ck158 = 0.95 time = 795
* CHECK dout0_7 vdout0_7ck158 = 0 time = 795
* CHECK dout0_8 vdout0_8ck158 = 0 time = 795
* CHECK dout0_9 vdout0_9ck158 = 0.95 time = 795
* CHECK dout0_10 vdout0_10ck158 = 0 time = 795
* CHECK dout0_11 vdout0_11ck158 = 0.95 time = 795
* CHECK dout0_12 vdout0_12ck158 = 0 time = 795
* CHECK dout0_13 vdout0_13ck158 = 0 time = 795
* CHECK dout0_14 vdout0_14ck158 = 0 time = 795
* CHECK dout0_15 vdout0_15ck158 = 0 time = 795
* CHECK dout0_16 vdout0_16ck158 = 0.95 time = 795
* CHECK dout0_17 vdout0_17ck158 = 0.95 time = 795
* CHECK dout0_18 vdout0_18ck158 = 0.95 time = 795
* CHECK dout0_19 vdout0_19ck158 = 0 time = 795
* CHECK dout0_0 vdout0_0ck159 = 0.95 time = 800
* CHECK dout0_1 vdout0_1ck159 = 0 time = 800
* CHECK dout0_2 vdout0_2ck159 = 0.95 time = 800
* CHECK dout0_3 vdout0_3ck159 = 0.95 time = 800
* CHECK dout0_4 vdout0_4ck159 = 0.95 time = 800
* CHECK dout0_5 vdout0_5ck159 = 0.95 time = 800
* CHECK dout0_6 vdout0_6ck159 = 0.95 time = 800
* CHECK dout0_7 vdout0_7ck159 = 0 time = 800
* CHECK dout0_8 vdout0_8ck159 = 0 time = 800
* CHECK dout0_9 vdout0_9ck159 = 0.95 time = 800
* CHECK dout0_10 vdout0_10ck159 = 0 time = 800
* CHECK dout0_11 vdout0_11ck159 = 0.95 time = 800
* CHECK dout0_12 vdout0_12ck159 = 0 time = 800
* CHECK dout0_13 vdout0_13ck159 = 0 time = 800
* CHECK dout0_14 vdout0_14ck159 = 0 time = 800
* CHECK dout0_15 vdout0_15ck159 = 0 time = 800
* CHECK dout0_16 vdout0_16ck159 = 0.95 time = 800
* CHECK dout0_17 vdout0_17ck159 = 0.95 time = 800
* CHECK dout0_18 vdout0_18ck159 = 0.95 time = 800
* CHECK dout0_19 vdout0_19ck159 = 0 time = 800
* CHECK dout0_0 vdout0_0ck164 = 0 time = 825
* CHECK dout0_1 vdout0_1ck164 = 0.95 time = 825
* CHECK dout0_2 vdout0_2ck164 = 0.95 time = 825
* CHECK dout0_3 vdout0_3ck164 = 0.95 time = 825
* CHECK dout0_4 vdout0_4ck164 = 0.95 time = 825
* CHECK dout0_5 vdout0_5ck164 = 0 time = 825
* CHECK dout0_6 vdout0_6ck164 = 0.95 time = 825
* CHECK dout0_7 vdout0_7ck164 = 0.95 time = 825
* CHECK dout0_8 vdout0_8ck164 = 0.95 time = 825
* CHECK dout0_9 vdout0_9ck164 = 0 time = 825
* CHECK dout0_10 vdout0_10ck164 = 0 time = 825
* CHECK dout0_11 vdout0_11ck164 = 0 time = 825
* CHECK dout0_12 vdout0_12ck164 = 0.95 time = 825
* CHECK dout0_13 vdout0_13ck164 = 0 time = 825
* CHECK dout0_14 vdout0_14ck164 = 0 time = 825
* CHECK dout0_15 vdout0_15ck164 = 0.95 time = 825
* CHECK dout0_16 vdout0_16ck164 = 0 time = 825
* CHECK dout0_17 vdout0_17ck164 = 0 time = 825
* CHECK dout0_18 vdout0_18ck164 = 0.95 time = 825
* CHECK dout0_19 vdout0_19ck164 = 0 time = 825
* CHECK dout0_0 vdout0_0ck165 = 0 time = 830
* CHECK dout0_1 vdout0_1ck165 = 0.95 time = 830
* CHECK dout0_2 vdout0_2ck165 = 0.95 time = 830
* CHECK dout0_3 vdout0_3ck165 = 0.95 time = 830
* CHECK dout0_4 vdout0_4ck165 = 0.95 time = 830
* CHECK dout0_5 vdout0_5ck165 = 0 time = 830
* CHECK dout0_6 vdout0_6ck165 = 0.95 time = 830
* CHECK dout0_7 vdout0_7ck165 = 0.95 time = 830
* CHECK dout0_8 vdout0_8ck165 = 0.95 time = 830
* CHECK dout0_9 vdout0_9ck165 = 0 time = 830
* CHECK dout0_10 vdout0_10ck165 = 0 time = 830
* CHECK dout0_11 vdout0_11ck165 = 0 time = 830
* CHECK dout0_12 vdout0_12ck165 = 0.95 time = 830
* CHECK dout0_13 vdout0_13ck165 = 0 time = 830
* CHECK dout0_14 vdout0_14ck165 = 0 time = 830
* CHECK dout0_15 vdout0_15ck165 = 0.95 time = 830
* CHECK dout0_16 vdout0_16ck165 = 0 time = 830
* CHECK dout0_17 vdout0_17ck165 = 0 time = 830
* CHECK dout0_18 vdout0_18ck165 = 0.95 time = 830
* CHECK dout0_19 vdout0_19ck165 = 0 time = 830
* CHECK dout0_0 vdout0_0ck166 = 0.95 time = 835
* CHECK dout0_1 vdout0_1ck166 = 0.95 time = 835
* CHECK dout0_2 vdout0_2ck166 = 0 time = 835
* CHECK dout0_3 vdout0_3ck166 = 0 time = 835
* CHECK dout0_4 vdout0_4ck166 = 0 time = 835
* CHECK dout0_5 vdout0_5ck166 = 0 time = 835
* CHECK dout0_6 vdout0_6ck166 = 0 time = 835
* CHECK dout0_7 vdout0_7ck166 = 0.95 time = 835
* CHECK dout0_8 vdout0_8ck166 = 0 time = 835
* CHECK dout0_9 vdout0_9ck166 = 0.95 time = 835
* CHECK dout0_10 vdout0_10ck166 = 0.95 time = 835
* CHECK dout0_11 vdout0_11ck166 = 0.95 time = 835
* CHECK dout0_12 vdout0_12ck166 = 0.95 time = 835
* CHECK dout0_13 vdout0_13ck166 = 0 time = 835
* CHECK dout0_14 vdout0_14ck166 = 0.95 time = 835
* CHECK dout0_15 vdout0_15ck166 = 0.95 time = 835
* CHECK dout0_16 vdout0_16ck166 = 0 time = 835
* CHECK dout0_17 vdout0_17ck166 = 0 time = 835
* CHECK dout0_18 vdout0_18ck166 = 0 time = 835
* CHECK dout0_19 vdout0_19ck166 = 0 time = 835
* CHECK dout0_0 vdout0_0ck167 = 0.95 time = 840
* CHECK dout0_1 vdout0_1ck167 = 0.95 time = 840
* CHECK dout0_2 vdout0_2ck167 = 0.95 time = 840
* CHECK dout0_3 vdout0_3ck167 = 0 time = 840
* CHECK dout0_4 vdout0_4ck167 = 0.95 time = 840
* CHECK dout0_5 vdout0_5ck167 = 0.95 time = 840
* CHECK dout0_6 vdout0_6ck167 = 0 time = 840
* CHECK dout0_7 vdout0_7ck167 = 0.95 time = 840
* CHECK dout0_8 vdout0_8ck167 = 0.95 time = 840
* CHECK dout0_9 vdout0_9ck167 = 0 time = 840
* CHECK dout0_10 vdout0_10ck167 = 0.95 time = 840
* CHECK dout0_11 vdout0_11ck167 = 0 time = 840
* CHECK dout0_12 vdout0_12ck167 = 0.95 time = 840
* CHECK dout0_13 vdout0_13ck167 = 0 time = 840
* CHECK dout0_14 vdout0_14ck167 = 0.95 time = 840
* CHECK dout0_15 vdout0_15ck167 = 0.95 time = 840
* CHECK dout0_16 vdout0_16ck167 = 0 time = 840
* CHECK dout0_17 vdout0_17ck167 = 0.95 time = 840
* CHECK dout0_18 vdout0_18ck167 = 0 time = 840
* CHECK dout0_19 vdout0_19ck167 = 0 time = 840
* CHECK dout0_0 vdout0_0ck168 = 0.95 time = 845
* CHECK dout0_1 vdout0_1ck168 = 0 time = 845
* CHECK dout0_2 vdout0_2ck168 = 0.95 time = 845
* CHECK dout0_3 vdout0_3ck168 = 0.95 time = 845
* CHECK dout0_4 vdout0_4ck168 = 0.95 time = 845
* CHECK dout0_5 vdout0_5ck168 = 0 time = 845
* CHECK dout0_6 vdout0_6ck168 = 0 time = 845
* CHECK dout0_7 vdout0_7ck168 = 0 time = 845
* CHECK dout0_8 vdout0_8ck168 = 0 time = 845
* CHECK dout0_9 vdout0_9ck168 = 0.95 time = 845
* CHECK dout0_10 vdout0_10ck168 = 0 time = 845
* CHECK dout0_11 vdout0_11ck168 = 0.95 time = 845
* CHECK dout0_12 vdout0_12ck168 = 0 time = 845
* CHECK dout0_13 vdout0_13ck168 = 0 time = 845
* CHECK dout0_14 vdout0_14ck168 = 0 time = 845
* CHECK dout0_15 vdout0_15ck168 = 0.95 time = 845
* CHECK dout0_16 vdout0_16ck168 = 0 time = 845
* CHECK dout0_17 vdout0_17ck168 = 0 time = 845
* CHECK dout0_18 vdout0_18ck168 = 0 time = 845
* CHECK dout0_19 vdout0_19ck168 = 0.95 time = 845
* CHECK dout0_0 vdout0_0ck169 = 0.95 time = 850
* CHECK dout0_1 vdout0_1ck169 = 0 time = 850
* CHECK dout0_2 vdout0_2ck169 = 0.95 time = 850
* CHECK dout0_3 vdout0_3ck169 = 0.95 time = 850
* CHECK dout0_4 vdout0_4ck169 = 0 time = 850
* CHECK dout0_5 vdout0_5ck169 = 0 time = 850
* CHECK dout0_6 vdout0_6ck169 = 0.95 time = 850
* CHECK dout0_7 vdout0_7ck169 = 0.95 time = 850
* CHECK dout0_8 vdout0_8ck169 = 0 time = 850
* CHECK dout0_9 vdout0_9ck169 = 0.95 time = 850
* CHECK dout0_10 vdout0_10ck169 = 0 time = 850
* CHECK dout0_11 vdout0_11ck169 = 0.95 time = 850
* CHECK dout0_12 vdout0_12ck169 = 0.95 time = 850
* CHECK dout0_13 vdout0_13ck169 = 0 time = 850
* CHECK dout0_14 vdout0_14ck169 = 0 time = 850
* CHECK dout0_15 vdout0_15ck169 = 0 time = 850
* CHECK dout0_16 vdout0_16ck169 = 0.95 time = 850
* CHECK dout0_17 vdout0_17ck169 = 0.95 time = 850
* CHECK dout0_18 vdout0_18ck169 = 0 time = 850
* CHECK dout0_19 vdout0_19ck169 = 0.95 time = 850
* CHECK dout0_0 vdout0_0ck170 = 0.95 time = 855
* CHECK dout0_1 vdout0_1ck170 = 0 time = 855
* CHECK dout0_2 vdout0_2ck170 = 0.95 time = 855
* CHECK dout0_3 vdout0_3ck170 = 0.95 time = 855
* CHECK dout0_4 vdout0_4ck170 = 0.95 time = 855
* CHECK dout0_5 vdout0_5ck170 = 0 time = 855
* CHECK dout0_6 vdout0_6ck170 = 0 time = 855
* CHECK dout0_7 vdout0_7ck170 = 0 time = 855
* CHECK dout0_8 vdout0_8ck170 = 0 time = 855
* CHECK dout0_9 vdout0_9ck170 = 0.95 time = 855
* CHECK dout0_10 vdout0_10ck170 = 0 time = 855
* CHECK dout0_11 vdout0_11ck170 = 0.95 time = 855
* CHECK dout0_12 vdout0_12ck170 = 0 time = 855
* CHECK dout0_13 vdout0_13ck170 = 0 time = 855
* CHECK dout0_14 vdout0_14ck170 = 0 time = 855
* CHECK dout0_15 vdout0_15ck170 = 0.95 time = 855
* CHECK dout0_16 vdout0_16ck170 = 0 time = 855
* CHECK dout0_17 vdout0_17ck170 = 0 time = 855
* CHECK dout0_18 vdout0_18ck170 = 0 time = 855
* CHECK dout0_19 vdout0_19ck170 = 0.95 time = 855
* CHECK dout0_0 vdout0_0ck172 = 0.95 time = 865
* CHECK dout0_1 vdout0_1ck172 = 0 time = 865
* CHECK dout0_2 vdout0_2ck172 = 0.95 time = 865
* CHECK dout0_3 vdout0_3ck172 = 0.95 time = 865
* CHECK dout0_4 vdout0_4ck172 = 0.95 time = 865
* CHECK dout0_5 vdout0_5ck172 = 0 time = 865
* CHECK dout0_6 vdout0_6ck172 = 0 time = 865
* CHECK dout0_7 vdout0_7ck172 = 0 time = 865
* CHECK dout0_8 vdout0_8ck172 = 0 time = 865
* CHECK dout0_9 vdout0_9ck172 = 0.95 time = 865
* CHECK dout0_10 vdout0_10ck172 = 0 time = 865
* CHECK dout0_11 vdout0_11ck172 = 0.95 time = 865
* CHECK dout0_12 vdout0_12ck172 = 0 time = 865
* CHECK dout0_13 vdout0_13ck172 = 0 time = 865
* CHECK dout0_14 vdout0_14ck172 = 0 time = 865
* CHECK dout0_15 vdout0_15ck172 = 0.95 time = 865
* CHECK dout0_16 vdout0_16ck172 = 0 time = 865
* CHECK dout0_17 vdout0_17ck172 = 0 time = 865
* CHECK dout0_18 vdout0_18ck172 = 0 time = 865
* CHECK dout0_19 vdout0_19ck172 = 0.95 time = 865
* CHECK dout0_0 vdout0_0ck173 = 0 time = 870
* CHECK dout0_1 vdout0_1ck173 = 0.95 time = 870
* CHECK dout0_2 vdout0_2ck173 = 0 time = 870
* CHECK dout0_3 vdout0_3ck173 = 0 time = 870
* CHECK dout0_4 vdout0_4ck173 = 0.95 time = 870
* CHECK dout0_5 vdout0_5ck173 = 0 time = 870
* CHECK dout0_6 vdout0_6ck173 = 0.95 time = 870
* CHECK dout0_7 vdout0_7ck173 = 0 time = 870
* CHECK dout0_8 vdout0_8ck173 = 0.95 time = 870
* CHECK dout0_9 vdout0_9ck173 = 0 time = 870
* CHECK dout0_10 vdout0_10ck173 = 0 time = 870
* CHECK dout0_11 vdout0_11ck173 = 0.95 time = 870
* CHECK dout0_12 vdout0_12ck173 = 0 time = 870
* CHECK dout0_13 vdout0_13ck173 = 0 time = 870
* CHECK dout0_14 vdout0_14ck173 = 0.95 time = 870
* CHECK dout0_15 vdout0_15ck173 = 0 time = 870
* CHECK dout0_16 vdout0_16ck173 = 0 time = 870
* CHECK dout0_17 vdout0_17ck173 = 0.95 time = 870
* CHECK dout0_18 vdout0_18ck173 = 0.95 time = 870
* CHECK dout0_19 vdout0_19ck173 = 0.95 time = 870
* CHECK dout0_0 vdout0_0ck175 = 0.95 time = 880
* CHECK dout0_1 vdout0_1ck175 = 0.95 time = 880
* CHECK dout0_2 vdout0_2ck175 = 0 time = 880
* CHECK dout0_3 vdout0_3ck175 = 0 time = 880
* CHECK dout0_4 vdout0_4ck175 = 0.95 time = 880
* CHECK dout0_5 vdout0_5ck175 = 0 time = 880
* CHECK dout0_6 vdout0_6ck175 = 0.95 time = 880
* CHECK dout0_7 vdout0_7ck175 = 0.95 time = 880
* CHECK dout0_8 vdout0_8ck175 = 0 time = 880
* CHECK dout0_9 vdout0_9ck175 = 0.95 time = 880
* CHECK dout0_10 vdout0_10ck175 = 0 time = 880
* CHECK dout0_11 vdout0_11ck175 = 0.95 time = 880
* CHECK dout0_12 vdout0_12ck175 = 0.95 time = 880
* CHECK dout0_13 vdout0_13ck175 = 0 time = 880
* CHECK dout0_14 vdout0_14ck175 = 0.95 time = 880
* CHECK dout0_15 vdout0_15ck175 = 0 time = 880
* CHECK dout0_16 vdout0_16ck175 = 0 time = 880
* CHECK dout0_17 vdout0_17ck175 = 0 time = 880
* CHECK dout0_18 vdout0_18ck175 = 0 time = 880
* CHECK dout0_19 vdout0_19ck175 = 0 time = 880
* CHECK dout0_0 vdout0_0ck181 = 0.95 time = 910
* CHECK dout0_1 vdout0_1ck181 = 0.95 time = 910
* CHECK dout0_2 vdout0_2ck181 = 0.95 time = 910
* CHECK dout0_3 vdout0_3ck181 = 0 time = 910
* CHECK dout0_4 vdout0_4ck181 = 0.95 time = 910
* CHECK dout0_5 vdout0_5ck181 = 0.95 time = 910
* CHECK dout0_6 vdout0_6ck181 = 0 time = 910
* CHECK dout0_7 vdout0_7ck181 = 0.95 time = 910
* CHECK dout0_8 vdout0_8ck181 = 0.95 time = 910
* CHECK dout0_9 vdout0_9ck181 = 0 time = 910
* CHECK dout0_10 vdout0_10ck181 = 0.95 time = 910
* CHECK dout0_11 vdout0_11ck181 = 0 time = 910
* CHECK dout0_12 vdout0_12ck181 = 0.95 time = 910
* CHECK dout0_13 vdout0_13ck181 = 0 time = 910
* CHECK dout0_14 vdout0_14ck181 = 0.95 time = 910
* CHECK dout0_15 vdout0_15ck181 = 0.95 time = 910
* CHECK dout0_16 vdout0_16ck181 = 0 time = 910
* CHECK dout0_17 vdout0_17ck181 = 0.95 time = 910
* CHECK dout0_18 vdout0_18ck181 = 0 time = 910
* CHECK dout0_19 vdout0_19ck181 = 0 time = 910
* CHECK dout0_0 vdout0_0ck182 = 0.95 time = 915
* CHECK dout0_1 vdout0_1ck182 = 0.95 time = 915
* CHECK dout0_2 vdout0_2ck182 = 0.95 time = 915
* CHECK dout0_3 vdout0_3ck182 = 0 time = 915
* CHECK dout0_4 vdout0_4ck182 = 0.95 time = 915
* CHECK dout0_5 vdout0_5ck182 = 0 time = 915
* CHECK dout0_6 vdout0_6ck182 = 0 time = 915
* CHECK dout0_7 vdout0_7ck182 = 0 time = 915
* CHECK dout0_8 vdout0_8ck182 = 0 time = 915
* CHECK dout0_9 vdout0_9ck182 = 0.95 time = 915
* CHECK dout0_10 vdout0_10ck182 = 0 time = 915
* CHECK dout0_11 vdout0_11ck182 = 0.95 time = 915
* CHECK dout0_12 vdout0_12ck182 = 0.95 time = 915
* CHECK dout0_13 vdout0_13ck182 = 0.95 time = 915
* CHECK dout0_14 vdout0_14ck182 = 0 time = 915
* CHECK dout0_15 vdout0_15ck182 = 0.95 time = 915
* CHECK dout0_16 vdout0_16ck182 = 0 time = 915
* CHECK dout0_17 vdout0_17ck182 = 0.95 time = 915
* CHECK dout0_18 vdout0_18ck182 = 0.95 time = 915
* CHECK dout0_19 vdout0_19ck182 = 0 time = 915
* CHECK dout0_0 vdout0_0ck184 = 0.95 time = 925
* CHECK dout0_1 vdout0_1ck184 = 0.95 time = 925
* CHECK dout0_2 vdout0_2ck184 = 0.95 time = 925
* CHECK dout0_3 vdout0_3ck184 = 0 time = 925
* CHECK dout0_4 vdout0_4ck184 = 0.95 time = 925
* CHECK dout0_5 vdout0_5ck184 = 0 time = 925
* CHECK dout0_6 vdout0_6ck184 = 0 time = 925
* CHECK dout0_7 vdout0_7ck184 = 0 time = 925
* CHECK dout0_8 vdout0_8ck184 = 0 time = 925
* CHECK dout0_9 vdout0_9ck184 = 0.95 time = 925
* CHECK dout0_10 vdout0_10ck184 = 0 time = 925
* CHECK dout0_11 vdout0_11ck184 = 0.95 time = 925
* CHECK dout0_12 vdout0_12ck184 = 0.95 time = 925
* CHECK dout0_13 vdout0_13ck184 = 0.95 time = 925
* CHECK dout0_14 vdout0_14ck184 = 0 time = 925
* CHECK dout0_15 vdout0_15ck184 = 0.95 time = 925
* CHECK dout0_16 vdout0_16ck184 = 0 time = 925
* CHECK dout0_17 vdout0_17ck184 = 0.95 time = 925
* CHECK dout0_18 vdout0_18ck184 = 0.95 time = 925
* CHECK dout0_19 vdout0_19ck184 = 0 time = 925
* CHECK dout0_0 vdout0_0ck187 = 0.95 time = 940
* CHECK dout0_1 vdout0_1ck187 = 0.95 time = 940
* CHECK dout0_2 vdout0_2ck187 = 0.95 time = 940
* CHECK dout0_3 vdout0_3ck187 = 0 time = 940
* CHECK dout0_4 vdout0_4ck187 = 0.95 time = 940
* CHECK dout0_5 vdout0_5ck187 = 0.95 time = 940
* CHECK dout0_6 vdout0_6ck187 = 0 time = 940
* CHECK dout0_7 vdout0_7ck187 = 0.95 time = 940
* CHECK dout0_8 vdout0_8ck187 = 0.95 time = 940
* CHECK dout0_9 vdout0_9ck187 = 0 time = 940
* CHECK dout0_10 vdout0_10ck187 = 0.95 time = 940
* CHECK dout0_11 vdout0_11ck187 = 0 time = 940
* CHECK dout0_12 vdout0_12ck187 = 0.95 time = 940
* CHECK dout0_13 vdout0_13ck187 = 0 time = 940
* CHECK dout0_14 vdout0_14ck187 = 0.95 time = 940
* CHECK dout0_15 vdout0_15ck187 = 0.95 time = 940
* CHECK dout0_16 vdout0_16ck187 = 0 time = 940
* CHECK dout0_17 vdout0_17ck187 = 0.95 time = 940
* CHECK dout0_18 vdout0_18ck187 = 0 time = 940
* CHECK dout0_19 vdout0_19ck187 = 0 time = 940
* CHECK dout0_0 vdout0_0ck189 = 0.95 time = 950
* CHECK dout0_1 vdout0_1ck189 = 0.95 time = 950
* CHECK dout0_2 vdout0_2ck189 = 0.95 time = 950
* CHECK dout0_3 vdout0_3ck189 = 0.95 time = 950
* CHECK dout0_4 vdout0_4ck189 = 0.95 time = 950
* CHECK dout0_5 vdout0_5ck189 = 0 time = 950
* CHECK dout0_6 vdout0_6ck189 = 0 time = 950
* CHECK dout0_7 vdout0_7ck189 = 0.95 time = 950
* CHECK dout0_8 vdout0_8ck189 = 0.95 time = 950
* CHECK dout0_9 vdout0_9ck189 = 0 time = 950
* CHECK dout0_10 vdout0_10ck189 = 0.95 time = 950
* CHECK dout0_11 vdout0_11ck189 = 0 time = 950
* CHECK dout0_12 vdout0_12ck189 = 0 time = 950
* CHECK dout0_13 vdout0_13ck189 = 0.95 time = 950
* CHECK dout0_14 vdout0_14ck189 = 0 time = 950
* CHECK dout0_15 vdout0_15ck189 = 0.95 time = 950
* CHECK dout0_16 vdout0_16ck189 = 0 time = 950
* CHECK dout0_17 vdout0_17ck189 = 0 time = 950
* CHECK dout0_18 vdout0_18ck189 = 0.95 time = 950
* CHECK dout0_19 vdout0_19ck189 = 0.95 time = 950
* CHECK dout0_0 vdout0_0ck190 = 0.95 time = 955
* CHECK dout0_1 vdout0_1ck190 = 0.95 time = 955
* CHECK dout0_2 vdout0_2ck190 = 0.95 time = 955
* CHECK dout0_3 vdout0_3ck190 = 0 time = 955
* CHECK dout0_4 vdout0_4ck190 = 0 time = 955
* CHECK dout0_5 vdout0_5ck190 = 0 time = 955
* CHECK dout0_6 vdout0_6ck190 = 0.95 time = 955
* CHECK dout0_7 vdout0_7ck190 = 0.95 time = 955
* CHECK dout0_8 vdout0_8ck190 = 0 time = 955
* CHECK dout0_9 vdout0_9ck190 = 0 time = 955
* CHECK dout0_10 vdout0_10ck190 = 0.95 time = 955
* CHECK dout0_11 vdout0_11ck190 = 0.95 time = 955
* CHECK dout0_12 vdout0_12ck190 = 0 time = 955
* CHECK dout0_13 vdout0_13ck190 = 0 time = 955
* CHECK dout0_14 vdout0_14ck190 = 0 time = 955
* CHECK dout0_15 vdout0_15ck190 = 0.95 time = 955
* CHECK dout0_16 vdout0_16ck190 = 0 time = 955
* CHECK dout0_17 vdout0_17ck190 = 0.95 time = 955
* CHECK dout0_18 vdout0_18ck190 = 0 time = 955
* CHECK dout0_19 vdout0_19ck190 = 0 time = 955
* CHECK dout0_0 vdout0_0ck192 = 0.95 time = 965
* CHECK dout0_1 vdout0_1ck192 = 0.95 time = 965
* CHECK dout0_2 vdout0_2ck192 = 0 time = 965
* CHECK dout0_3 vdout0_3ck192 = 0 time = 965
* CHECK dout0_4 vdout0_4ck192 = 0.95 time = 965
* CHECK dout0_5 vdout0_5ck192 = 0 time = 965
* CHECK dout0_6 vdout0_6ck192 = 0.95 time = 965
* CHECK dout0_7 vdout0_7ck192 = 0.95 time = 965
* CHECK dout0_8 vdout0_8ck192 = 0 time = 965
* CHECK dout0_9 vdout0_9ck192 = 0.95 time = 965
* CHECK dout0_10 vdout0_10ck192 = 0 time = 965
* CHECK dout0_11 vdout0_11ck192 = 0.95 time = 965
* CHECK dout0_12 vdout0_12ck192 = 0.95 time = 965
* CHECK dout0_13 vdout0_13ck192 = 0 time = 965
* CHECK dout0_14 vdout0_14ck192 = 0.95 time = 965
* CHECK dout0_15 vdout0_15ck192 = 0 time = 965
* CHECK dout0_16 vdout0_16ck192 = 0 time = 965
* CHECK dout0_17 vdout0_17ck192 = 0 time = 965
* CHECK dout0_18 vdout0_18ck192 = 0 time = 965
* CHECK dout0_19 vdout0_19ck192 = 0 time = 965
* CHECK dout0_0 vdout0_0ck194 = 0 time = 975
* CHECK dout0_1 vdout0_1ck194 = 0.95 time = 975
* CHECK dout0_2 vdout0_2ck194 = 0.95 time = 975
* CHECK dout0_3 vdout0_3ck194 = 0.95 time = 975
* CHECK dout0_4 vdout0_4ck194 = 0 time = 975
* CHECK dout0_5 vdout0_5ck194 = 0 time = 975
* CHECK dout0_6 vdout0_6ck194 = 0.95 time = 975
* CHECK dout0_7 vdout0_7ck194 = 0.95 time = 975
* CHECK dout0_8 vdout0_8ck194 = 0 time = 975
* CHECK dout0_9 vdout0_9ck194 = 0.95 time = 975
* CHECK dout0_10 vdout0_10ck194 = 0 time = 975
* CHECK dout0_11 vdout0_11ck194 = 0.95 time = 975
* CHECK dout0_12 vdout0_12ck194 = 0 time = 975
* CHECK dout0_13 vdout0_13ck194 = 0 time = 975
* CHECK dout0_14 vdout0_14ck194 = 0 time = 975
* CHECK dout0_15 vdout0_15ck194 = 0.95 time = 975
* CHECK dout0_16 vdout0_16ck194 = 0.95 time = 975
* CHECK dout0_17 vdout0_17ck194 = 0 time = 975
* CHECK dout0_18 vdout0_18ck194 = 0 time = 975
* CHECK dout0_19 vdout0_19ck194 = 0.95 time = 975
* CHECK dout0_0 vdout0_0ck200 = 0.95 time = 1005
* CHECK dout0_1 vdout0_1ck200 = 0.95 time = 1005
* CHECK dout0_2 vdout0_2ck200 = 0.95 time = 1005
* CHECK dout0_3 vdout0_3ck200 = 0.95 time = 1005
* CHECK dout0_4 vdout0_4ck200 = 0.95 time = 1005
* CHECK dout0_5 vdout0_5ck200 = 0 time = 1005
* CHECK dout0_6 vdout0_6ck200 = 0 time = 1005
* CHECK dout0_7 vdout0_7ck200 = 0.95 time = 1005
* CHECK dout0_8 vdout0_8ck200 = 0.95 time = 1005
* CHECK dout0_9 vdout0_9ck200 = 0 time = 1005
* CHECK dout0_10 vdout0_10ck200 = 0.95 time = 1005
* CHECK dout0_11 vdout0_11ck200 = 0 time = 1005
* CHECK dout0_12 vdout0_12ck200 = 0 time = 1005
* CHECK dout0_13 vdout0_13ck200 = 0.95 time = 1005
* CHECK dout0_14 vdout0_14ck200 = 0 time = 1005
* CHECK dout0_15 vdout0_15ck200 = 0.95 time = 1005
* CHECK dout0_16 vdout0_16ck200 = 0 time = 1005
* CHECK dout0_17 vdout0_17ck200 = 0 time = 1005
* CHECK dout0_18 vdout0_18ck200 = 0.95 time = 1005
* CHECK dout0_19 vdout0_19ck200 = 0.95 time = 1005
* CHECK dout0_0 vdout0_0ck203 = 0 time = 1020
* CHECK dout0_1 vdout0_1ck203 = 0.95 time = 1020
* CHECK dout0_2 vdout0_2ck203 = 0 time = 1020
* CHECK dout0_3 vdout0_3ck203 = 0.95 time = 1020
* CHECK dout0_4 vdout0_4ck203 = 0.95 time = 1020
* CHECK dout0_5 vdout0_5ck203 = 0.95 time = 1020
* CHECK dout0_6 vdout0_6ck203 = 0 time = 1020
* CHECK dout0_7 vdout0_7ck203 = 0.95 time = 1020
* CHECK dout0_8 vdout0_8ck203 = 0.95 time = 1020
* CHECK dout0_9 vdout0_9ck203 = 0 time = 1020
* CHECK dout0_10 vdout0_10ck203 = 0.95 time = 1020
* CHECK dout0_11 vdout0_11ck203 = 0 time = 1020
* CHECK dout0_12 vdout0_12ck203 = 0.95 time = 1020
* CHECK dout0_13 vdout0_13ck203 = 0.95 time = 1020
* CHECK dout0_14 vdout0_14ck203 = 0 time = 1020
* CHECK dout0_15 vdout0_15ck203 = 0 time = 1020
* CHECK dout0_16 vdout0_16ck203 = 0.95 time = 1020
* CHECK dout0_17 vdout0_17ck203 = 0.95 time = 1020
* CHECK dout0_18 vdout0_18ck203 = 0.95 time = 1020
* CHECK dout0_19 vdout0_19ck203 = 0.95 time = 1020
* CHECK dout0_0 vdout0_0ck204 = 0.95 time = 1025
* CHECK dout0_1 vdout0_1ck204 = 0.95 time = 1025
* CHECK dout0_2 vdout0_2ck204 = 0 time = 1025
* CHECK dout0_3 vdout0_3ck204 = 0 time = 1025
* CHECK dout0_4 vdout0_4ck204 = 0 time = 1025
* CHECK dout0_5 vdout0_5ck204 = 0 time = 1025
* CHECK dout0_6 vdout0_6ck204 = 0 time = 1025
* CHECK dout0_7 vdout0_7ck204 = 0.95 time = 1025
* CHECK dout0_8 vdout0_8ck204 = 0 time = 1025
* CHECK dout0_9 vdout0_9ck204 = 0.95 time = 1025
* CHECK dout0_10 vdout0_10ck204 = 0.95 time = 1025
* CHECK dout0_11 vdout0_11ck204 = 0.95 time = 1025
* CHECK dout0_12 vdout0_12ck204 = 0.95 time = 1025
* CHECK dout0_13 vdout0_13ck204 = 0 time = 1025
* CHECK dout0_14 vdout0_14ck204 = 0.95 time = 1025
* CHECK dout0_15 vdout0_15ck204 = 0.95 time = 1025
* CHECK dout0_16 vdout0_16ck204 = 0 time = 1025
* CHECK dout0_17 vdout0_17ck204 = 0 time = 1025
* CHECK dout0_18 vdout0_18ck204 = 0 time = 1025
* CHECK dout0_19 vdout0_19ck204 = 0 time = 1025
.include /home/discontentBoron/Projects/OpenRAM/../orion-rv/sram/icache_tag_sram_1rw0r0w_20_128_freepdk45/functional_meas.sp
.OPTIONS DEVICE TEMP=125
.OPTIONS MEASURE MEASFAIL=1
.OPTIONS LINSOL type=klu
.OPTIONS TIMEINT RELTOL=1e-3 ABSTOL=1e-6 method=gear minorder=2
.TRAN 10p 1030n 0n 10p
* probe is used for hspice/xa, while plot is used in ngspice
.end
