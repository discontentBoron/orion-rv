.meas tran vdout0_0ck40 FIND v(dout0_0) AT=25.025n

.meas tran vdout0_1ck40 FIND v(dout0_1) AT=25.025n

.meas tran vdout0_2ck40 FIND v(dout0_2) AT=25.025n

.meas tran vdout0_3ck40 FIND v(dout0_3) AT=25.025n

.meas tran vdout0_4ck40 FIND v(dout0_4) AT=25.025n

.meas tran vdout0_5ck40 FIND v(dout0_5) AT=25.025n

.meas tran vdout0_6ck40 FIND v(dout0_6) AT=25.025n

.meas tran vdout0_7ck40 FIND v(dout0_7) AT=25.025n

.meas tran vdout0_8ck40 FIND v(dout0_8) AT=25.025n

.meas tran vdout0_9ck40 FIND v(dout0_9) AT=25.025n

.meas tran vdout0_10ck40 FIND v(dout0_10) AT=25.025n

.meas tran vdout0_11ck40 FIND v(dout0_11) AT=25.025n

.meas tran vdout0_12ck40 FIND v(dout0_12) AT=25.025n

.meas tran vdout0_13ck40 FIND v(dout0_13) AT=25.025n

.meas tran vdout0_14ck40 FIND v(dout0_14) AT=25.025n

.meas tran vdout0_15ck40 FIND v(dout0_15) AT=25.025n

.meas tran vdout0_16ck40 FIND v(dout0_16) AT=25.025n

.meas tran vdout0_17ck40 FIND v(dout0_17) AT=25.025n

.meas tran vdout0_18ck40 FIND v(dout0_18) AT=25.025n

.meas tran vdout0_19ck40 FIND v(dout0_19) AT=25.025n

.meas tran vdout0_20ck40 FIND v(dout0_20) AT=25.025n

.meas tran vdout0_21ck40 FIND v(dout0_21) AT=25.025n

.meas tran vdout0_22ck40 FIND v(dout0_22) AT=25.025n

.meas tran vdout0_23ck40 FIND v(dout0_23) AT=25.025n

.meas tran vdout0_24ck40 FIND v(dout0_24) AT=25.025n

.meas tran vdout0_25ck40 FIND v(dout0_25) AT=25.025n

.meas tran vdout0_26ck40 FIND v(dout0_26) AT=25.025n

.meas tran vdout0_27ck40 FIND v(dout0_27) AT=25.025n

.meas tran vdout0_28ck40 FIND v(dout0_28) AT=25.025n

.meas tran vdout0_29ck40 FIND v(dout0_29) AT=25.025n

.meas tran vdout0_30ck40 FIND v(dout0_30) AT=25.025n

.meas tran vdout0_31ck40 FIND v(dout0_31) AT=25.025n

.meas tran vdout0_0ck50 FIND v(dout0_0) AT=30.025n

.meas tran vdout0_1ck50 FIND v(dout0_1) AT=30.025n

.meas tran vdout0_2ck50 FIND v(dout0_2) AT=30.025n

.meas tran vdout0_3ck50 FIND v(dout0_3) AT=30.025n

.meas tran vdout0_4ck50 FIND v(dout0_4) AT=30.025n

.meas tran vdout0_5ck50 FIND v(dout0_5) AT=30.025n

.meas tran vdout0_6ck50 FIND v(dout0_6) AT=30.025n

.meas tran vdout0_7ck50 FIND v(dout0_7) AT=30.025n

.meas tran vdout0_8ck50 FIND v(dout0_8) AT=30.025n

.meas tran vdout0_9ck50 FIND v(dout0_9) AT=30.025n

.meas tran vdout0_10ck50 FIND v(dout0_10) AT=30.025n

.meas tran vdout0_11ck50 FIND v(dout0_11) AT=30.025n

.meas tran vdout0_12ck50 FIND v(dout0_12) AT=30.025n

.meas tran vdout0_13ck50 FIND v(dout0_13) AT=30.025n

.meas tran vdout0_14ck50 FIND v(dout0_14) AT=30.025n

.meas tran vdout0_15ck50 FIND v(dout0_15) AT=30.025n

.meas tran vdout0_16ck50 FIND v(dout0_16) AT=30.025n

.meas tran vdout0_17ck50 FIND v(dout0_17) AT=30.025n

.meas tran vdout0_18ck50 FIND v(dout0_18) AT=30.025n

.meas tran vdout0_19ck50 FIND v(dout0_19) AT=30.025n

.meas tran vdout0_20ck50 FIND v(dout0_20) AT=30.025n

.meas tran vdout0_21ck50 FIND v(dout0_21) AT=30.025n

.meas tran vdout0_22ck50 FIND v(dout0_22) AT=30.025n

.meas tran vdout0_23ck50 FIND v(dout0_23) AT=30.025n

.meas tran vdout0_24ck50 FIND v(dout0_24) AT=30.025n

.meas tran vdout0_25ck50 FIND v(dout0_25) AT=30.025n

.meas tran vdout0_26ck50 FIND v(dout0_26) AT=30.025n

.meas tran vdout0_27ck50 FIND v(dout0_27) AT=30.025n

.meas tran vdout0_28ck50 FIND v(dout0_28) AT=30.025n

.meas tran vdout0_29ck50 FIND v(dout0_29) AT=30.025n

.meas tran vdout0_30ck50 FIND v(dout0_30) AT=30.025n

.meas tran vdout0_31ck50 FIND v(dout0_31) AT=30.025n

.meas tran vdout0_0ck70 FIND v(dout0_0) AT=40.025n

.meas tran vdout0_1ck70 FIND v(dout0_1) AT=40.025n

.meas tran vdout0_2ck70 FIND v(dout0_2) AT=40.025n

.meas tran vdout0_3ck70 FIND v(dout0_3) AT=40.025n

.meas tran vdout0_4ck70 FIND v(dout0_4) AT=40.025n

.meas tran vdout0_5ck70 FIND v(dout0_5) AT=40.025n

.meas tran vdout0_6ck70 FIND v(dout0_6) AT=40.025n

.meas tran vdout0_7ck70 FIND v(dout0_7) AT=40.025n

.meas tran vdout0_8ck70 FIND v(dout0_8) AT=40.025n

.meas tran vdout0_9ck70 FIND v(dout0_9) AT=40.025n

.meas tran vdout0_10ck70 FIND v(dout0_10) AT=40.025n

.meas tran vdout0_11ck70 FIND v(dout0_11) AT=40.025n

.meas tran vdout0_12ck70 FIND v(dout0_12) AT=40.025n

.meas tran vdout0_13ck70 FIND v(dout0_13) AT=40.025n

.meas tran vdout0_14ck70 FIND v(dout0_14) AT=40.025n

.meas tran vdout0_15ck70 FIND v(dout0_15) AT=40.025n

.meas tran vdout0_16ck70 FIND v(dout0_16) AT=40.025n

.meas tran vdout0_17ck70 FIND v(dout0_17) AT=40.025n

.meas tran vdout0_18ck70 FIND v(dout0_18) AT=40.025n

.meas tran vdout0_19ck70 FIND v(dout0_19) AT=40.025n

.meas tran vdout0_20ck70 FIND v(dout0_20) AT=40.025n

.meas tran vdout0_21ck70 FIND v(dout0_21) AT=40.025n

.meas tran vdout0_22ck70 FIND v(dout0_22) AT=40.025n

.meas tran vdout0_23ck70 FIND v(dout0_23) AT=40.025n

.meas tran vdout0_24ck70 FIND v(dout0_24) AT=40.025n

.meas tran vdout0_25ck70 FIND v(dout0_25) AT=40.025n

.meas tran vdout0_26ck70 FIND v(dout0_26) AT=40.025n

.meas tran vdout0_27ck70 FIND v(dout0_27) AT=40.025n

.meas tran vdout0_28ck70 FIND v(dout0_28) AT=40.025n

.meas tran vdout0_29ck70 FIND v(dout0_29) AT=40.025n

.meas tran vdout0_30ck70 FIND v(dout0_30) AT=40.025n

.meas tran vdout0_31ck70 FIND v(dout0_31) AT=40.025n

.meas tran vdout0_0ck80 FIND v(dout0_0) AT=45.025n

.meas tran vdout0_1ck80 FIND v(dout0_1) AT=45.025n

.meas tran vdout0_2ck80 FIND v(dout0_2) AT=45.025n

.meas tran vdout0_3ck80 FIND v(dout0_3) AT=45.025n

.meas tran vdout0_4ck80 FIND v(dout0_4) AT=45.025n

.meas tran vdout0_5ck80 FIND v(dout0_5) AT=45.025n

.meas tran vdout0_6ck80 FIND v(dout0_6) AT=45.025n

.meas tran vdout0_7ck80 FIND v(dout0_7) AT=45.025n

.meas tran vdout0_8ck80 FIND v(dout0_8) AT=45.025n

.meas tran vdout0_9ck80 FIND v(dout0_9) AT=45.025n

.meas tran vdout0_10ck80 FIND v(dout0_10) AT=45.025n

.meas tran vdout0_11ck80 FIND v(dout0_11) AT=45.025n

.meas tran vdout0_12ck80 FIND v(dout0_12) AT=45.025n

.meas tran vdout0_13ck80 FIND v(dout0_13) AT=45.025n

.meas tran vdout0_14ck80 FIND v(dout0_14) AT=45.025n

.meas tran vdout0_15ck80 FIND v(dout0_15) AT=45.025n

.meas tran vdout0_16ck80 FIND v(dout0_16) AT=45.025n

.meas tran vdout0_17ck80 FIND v(dout0_17) AT=45.025n

.meas tran vdout0_18ck80 FIND v(dout0_18) AT=45.025n

.meas tran vdout0_19ck80 FIND v(dout0_19) AT=45.025n

.meas tran vdout0_20ck80 FIND v(dout0_20) AT=45.025n

.meas tran vdout0_21ck80 FIND v(dout0_21) AT=45.025n

.meas tran vdout0_22ck80 FIND v(dout0_22) AT=45.025n

.meas tran vdout0_23ck80 FIND v(dout0_23) AT=45.025n

.meas tran vdout0_24ck80 FIND v(dout0_24) AT=45.025n

.meas tran vdout0_25ck80 FIND v(dout0_25) AT=45.025n

.meas tran vdout0_26ck80 FIND v(dout0_26) AT=45.025n

.meas tran vdout0_27ck80 FIND v(dout0_27) AT=45.025n

.meas tran vdout0_28ck80 FIND v(dout0_28) AT=45.025n

.meas tran vdout0_29ck80 FIND v(dout0_29) AT=45.025n

.meas tran vdout0_30ck80 FIND v(dout0_30) AT=45.025n

.meas tran vdout0_31ck80 FIND v(dout0_31) AT=45.025n

.meas tran vdout0_0ck110 FIND v(dout0_0) AT=60.025n

.meas tran vdout0_1ck110 FIND v(dout0_1) AT=60.025n

.meas tran vdout0_2ck110 FIND v(dout0_2) AT=60.025n

.meas tran vdout0_3ck110 FIND v(dout0_3) AT=60.025n

.meas tran vdout0_4ck110 FIND v(dout0_4) AT=60.025n

.meas tran vdout0_5ck110 FIND v(dout0_5) AT=60.025n

.meas tran vdout0_6ck110 FIND v(dout0_6) AT=60.025n

.meas tran vdout0_7ck110 FIND v(dout0_7) AT=60.025n

.meas tran vdout0_8ck110 FIND v(dout0_8) AT=60.025n

.meas tran vdout0_9ck110 FIND v(dout0_9) AT=60.025n

.meas tran vdout0_10ck110 FIND v(dout0_10) AT=60.025n

.meas tran vdout0_11ck110 FIND v(dout0_11) AT=60.025n

.meas tran vdout0_12ck110 FIND v(dout0_12) AT=60.025n

.meas tran vdout0_13ck110 FIND v(dout0_13) AT=60.025n

.meas tran vdout0_14ck110 FIND v(dout0_14) AT=60.025n

.meas tran vdout0_15ck110 FIND v(dout0_15) AT=60.025n

.meas tran vdout0_16ck110 FIND v(dout0_16) AT=60.025n

.meas tran vdout0_17ck110 FIND v(dout0_17) AT=60.025n

.meas tran vdout0_18ck110 FIND v(dout0_18) AT=60.025n

.meas tran vdout0_19ck110 FIND v(dout0_19) AT=60.025n

.meas tran vdout0_20ck110 FIND v(dout0_20) AT=60.025n

.meas tran vdout0_21ck110 FIND v(dout0_21) AT=60.025n

.meas tran vdout0_22ck110 FIND v(dout0_22) AT=60.025n

.meas tran vdout0_23ck110 FIND v(dout0_23) AT=60.025n

.meas tran vdout0_24ck110 FIND v(dout0_24) AT=60.025n

.meas tran vdout0_25ck110 FIND v(dout0_25) AT=60.025n

.meas tran vdout0_26ck110 FIND v(dout0_26) AT=60.025n

.meas tran vdout0_27ck110 FIND v(dout0_27) AT=60.025n

.meas tran vdout0_28ck110 FIND v(dout0_28) AT=60.025n

.meas tran vdout0_29ck110 FIND v(dout0_29) AT=60.025n

.meas tran vdout0_30ck110 FIND v(dout0_30) AT=60.025n

.meas tran vdout0_31ck110 FIND v(dout0_31) AT=60.025n

.meas tran vdout0_0ck120 FIND v(dout0_0) AT=65.025n

.meas tran vdout0_1ck120 FIND v(dout0_1) AT=65.025n

.meas tran vdout0_2ck120 FIND v(dout0_2) AT=65.025n

.meas tran vdout0_3ck120 FIND v(dout0_3) AT=65.025n

.meas tran vdout0_4ck120 FIND v(dout0_4) AT=65.025n

.meas tran vdout0_5ck120 FIND v(dout0_5) AT=65.025n

.meas tran vdout0_6ck120 FIND v(dout0_6) AT=65.025n

.meas tran vdout0_7ck120 FIND v(dout0_7) AT=65.025n

.meas tran vdout0_8ck120 FIND v(dout0_8) AT=65.025n

.meas tran vdout0_9ck120 FIND v(dout0_9) AT=65.025n

.meas tran vdout0_10ck120 FIND v(dout0_10) AT=65.025n

.meas tran vdout0_11ck120 FIND v(dout0_11) AT=65.025n

.meas tran vdout0_12ck120 FIND v(dout0_12) AT=65.025n

.meas tran vdout0_13ck120 FIND v(dout0_13) AT=65.025n

.meas tran vdout0_14ck120 FIND v(dout0_14) AT=65.025n

.meas tran vdout0_15ck120 FIND v(dout0_15) AT=65.025n

.meas tran vdout0_16ck120 FIND v(dout0_16) AT=65.025n

.meas tran vdout0_17ck120 FIND v(dout0_17) AT=65.025n

.meas tran vdout0_18ck120 FIND v(dout0_18) AT=65.025n

.meas tran vdout0_19ck120 FIND v(dout0_19) AT=65.025n

.meas tran vdout0_20ck120 FIND v(dout0_20) AT=65.025n

.meas tran vdout0_21ck120 FIND v(dout0_21) AT=65.025n

.meas tran vdout0_22ck120 FIND v(dout0_22) AT=65.025n

.meas tran vdout0_23ck120 FIND v(dout0_23) AT=65.025n

.meas tran vdout0_24ck120 FIND v(dout0_24) AT=65.025n

.meas tran vdout0_25ck120 FIND v(dout0_25) AT=65.025n

.meas tran vdout0_26ck120 FIND v(dout0_26) AT=65.025n

.meas tran vdout0_27ck120 FIND v(dout0_27) AT=65.025n

.meas tran vdout0_28ck120 FIND v(dout0_28) AT=65.025n

.meas tran vdout0_29ck120 FIND v(dout0_29) AT=65.025n

.meas tran vdout0_30ck120 FIND v(dout0_30) AT=65.025n

.meas tran vdout0_31ck120 FIND v(dout0_31) AT=65.025n

.meas tran vdout0_0ck160 FIND v(dout0_0) AT=85.025n

.meas tran vdout0_1ck160 FIND v(dout0_1) AT=85.025n

.meas tran vdout0_2ck160 FIND v(dout0_2) AT=85.025n

.meas tran vdout0_3ck160 FIND v(dout0_3) AT=85.025n

.meas tran vdout0_4ck160 FIND v(dout0_4) AT=85.025n

.meas tran vdout0_5ck160 FIND v(dout0_5) AT=85.025n

.meas tran vdout0_6ck160 FIND v(dout0_6) AT=85.025n

.meas tran vdout0_7ck160 FIND v(dout0_7) AT=85.025n

.meas tran vdout0_8ck160 FIND v(dout0_8) AT=85.025n

.meas tran vdout0_9ck160 FIND v(dout0_9) AT=85.025n

.meas tran vdout0_10ck160 FIND v(dout0_10) AT=85.025n

.meas tran vdout0_11ck160 FIND v(dout0_11) AT=85.025n

.meas tran vdout0_12ck160 FIND v(dout0_12) AT=85.025n

.meas tran vdout0_13ck160 FIND v(dout0_13) AT=85.025n

.meas tran vdout0_14ck160 FIND v(dout0_14) AT=85.025n

.meas tran vdout0_15ck160 FIND v(dout0_15) AT=85.025n

.meas tran vdout0_16ck160 FIND v(dout0_16) AT=85.025n

.meas tran vdout0_17ck160 FIND v(dout0_17) AT=85.025n

.meas tran vdout0_18ck160 FIND v(dout0_18) AT=85.025n

.meas tran vdout0_19ck160 FIND v(dout0_19) AT=85.025n

.meas tran vdout0_20ck160 FIND v(dout0_20) AT=85.025n

.meas tran vdout0_21ck160 FIND v(dout0_21) AT=85.025n

.meas tran vdout0_22ck160 FIND v(dout0_22) AT=85.025n

.meas tran vdout0_23ck160 FIND v(dout0_23) AT=85.025n

.meas tran vdout0_24ck160 FIND v(dout0_24) AT=85.025n

.meas tran vdout0_25ck160 FIND v(dout0_25) AT=85.025n

.meas tran vdout0_26ck160 FIND v(dout0_26) AT=85.025n

.meas tran vdout0_27ck160 FIND v(dout0_27) AT=85.025n

.meas tran vdout0_28ck160 FIND v(dout0_28) AT=85.025n

.meas tran vdout0_29ck160 FIND v(dout0_29) AT=85.025n

.meas tran vdout0_30ck160 FIND v(dout0_30) AT=85.025n

.meas tran vdout0_31ck160 FIND v(dout0_31) AT=85.025n

.meas tran vdout0_0ck170 FIND v(dout0_0) AT=90.025n

.meas tran vdout0_1ck170 FIND v(dout0_1) AT=90.025n

.meas tran vdout0_2ck170 FIND v(dout0_2) AT=90.025n

.meas tran vdout0_3ck170 FIND v(dout0_3) AT=90.025n

.meas tran vdout0_4ck170 FIND v(dout0_4) AT=90.025n

.meas tran vdout0_5ck170 FIND v(dout0_5) AT=90.025n

.meas tran vdout0_6ck170 FIND v(dout0_6) AT=90.025n

.meas tran vdout0_7ck170 FIND v(dout0_7) AT=90.025n

.meas tran vdout0_8ck170 FIND v(dout0_8) AT=90.025n

.meas tran vdout0_9ck170 FIND v(dout0_9) AT=90.025n

.meas tran vdout0_10ck170 FIND v(dout0_10) AT=90.025n

.meas tran vdout0_11ck170 FIND v(dout0_11) AT=90.025n

.meas tran vdout0_12ck170 FIND v(dout0_12) AT=90.025n

.meas tran vdout0_13ck170 FIND v(dout0_13) AT=90.025n

.meas tran vdout0_14ck170 FIND v(dout0_14) AT=90.025n

.meas tran vdout0_15ck170 FIND v(dout0_15) AT=90.025n

.meas tran vdout0_16ck170 FIND v(dout0_16) AT=90.025n

.meas tran vdout0_17ck170 FIND v(dout0_17) AT=90.025n

.meas tran vdout0_18ck170 FIND v(dout0_18) AT=90.025n

.meas tran vdout0_19ck170 FIND v(dout0_19) AT=90.025n

.meas tran vdout0_20ck170 FIND v(dout0_20) AT=90.025n

.meas tran vdout0_21ck170 FIND v(dout0_21) AT=90.025n

.meas tran vdout0_22ck170 FIND v(dout0_22) AT=90.025n

.meas tran vdout0_23ck170 FIND v(dout0_23) AT=90.025n

.meas tran vdout0_24ck170 FIND v(dout0_24) AT=90.025n

.meas tran vdout0_25ck170 FIND v(dout0_25) AT=90.025n

.meas tran vdout0_26ck170 FIND v(dout0_26) AT=90.025n

.meas tran vdout0_27ck170 FIND v(dout0_27) AT=90.025n

.meas tran vdout0_28ck170 FIND v(dout0_28) AT=90.025n

.meas tran vdout0_29ck170 FIND v(dout0_29) AT=90.025n

.meas tran vdout0_30ck170 FIND v(dout0_30) AT=90.025n

.meas tran vdout0_31ck170 FIND v(dout0_31) AT=90.025n

.meas tran vdout0_0ck200 FIND v(dout0_0) AT=105.025n

.meas tran vdout0_1ck200 FIND v(dout0_1) AT=105.025n

.meas tran vdout0_2ck200 FIND v(dout0_2) AT=105.025n

.meas tran vdout0_3ck200 FIND v(dout0_3) AT=105.025n

.meas tran vdout0_4ck200 FIND v(dout0_4) AT=105.025n

.meas tran vdout0_5ck200 FIND v(dout0_5) AT=105.025n

.meas tran vdout0_6ck200 FIND v(dout0_6) AT=105.025n

.meas tran vdout0_7ck200 FIND v(dout0_7) AT=105.025n

.meas tran vdout0_8ck200 FIND v(dout0_8) AT=105.025n

.meas tran vdout0_9ck200 FIND v(dout0_9) AT=105.025n

.meas tran vdout0_10ck200 FIND v(dout0_10) AT=105.025n

.meas tran vdout0_11ck200 FIND v(dout0_11) AT=105.025n

.meas tran vdout0_12ck200 FIND v(dout0_12) AT=105.025n

.meas tran vdout0_13ck200 FIND v(dout0_13) AT=105.025n

.meas tran vdout0_14ck200 FIND v(dout0_14) AT=105.025n

.meas tran vdout0_15ck200 FIND v(dout0_15) AT=105.025n

.meas tran vdout0_16ck200 FIND v(dout0_16) AT=105.025n

.meas tran vdout0_17ck200 FIND v(dout0_17) AT=105.025n

.meas tran vdout0_18ck200 FIND v(dout0_18) AT=105.025n

.meas tran vdout0_19ck200 FIND v(dout0_19) AT=105.025n

.meas tran vdout0_20ck200 FIND v(dout0_20) AT=105.025n

.meas tran vdout0_21ck200 FIND v(dout0_21) AT=105.025n

.meas tran vdout0_22ck200 FIND v(dout0_22) AT=105.025n

.meas tran vdout0_23ck200 FIND v(dout0_23) AT=105.025n

.meas tran vdout0_24ck200 FIND v(dout0_24) AT=105.025n

.meas tran vdout0_25ck200 FIND v(dout0_25) AT=105.025n

.meas tran vdout0_26ck200 FIND v(dout0_26) AT=105.025n

.meas tran vdout0_27ck200 FIND v(dout0_27) AT=105.025n

.meas tran vdout0_28ck200 FIND v(dout0_28) AT=105.025n

.meas tran vdout0_29ck200 FIND v(dout0_29) AT=105.025n

.meas tran vdout0_30ck200 FIND v(dout0_30) AT=105.025n

.meas tran vdout0_31ck200 FIND v(dout0_31) AT=105.025n

.meas tran vdout0_0ck210 FIND v(dout0_0) AT=110.025n

.meas tran vdout0_1ck210 FIND v(dout0_1) AT=110.025n

.meas tran vdout0_2ck210 FIND v(dout0_2) AT=110.025n

.meas tran vdout0_3ck210 FIND v(dout0_3) AT=110.025n

.meas tran vdout0_4ck210 FIND v(dout0_4) AT=110.025n

.meas tran vdout0_5ck210 FIND v(dout0_5) AT=110.025n

.meas tran vdout0_6ck210 FIND v(dout0_6) AT=110.025n

.meas tran vdout0_7ck210 FIND v(dout0_7) AT=110.025n

.meas tran vdout0_8ck210 FIND v(dout0_8) AT=110.025n

.meas tran vdout0_9ck210 FIND v(dout0_9) AT=110.025n

.meas tran vdout0_10ck210 FIND v(dout0_10) AT=110.025n

.meas tran vdout0_11ck210 FIND v(dout0_11) AT=110.025n

.meas tran vdout0_12ck210 FIND v(dout0_12) AT=110.025n

.meas tran vdout0_13ck210 FIND v(dout0_13) AT=110.025n

.meas tran vdout0_14ck210 FIND v(dout0_14) AT=110.025n

.meas tran vdout0_15ck210 FIND v(dout0_15) AT=110.025n

.meas tran vdout0_16ck210 FIND v(dout0_16) AT=110.025n

.meas tran vdout0_17ck210 FIND v(dout0_17) AT=110.025n

.meas tran vdout0_18ck210 FIND v(dout0_18) AT=110.025n

.meas tran vdout0_19ck210 FIND v(dout0_19) AT=110.025n

.meas tran vdout0_20ck210 FIND v(dout0_20) AT=110.025n

.meas tran vdout0_21ck210 FIND v(dout0_21) AT=110.025n

.meas tran vdout0_22ck210 FIND v(dout0_22) AT=110.025n

.meas tran vdout0_23ck210 FIND v(dout0_23) AT=110.025n

.meas tran vdout0_24ck210 FIND v(dout0_24) AT=110.025n

.meas tran vdout0_25ck210 FIND v(dout0_25) AT=110.025n

.meas tran vdout0_26ck210 FIND v(dout0_26) AT=110.025n

.meas tran vdout0_27ck210 FIND v(dout0_27) AT=110.025n

.meas tran vdout0_28ck210 FIND v(dout0_28) AT=110.025n

.meas tran vdout0_29ck210 FIND v(dout0_29) AT=110.025n

.meas tran vdout0_30ck210 FIND v(dout0_30) AT=110.025n

.meas tran vdout0_31ck210 FIND v(dout0_31) AT=110.025n

.meas tran vdout0_0ck240 FIND v(dout0_0) AT=125.025n

.meas tran vdout0_1ck240 FIND v(dout0_1) AT=125.025n

.meas tran vdout0_2ck240 FIND v(dout0_2) AT=125.025n

.meas tran vdout0_3ck240 FIND v(dout0_3) AT=125.025n

.meas tran vdout0_4ck240 FIND v(dout0_4) AT=125.025n

.meas tran vdout0_5ck240 FIND v(dout0_5) AT=125.025n

.meas tran vdout0_6ck240 FIND v(dout0_6) AT=125.025n

.meas tran vdout0_7ck240 FIND v(dout0_7) AT=125.025n

.meas tran vdout0_8ck240 FIND v(dout0_8) AT=125.025n

.meas tran vdout0_9ck240 FIND v(dout0_9) AT=125.025n

.meas tran vdout0_10ck240 FIND v(dout0_10) AT=125.025n

.meas tran vdout0_11ck240 FIND v(dout0_11) AT=125.025n

.meas tran vdout0_12ck240 FIND v(dout0_12) AT=125.025n

.meas tran vdout0_13ck240 FIND v(dout0_13) AT=125.025n

.meas tran vdout0_14ck240 FIND v(dout0_14) AT=125.025n

.meas tran vdout0_15ck240 FIND v(dout0_15) AT=125.025n

.meas tran vdout0_16ck240 FIND v(dout0_16) AT=125.025n

.meas tran vdout0_17ck240 FIND v(dout0_17) AT=125.025n

.meas tran vdout0_18ck240 FIND v(dout0_18) AT=125.025n

.meas tran vdout0_19ck240 FIND v(dout0_19) AT=125.025n

.meas tran vdout0_20ck240 FIND v(dout0_20) AT=125.025n

.meas tran vdout0_21ck240 FIND v(dout0_21) AT=125.025n

.meas tran vdout0_22ck240 FIND v(dout0_22) AT=125.025n

.meas tran vdout0_23ck240 FIND v(dout0_23) AT=125.025n

.meas tran vdout0_24ck240 FIND v(dout0_24) AT=125.025n

.meas tran vdout0_25ck240 FIND v(dout0_25) AT=125.025n

.meas tran vdout0_26ck240 FIND v(dout0_26) AT=125.025n

.meas tran vdout0_27ck240 FIND v(dout0_27) AT=125.025n

.meas tran vdout0_28ck240 FIND v(dout0_28) AT=125.025n

.meas tran vdout0_29ck240 FIND v(dout0_29) AT=125.025n

.meas tran vdout0_30ck240 FIND v(dout0_30) AT=125.025n

.meas tran vdout0_31ck240 FIND v(dout0_31) AT=125.025n

.meas tran vdout0_0ck260 FIND v(dout0_0) AT=135.025n

.meas tran vdout0_1ck260 FIND v(dout0_1) AT=135.025n

.meas tran vdout0_2ck260 FIND v(dout0_2) AT=135.025n

.meas tran vdout0_3ck260 FIND v(dout0_3) AT=135.025n

.meas tran vdout0_4ck260 FIND v(dout0_4) AT=135.025n

.meas tran vdout0_5ck260 FIND v(dout0_5) AT=135.025n

.meas tran vdout0_6ck260 FIND v(dout0_6) AT=135.025n

.meas tran vdout0_7ck260 FIND v(dout0_7) AT=135.025n

.meas tran vdout0_8ck260 FIND v(dout0_8) AT=135.025n

.meas tran vdout0_9ck260 FIND v(dout0_9) AT=135.025n

.meas tran vdout0_10ck260 FIND v(dout0_10) AT=135.025n

.meas tran vdout0_11ck260 FIND v(dout0_11) AT=135.025n

.meas tran vdout0_12ck260 FIND v(dout0_12) AT=135.025n

.meas tran vdout0_13ck260 FIND v(dout0_13) AT=135.025n

.meas tran vdout0_14ck260 FIND v(dout0_14) AT=135.025n

.meas tran vdout0_15ck260 FIND v(dout0_15) AT=135.025n

.meas tran vdout0_16ck260 FIND v(dout0_16) AT=135.025n

.meas tran vdout0_17ck260 FIND v(dout0_17) AT=135.025n

.meas tran vdout0_18ck260 FIND v(dout0_18) AT=135.025n

.meas tran vdout0_19ck260 FIND v(dout0_19) AT=135.025n

.meas tran vdout0_20ck260 FIND v(dout0_20) AT=135.025n

.meas tran vdout0_21ck260 FIND v(dout0_21) AT=135.025n

.meas tran vdout0_22ck260 FIND v(dout0_22) AT=135.025n

.meas tran vdout0_23ck260 FIND v(dout0_23) AT=135.025n

.meas tran vdout0_24ck260 FIND v(dout0_24) AT=135.025n

.meas tran vdout0_25ck260 FIND v(dout0_25) AT=135.025n

.meas tran vdout0_26ck260 FIND v(dout0_26) AT=135.025n

.meas tran vdout0_27ck260 FIND v(dout0_27) AT=135.025n

.meas tran vdout0_28ck260 FIND v(dout0_28) AT=135.025n

.meas tran vdout0_29ck260 FIND v(dout0_29) AT=135.025n

.meas tran vdout0_30ck260 FIND v(dout0_30) AT=135.025n

.meas tran vdout0_31ck260 FIND v(dout0_31) AT=135.025n

.meas tran vdout0_0ck310 FIND v(dout0_0) AT=160.025n

.meas tran vdout0_1ck310 FIND v(dout0_1) AT=160.025n

.meas tran vdout0_2ck310 FIND v(dout0_2) AT=160.025n

.meas tran vdout0_3ck310 FIND v(dout0_3) AT=160.025n

.meas tran vdout0_4ck310 FIND v(dout0_4) AT=160.025n

.meas tran vdout0_5ck310 FIND v(dout0_5) AT=160.025n

.meas tran vdout0_6ck310 FIND v(dout0_6) AT=160.025n

.meas tran vdout0_7ck310 FIND v(dout0_7) AT=160.025n

.meas tran vdout0_8ck310 FIND v(dout0_8) AT=160.025n

.meas tran vdout0_9ck310 FIND v(dout0_9) AT=160.025n

.meas tran vdout0_10ck310 FIND v(dout0_10) AT=160.025n

.meas tran vdout0_11ck310 FIND v(dout0_11) AT=160.025n

.meas tran vdout0_12ck310 FIND v(dout0_12) AT=160.025n

.meas tran vdout0_13ck310 FIND v(dout0_13) AT=160.025n

.meas tran vdout0_14ck310 FIND v(dout0_14) AT=160.025n

.meas tran vdout0_15ck310 FIND v(dout0_15) AT=160.025n

.meas tran vdout0_16ck310 FIND v(dout0_16) AT=160.025n

.meas tran vdout0_17ck310 FIND v(dout0_17) AT=160.025n

.meas tran vdout0_18ck310 FIND v(dout0_18) AT=160.025n

.meas tran vdout0_19ck310 FIND v(dout0_19) AT=160.025n

.meas tran vdout0_20ck310 FIND v(dout0_20) AT=160.025n

.meas tran vdout0_21ck310 FIND v(dout0_21) AT=160.025n

.meas tran vdout0_22ck310 FIND v(dout0_22) AT=160.025n

.meas tran vdout0_23ck310 FIND v(dout0_23) AT=160.025n

.meas tran vdout0_24ck310 FIND v(dout0_24) AT=160.025n

.meas tran vdout0_25ck310 FIND v(dout0_25) AT=160.025n

.meas tran vdout0_26ck310 FIND v(dout0_26) AT=160.025n

.meas tran vdout0_27ck310 FIND v(dout0_27) AT=160.025n

.meas tran vdout0_28ck310 FIND v(dout0_28) AT=160.025n

.meas tran vdout0_29ck310 FIND v(dout0_29) AT=160.025n

.meas tran vdout0_30ck310 FIND v(dout0_30) AT=160.025n

.meas tran vdout0_31ck310 FIND v(dout0_31) AT=160.025n

.meas tran vdout0_0ck340 FIND v(dout0_0) AT=175.025n

.meas tran vdout0_1ck340 FIND v(dout0_1) AT=175.025n

.meas tran vdout0_2ck340 FIND v(dout0_2) AT=175.025n

.meas tran vdout0_3ck340 FIND v(dout0_3) AT=175.025n

.meas tran vdout0_4ck340 FIND v(dout0_4) AT=175.025n

.meas tran vdout0_5ck340 FIND v(dout0_5) AT=175.025n

.meas tran vdout0_6ck340 FIND v(dout0_6) AT=175.025n

.meas tran vdout0_7ck340 FIND v(dout0_7) AT=175.025n

.meas tran vdout0_8ck340 FIND v(dout0_8) AT=175.025n

.meas tran vdout0_9ck340 FIND v(dout0_9) AT=175.025n

.meas tran vdout0_10ck340 FIND v(dout0_10) AT=175.025n

.meas tran vdout0_11ck340 FIND v(dout0_11) AT=175.025n

.meas tran vdout0_12ck340 FIND v(dout0_12) AT=175.025n

.meas tran vdout0_13ck340 FIND v(dout0_13) AT=175.025n

.meas tran vdout0_14ck340 FIND v(dout0_14) AT=175.025n

.meas tran vdout0_15ck340 FIND v(dout0_15) AT=175.025n

.meas tran vdout0_16ck340 FIND v(dout0_16) AT=175.025n

.meas tran vdout0_17ck340 FIND v(dout0_17) AT=175.025n

.meas tran vdout0_18ck340 FIND v(dout0_18) AT=175.025n

.meas tran vdout0_19ck340 FIND v(dout0_19) AT=175.025n

.meas tran vdout0_20ck340 FIND v(dout0_20) AT=175.025n

.meas tran vdout0_21ck340 FIND v(dout0_21) AT=175.025n

.meas tran vdout0_22ck340 FIND v(dout0_22) AT=175.025n

.meas tran vdout0_23ck340 FIND v(dout0_23) AT=175.025n

.meas tran vdout0_24ck340 FIND v(dout0_24) AT=175.025n

.meas tran vdout0_25ck340 FIND v(dout0_25) AT=175.025n

.meas tran vdout0_26ck340 FIND v(dout0_26) AT=175.025n

.meas tran vdout0_27ck340 FIND v(dout0_27) AT=175.025n

.meas tran vdout0_28ck340 FIND v(dout0_28) AT=175.025n

.meas tran vdout0_29ck340 FIND v(dout0_29) AT=175.025n

.meas tran vdout0_30ck340 FIND v(dout0_30) AT=175.025n

.meas tran vdout0_31ck340 FIND v(dout0_31) AT=175.025n

.meas tran vdout0_0ck360 FIND v(dout0_0) AT=185.025n

.meas tran vdout0_1ck360 FIND v(dout0_1) AT=185.025n

.meas tran vdout0_2ck360 FIND v(dout0_2) AT=185.025n

.meas tran vdout0_3ck360 FIND v(dout0_3) AT=185.025n

.meas tran vdout0_4ck360 FIND v(dout0_4) AT=185.025n

.meas tran vdout0_5ck360 FIND v(dout0_5) AT=185.025n

.meas tran vdout0_6ck360 FIND v(dout0_6) AT=185.025n

.meas tran vdout0_7ck360 FIND v(dout0_7) AT=185.025n

.meas tran vdout0_8ck360 FIND v(dout0_8) AT=185.025n

.meas tran vdout0_9ck360 FIND v(dout0_9) AT=185.025n

.meas tran vdout0_10ck360 FIND v(dout0_10) AT=185.025n

.meas tran vdout0_11ck360 FIND v(dout0_11) AT=185.025n

.meas tran vdout0_12ck360 FIND v(dout0_12) AT=185.025n

.meas tran vdout0_13ck360 FIND v(dout0_13) AT=185.025n

.meas tran vdout0_14ck360 FIND v(dout0_14) AT=185.025n

.meas tran vdout0_15ck360 FIND v(dout0_15) AT=185.025n

.meas tran vdout0_16ck360 FIND v(dout0_16) AT=185.025n

.meas tran vdout0_17ck360 FIND v(dout0_17) AT=185.025n

.meas tran vdout0_18ck360 FIND v(dout0_18) AT=185.025n

.meas tran vdout0_19ck360 FIND v(dout0_19) AT=185.025n

.meas tran vdout0_20ck360 FIND v(dout0_20) AT=185.025n

.meas tran vdout0_21ck360 FIND v(dout0_21) AT=185.025n

.meas tran vdout0_22ck360 FIND v(dout0_22) AT=185.025n

.meas tran vdout0_23ck360 FIND v(dout0_23) AT=185.025n

.meas tran vdout0_24ck360 FIND v(dout0_24) AT=185.025n

.meas tran vdout0_25ck360 FIND v(dout0_25) AT=185.025n

.meas tran vdout0_26ck360 FIND v(dout0_26) AT=185.025n

.meas tran vdout0_27ck360 FIND v(dout0_27) AT=185.025n

.meas tran vdout0_28ck360 FIND v(dout0_28) AT=185.025n

.meas tran vdout0_29ck360 FIND v(dout0_29) AT=185.025n

.meas tran vdout0_30ck360 FIND v(dout0_30) AT=185.025n

.meas tran vdout0_31ck360 FIND v(dout0_31) AT=185.025n

.meas tran vdout0_0ck370 FIND v(dout0_0) AT=190.025n

.meas tran vdout0_1ck370 FIND v(dout0_1) AT=190.025n

.meas tran vdout0_2ck370 FIND v(dout0_2) AT=190.025n

.meas tran vdout0_3ck370 FIND v(dout0_3) AT=190.025n

.meas tran vdout0_4ck370 FIND v(dout0_4) AT=190.025n

.meas tran vdout0_5ck370 FIND v(dout0_5) AT=190.025n

.meas tran vdout0_6ck370 FIND v(dout0_6) AT=190.025n

.meas tran vdout0_7ck370 FIND v(dout0_7) AT=190.025n

.meas tran vdout0_8ck370 FIND v(dout0_8) AT=190.025n

.meas tran vdout0_9ck370 FIND v(dout0_9) AT=190.025n

.meas tran vdout0_10ck370 FIND v(dout0_10) AT=190.025n

.meas tran vdout0_11ck370 FIND v(dout0_11) AT=190.025n

.meas tran vdout0_12ck370 FIND v(dout0_12) AT=190.025n

.meas tran vdout0_13ck370 FIND v(dout0_13) AT=190.025n

.meas tran vdout0_14ck370 FIND v(dout0_14) AT=190.025n

.meas tran vdout0_15ck370 FIND v(dout0_15) AT=190.025n

.meas tran vdout0_16ck370 FIND v(dout0_16) AT=190.025n

.meas tran vdout0_17ck370 FIND v(dout0_17) AT=190.025n

.meas tran vdout0_18ck370 FIND v(dout0_18) AT=190.025n

.meas tran vdout0_19ck370 FIND v(dout0_19) AT=190.025n

.meas tran vdout0_20ck370 FIND v(dout0_20) AT=190.025n

.meas tran vdout0_21ck370 FIND v(dout0_21) AT=190.025n

.meas tran vdout0_22ck370 FIND v(dout0_22) AT=190.025n

.meas tran vdout0_23ck370 FIND v(dout0_23) AT=190.025n

.meas tran vdout0_24ck370 FIND v(dout0_24) AT=190.025n

.meas tran vdout0_25ck370 FIND v(dout0_25) AT=190.025n

.meas tran vdout0_26ck370 FIND v(dout0_26) AT=190.025n

.meas tran vdout0_27ck370 FIND v(dout0_27) AT=190.025n

.meas tran vdout0_28ck370 FIND v(dout0_28) AT=190.025n

.meas tran vdout0_29ck370 FIND v(dout0_29) AT=190.025n

.meas tran vdout0_30ck370 FIND v(dout0_30) AT=190.025n

.meas tran vdout0_31ck370 FIND v(dout0_31) AT=190.025n

.meas tran vdout0_0ck400 FIND v(dout0_0) AT=205.025n

.meas tran vdout0_1ck400 FIND v(dout0_1) AT=205.025n

.meas tran vdout0_2ck400 FIND v(dout0_2) AT=205.025n

.meas tran vdout0_3ck400 FIND v(dout0_3) AT=205.025n

.meas tran vdout0_4ck400 FIND v(dout0_4) AT=205.025n

.meas tran vdout0_5ck400 FIND v(dout0_5) AT=205.025n

.meas tran vdout0_6ck400 FIND v(dout0_6) AT=205.025n

.meas tran vdout0_7ck400 FIND v(dout0_7) AT=205.025n

.meas tran vdout0_8ck400 FIND v(dout0_8) AT=205.025n

.meas tran vdout0_9ck400 FIND v(dout0_9) AT=205.025n

.meas tran vdout0_10ck400 FIND v(dout0_10) AT=205.025n

.meas tran vdout0_11ck400 FIND v(dout0_11) AT=205.025n

.meas tran vdout0_12ck400 FIND v(dout0_12) AT=205.025n

.meas tran vdout0_13ck400 FIND v(dout0_13) AT=205.025n

.meas tran vdout0_14ck400 FIND v(dout0_14) AT=205.025n

.meas tran vdout0_15ck400 FIND v(dout0_15) AT=205.025n

.meas tran vdout0_16ck400 FIND v(dout0_16) AT=205.025n

.meas tran vdout0_17ck400 FIND v(dout0_17) AT=205.025n

.meas tran vdout0_18ck400 FIND v(dout0_18) AT=205.025n

.meas tran vdout0_19ck400 FIND v(dout0_19) AT=205.025n

.meas tran vdout0_20ck400 FIND v(dout0_20) AT=205.025n

.meas tran vdout0_21ck400 FIND v(dout0_21) AT=205.025n

.meas tran vdout0_22ck400 FIND v(dout0_22) AT=205.025n

.meas tran vdout0_23ck400 FIND v(dout0_23) AT=205.025n

.meas tran vdout0_24ck400 FIND v(dout0_24) AT=205.025n

.meas tran vdout0_25ck400 FIND v(dout0_25) AT=205.025n

.meas tran vdout0_26ck400 FIND v(dout0_26) AT=205.025n

.meas tran vdout0_27ck400 FIND v(dout0_27) AT=205.025n

.meas tran vdout0_28ck400 FIND v(dout0_28) AT=205.025n

.meas tran vdout0_29ck400 FIND v(dout0_29) AT=205.025n

.meas tran vdout0_30ck400 FIND v(dout0_30) AT=205.025n

.meas tran vdout0_31ck400 FIND v(dout0_31) AT=205.025n

.meas tran vdout0_0ck410 FIND v(dout0_0) AT=210.025n

.meas tran vdout0_1ck410 FIND v(dout0_1) AT=210.025n

.meas tran vdout0_2ck410 FIND v(dout0_2) AT=210.025n

.meas tran vdout0_3ck410 FIND v(dout0_3) AT=210.025n

.meas tran vdout0_4ck410 FIND v(dout0_4) AT=210.025n

.meas tran vdout0_5ck410 FIND v(dout0_5) AT=210.025n

.meas tran vdout0_6ck410 FIND v(dout0_6) AT=210.025n

.meas tran vdout0_7ck410 FIND v(dout0_7) AT=210.025n

.meas tran vdout0_8ck410 FIND v(dout0_8) AT=210.025n

.meas tran vdout0_9ck410 FIND v(dout0_9) AT=210.025n

.meas tran vdout0_10ck410 FIND v(dout0_10) AT=210.025n

.meas tran vdout0_11ck410 FIND v(dout0_11) AT=210.025n

.meas tran vdout0_12ck410 FIND v(dout0_12) AT=210.025n

.meas tran vdout0_13ck410 FIND v(dout0_13) AT=210.025n

.meas tran vdout0_14ck410 FIND v(dout0_14) AT=210.025n

.meas tran vdout0_15ck410 FIND v(dout0_15) AT=210.025n

.meas tran vdout0_16ck410 FIND v(dout0_16) AT=210.025n

.meas tran vdout0_17ck410 FIND v(dout0_17) AT=210.025n

.meas tran vdout0_18ck410 FIND v(dout0_18) AT=210.025n

.meas tran vdout0_19ck410 FIND v(dout0_19) AT=210.025n

.meas tran vdout0_20ck410 FIND v(dout0_20) AT=210.025n

.meas tran vdout0_21ck410 FIND v(dout0_21) AT=210.025n

.meas tran vdout0_22ck410 FIND v(dout0_22) AT=210.025n

.meas tran vdout0_23ck410 FIND v(dout0_23) AT=210.025n

.meas tran vdout0_24ck410 FIND v(dout0_24) AT=210.025n

.meas tran vdout0_25ck410 FIND v(dout0_25) AT=210.025n

.meas tran vdout0_26ck410 FIND v(dout0_26) AT=210.025n

.meas tran vdout0_27ck410 FIND v(dout0_27) AT=210.025n

.meas tran vdout0_28ck410 FIND v(dout0_28) AT=210.025n

.meas tran vdout0_29ck410 FIND v(dout0_29) AT=210.025n

.meas tran vdout0_30ck410 FIND v(dout0_30) AT=210.025n

.meas tran vdout0_31ck410 FIND v(dout0_31) AT=210.025n

.meas tran vdout0_0ck420 FIND v(dout0_0) AT=215.025n

.meas tran vdout0_1ck420 FIND v(dout0_1) AT=215.025n

.meas tran vdout0_2ck420 FIND v(dout0_2) AT=215.025n

.meas tran vdout0_3ck420 FIND v(dout0_3) AT=215.025n

.meas tran vdout0_4ck420 FIND v(dout0_4) AT=215.025n

.meas tran vdout0_5ck420 FIND v(dout0_5) AT=215.025n

.meas tran vdout0_6ck420 FIND v(dout0_6) AT=215.025n

.meas tran vdout0_7ck420 FIND v(dout0_7) AT=215.025n

.meas tran vdout0_8ck420 FIND v(dout0_8) AT=215.025n

.meas tran vdout0_9ck420 FIND v(dout0_9) AT=215.025n

.meas tran vdout0_10ck420 FIND v(dout0_10) AT=215.025n

.meas tran vdout0_11ck420 FIND v(dout0_11) AT=215.025n

.meas tran vdout0_12ck420 FIND v(dout0_12) AT=215.025n

.meas tran vdout0_13ck420 FIND v(dout0_13) AT=215.025n

.meas tran vdout0_14ck420 FIND v(dout0_14) AT=215.025n

.meas tran vdout0_15ck420 FIND v(dout0_15) AT=215.025n

.meas tran vdout0_16ck420 FIND v(dout0_16) AT=215.025n

.meas tran vdout0_17ck420 FIND v(dout0_17) AT=215.025n

.meas tran vdout0_18ck420 FIND v(dout0_18) AT=215.025n

.meas tran vdout0_19ck420 FIND v(dout0_19) AT=215.025n

.meas tran vdout0_20ck420 FIND v(dout0_20) AT=215.025n

.meas tran vdout0_21ck420 FIND v(dout0_21) AT=215.025n

.meas tran vdout0_22ck420 FIND v(dout0_22) AT=215.025n

.meas tran vdout0_23ck420 FIND v(dout0_23) AT=215.025n

.meas tran vdout0_24ck420 FIND v(dout0_24) AT=215.025n

.meas tran vdout0_25ck420 FIND v(dout0_25) AT=215.025n

.meas tran vdout0_26ck420 FIND v(dout0_26) AT=215.025n

.meas tran vdout0_27ck420 FIND v(dout0_27) AT=215.025n

.meas tran vdout0_28ck420 FIND v(dout0_28) AT=215.025n

.meas tran vdout0_29ck420 FIND v(dout0_29) AT=215.025n

.meas tran vdout0_30ck420 FIND v(dout0_30) AT=215.025n

.meas tran vdout0_31ck420 FIND v(dout0_31) AT=215.025n

.meas tran vdout0_0ck440 FIND v(dout0_0) AT=225.025n

.meas tran vdout0_1ck440 FIND v(dout0_1) AT=225.025n

.meas tran vdout0_2ck440 FIND v(dout0_2) AT=225.025n

.meas tran vdout0_3ck440 FIND v(dout0_3) AT=225.025n

.meas tran vdout0_4ck440 FIND v(dout0_4) AT=225.025n

.meas tran vdout0_5ck440 FIND v(dout0_5) AT=225.025n

.meas tran vdout0_6ck440 FIND v(dout0_6) AT=225.025n

.meas tran vdout0_7ck440 FIND v(dout0_7) AT=225.025n

.meas tran vdout0_8ck440 FIND v(dout0_8) AT=225.025n

.meas tran vdout0_9ck440 FIND v(dout0_9) AT=225.025n

.meas tran vdout0_10ck440 FIND v(dout0_10) AT=225.025n

.meas tran vdout0_11ck440 FIND v(dout0_11) AT=225.025n

.meas tran vdout0_12ck440 FIND v(dout0_12) AT=225.025n

.meas tran vdout0_13ck440 FIND v(dout0_13) AT=225.025n

.meas tran vdout0_14ck440 FIND v(dout0_14) AT=225.025n

.meas tran vdout0_15ck440 FIND v(dout0_15) AT=225.025n

.meas tran vdout0_16ck440 FIND v(dout0_16) AT=225.025n

.meas tran vdout0_17ck440 FIND v(dout0_17) AT=225.025n

.meas tran vdout0_18ck440 FIND v(dout0_18) AT=225.025n

.meas tran vdout0_19ck440 FIND v(dout0_19) AT=225.025n

.meas tran vdout0_20ck440 FIND v(dout0_20) AT=225.025n

.meas tran vdout0_21ck440 FIND v(dout0_21) AT=225.025n

.meas tran vdout0_22ck440 FIND v(dout0_22) AT=225.025n

.meas tran vdout0_23ck440 FIND v(dout0_23) AT=225.025n

.meas tran vdout0_24ck440 FIND v(dout0_24) AT=225.025n

.meas tran vdout0_25ck440 FIND v(dout0_25) AT=225.025n

.meas tran vdout0_26ck440 FIND v(dout0_26) AT=225.025n

.meas tran vdout0_27ck440 FIND v(dout0_27) AT=225.025n

.meas tran vdout0_28ck440 FIND v(dout0_28) AT=225.025n

.meas tran vdout0_29ck440 FIND v(dout0_29) AT=225.025n

.meas tran vdout0_30ck440 FIND v(dout0_30) AT=225.025n

.meas tran vdout0_31ck440 FIND v(dout0_31) AT=225.025n

.meas tran vdout0_0ck450 FIND v(dout0_0) AT=230.025n

.meas tran vdout0_1ck450 FIND v(dout0_1) AT=230.025n

.meas tran vdout0_2ck450 FIND v(dout0_2) AT=230.025n

.meas tran vdout0_3ck450 FIND v(dout0_3) AT=230.025n

.meas tran vdout0_4ck450 FIND v(dout0_4) AT=230.025n

.meas tran vdout0_5ck450 FIND v(dout0_5) AT=230.025n

.meas tran vdout0_6ck450 FIND v(dout0_6) AT=230.025n

.meas tran vdout0_7ck450 FIND v(dout0_7) AT=230.025n

.meas tran vdout0_8ck450 FIND v(dout0_8) AT=230.025n

.meas tran vdout0_9ck450 FIND v(dout0_9) AT=230.025n

.meas tran vdout0_10ck450 FIND v(dout0_10) AT=230.025n

.meas tran vdout0_11ck450 FIND v(dout0_11) AT=230.025n

.meas tran vdout0_12ck450 FIND v(dout0_12) AT=230.025n

.meas tran vdout0_13ck450 FIND v(dout0_13) AT=230.025n

.meas tran vdout0_14ck450 FIND v(dout0_14) AT=230.025n

.meas tran vdout0_15ck450 FIND v(dout0_15) AT=230.025n

.meas tran vdout0_16ck450 FIND v(dout0_16) AT=230.025n

.meas tran vdout0_17ck450 FIND v(dout0_17) AT=230.025n

.meas tran vdout0_18ck450 FIND v(dout0_18) AT=230.025n

.meas tran vdout0_19ck450 FIND v(dout0_19) AT=230.025n

.meas tran vdout0_20ck450 FIND v(dout0_20) AT=230.025n

.meas tran vdout0_21ck450 FIND v(dout0_21) AT=230.025n

.meas tran vdout0_22ck450 FIND v(dout0_22) AT=230.025n

.meas tran vdout0_23ck450 FIND v(dout0_23) AT=230.025n

.meas tran vdout0_24ck450 FIND v(dout0_24) AT=230.025n

.meas tran vdout0_25ck450 FIND v(dout0_25) AT=230.025n

.meas tran vdout0_26ck450 FIND v(dout0_26) AT=230.025n

.meas tran vdout0_27ck450 FIND v(dout0_27) AT=230.025n

.meas tran vdout0_28ck450 FIND v(dout0_28) AT=230.025n

.meas tran vdout0_29ck450 FIND v(dout0_29) AT=230.025n

.meas tran vdout0_30ck450 FIND v(dout0_30) AT=230.025n

.meas tran vdout0_31ck450 FIND v(dout0_31) AT=230.025n

.meas tran vdout0_0ck460 FIND v(dout0_0) AT=235.025n

.meas tran vdout0_1ck460 FIND v(dout0_1) AT=235.025n

.meas tran vdout0_2ck460 FIND v(dout0_2) AT=235.025n

.meas tran vdout0_3ck460 FIND v(dout0_3) AT=235.025n

.meas tran vdout0_4ck460 FIND v(dout0_4) AT=235.025n

.meas tran vdout0_5ck460 FIND v(dout0_5) AT=235.025n

.meas tran vdout0_6ck460 FIND v(dout0_6) AT=235.025n

.meas tran vdout0_7ck460 FIND v(dout0_7) AT=235.025n

.meas tran vdout0_8ck460 FIND v(dout0_8) AT=235.025n

.meas tran vdout0_9ck460 FIND v(dout0_9) AT=235.025n

.meas tran vdout0_10ck460 FIND v(dout0_10) AT=235.025n

.meas tran vdout0_11ck460 FIND v(dout0_11) AT=235.025n

.meas tran vdout0_12ck460 FIND v(dout0_12) AT=235.025n

.meas tran vdout0_13ck460 FIND v(dout0_13) AT=235.025n

.meas tran vdout0_14ck460 FIND v(dout0_14) AT=235.025n

.meas tran vdout0_15ck460 FIND v(dout0_15) AT=235.025n

.meas tran vdout0_16ck460 FIND v(dout0_16) AT=235.025n

.meas tran vdout0_17ck460 FIND v(dout0_17) AT=235.025n

.meas tran vdout0_18ck460 FIND v(dout0_18) AT=235.025n

.meas tran vdout0_19ck460 FIND v(dout0_19) AT=235.025n

.meas tran vdout0_20ck460 FIND v(dout0_20) AT=235.025n

.meas tran vdout0_21ck460 FIND v(dout0_21) AT=235.025n

.meas tran vdout0_22ck460 FIND v(dout0_22) AT=235.025n

.meas tran vdout0_23ck460 FIND v(dout0_23) AT=235.025n

.meas tran vdout0_24ck460 FIND v(dout0_24) AT=235.025n

.meas tran vdout0_25ck460 FIND v(dout0_25) AT=235.025n

.meas tran vdout0_26ck460 FIND v(dout0_26) AT=235.025n

.meas tran vdout0_27ck460 FIND v(dout0_27) AT=235.025n

.meas tran vdout0_28ck460 FIND v(dout0_28) AT=235.025n

.meas tran vdout0_29ck460 FIND v(dout0_29) AT=235.025n

.meas tran vdout0_30ck460 FIND v(dout0_30) AT=235.025n

.meas tran vdout0_31ck460 FIND v(dout0_31) AT=235.025n

.meas tran vdout0_0ck470 FIND v(dout0_0) AT=240.025n

.meas tran vdout0_1ck470 FIND v(dout0_1) AT=240.025n

.meas tran vdout0_2ck470 FIND v(dout0_2) AT=240.025n

.meas tran vdout0_3ck470 FIND v(dout0_3) AT=240.025n

.meas tran vdout0_4ck470 FIND v(dout0_4) AT=240.025n

.meas tran vdout0_5ck470 FIND v(dout0_5) AT=240.025n

.meas tran vdout0_6ck470 FIND v(dout0_6) AT=240.025n

.meas tran vdout0_7ck470 FIND v(dout0_7) AT=240.025n

.meas tran vdout0_8ck470 FIND v(dout0_8) AT=240.025n

.meas tran vdout0_9ck470 FIND v(dout0_9) AT=240.025n

.meas tran vdout0_10ck470 FIND v(dout0_10) AT=240.025n

.meas tran vdout0_11ck470 FIND v(dout0_11) AT=240.025n

.meas tran vdout0_12ck470 FIND v(dout0_12) AT=240.025n

.meas tran vdout0_13ck470 FIND v(dout0_13) AT=240.025n

.meas tran vdout0_14ck470 FIND v(dout0_14) AT=240.025n

.meas tran vdout0_15ck470 FIND v(dout0_15) AT=240.025n

.meas tran vdout0_16ck470 FIND v(dout0_16) AT=240.025n

.meas tran vdout0_17ck470 FIND v(dout0_17) AT=240.025n

.meas tran vdout0_18ck470 FIND v(dout0_18) AT=240.025n

.meas tran vdout0_19ck470 FIND v(dout0_19) AT=240.025n

.meas tran vdout0_20ck470 FIND v(dout0_20) AT=240.025n

.meas tran vdout0_21ck470 FIND v(dout0_21) AT=240.025n

.meas tran vdout0_22ck470 FIND v(dout0_22) AT=240.025n

.meas tran vdout0_23ck470 FIND v(dout0_23) AT=240.025n

.meas tran vdout0_24ck470 FIND v(dout0_24) AT=240.025n

.meas tran vdout0_25ck470 FIND v(dout0_25) AT=240.025n

.meas tran vdout0_26ck470 FIND v(dout0_26) AT=240.025n

.meas tran vdout0_27ck470 FIND v(dout0_27) AT=240.025n

.meas tran vdout0_28ck470 FIND v(dout0_28) AT=240.025n

.meas tran vdout0_29ck470 FIND v(dout0_29) AT=240.025n

.meas tran vdout0_30ck470 FIND v(dout0_30) AT=240.025n

.meas tran vdout0_31ck470 FIND v(dout0_31) AT=240.025n

.meas tran vdout0_0ck490 FIND v(dout0_0) AT=250.025n

.meas tran vdout0_1ck490 FIND v(dout0_1) AT=250.025n

.meas tran vdout0_2ck490 FIND v(dout0_2) AT=250.025n

.meas tran vdout0_3ck490 FIND v(dout0_3) AT=250.025n

.meas tran vdout0_4ck490 FIND v(dout0_4) AT=250.025n

.meas tran vdout0_5ck490 FIND v(dout0_5) AT=250.025n

.meas tran vdout0_6ck490 FIND v(dout0_6) AT=250.025n

.meas tran vdout0_7ck490 FIND v(dout0_7) AT=250.025n

.meas tran vdout0_8ck490 FIND v(dout0_8) AT=250.025n

.meas tran vdout0_9ck490 FIND v(dout0_9) AT=250.025n

.meas tran vdout0_10ck490 FIND v(dout0_10) AT=250.025n

.meas tran vdout0_11ck490 FIND v(dout0_11) AT=250.025n

.meas tran vdout0_12ck490 FIND v(dout0_12) AT=250.025n

.meas tran vdout0_13ck490 FIND v(dout0_13) AT=250.025n

.meas tran vdout0_14ck490 FIND v(dout0_14) AT=250.025n

.meas tran vdout0_15ck490 FIND v(dout0_15) AT=250.025n

.meas tran vdout0_16ck490 FIND v(dout0_16) AT=250.025n

.meas tran vdout0_17ck490 FIND v(dout0_17) AT=250.025n

.meas tran vdout0_18ck490 FIND v(dout0_18) AT=250.025n

.meas tran vdout0_19ck490 FIND v(dout0_19) AT=250.025n

.meas tran vdout0_20ck490 FIND v(dout0_20) AT=250.025n

.meas tran vdout0_21ck490 FIND v(dout0_21) AT=250.025n

.meas tran vdout0_22ck490 FIND v(dout0_22) AT=250.025n

.meas tran vdout0_23ck490 FIND v(dout0_23) AT=250.025n

.meas tran vdout0_24ck490 FIND v(dout0_24) AT=250.025n

.meas tran vdout0_25ck490 FIND v(dout0_25) AT=250.025n

.meas tran vdout0_26ck490 FIND v(dout0_26) AT=250.025n

.meas tran vdout0_27ck490 FIND v(dout0_27) AT=250.025n

.meas tran vdout0_28ck490 FIND v(dout0_28) AT=250.025n

.meas tran vdout0_29ck490 FIND v(dout0_29) AT=250.025n

.meas tran vdout0_30ck490 FIND v(dout0_30) AT=250.025n

.meas tran vdout0_31ck490 FIND v(dout0_31) AT=250.025n

.meas tran vdout0_0ck540 FIND v(dout0_0) AT=275.025n

.meas tran vdout0_1ck540 FIND v(dout0_1) AT=275.025n

.meas tran vdout0_2ck540 FIND v(dout0_2) AT=275.025n

.meas tran vdout0_3ck540 FIND v(dout0_3) AT=275.025n

.meas tran vdout0_4ck540 FIND v(dout0_4) AT=275.025n

.meas tran vdout0_5ck540 FIND v(dout0_5) AT=275.025n

.meas tran vdout0_6ck540 FIND v(dout0_6) AT=275.025n

.meas tran vdout0_7ck540 FIND v(dout0_7) AT=275.025n

.meas tran vdout0_8ck540 FIND v(dout0_8) AT=275.025n

.meas tran vdout0_9ck540 FIND v(dout0_9) AT=275.025n

.meas tran vdout0_10ck540 FIND v(dout0_10) AT=275.025n

.meas tran vdout0_11ck540 FIND v(dout0_11) AT=275.025n

.meas tran vdout0_12ck540 FIND v(dout0_12) AT=275.025n

.meas tran vdout0_13ck540 FIND v(dout0_13) AT=275.025n

.meas tran vdout0_14ck540 FIND v(dout0_14) AT=275.025n

.meas tran vdout0_15ck540 FIND v(dout0_15) AT=275.025n

.meas tran vdout0_16ck540 FIND v(dout0_16) AT=275.025n

.meas tran vdout0_17ck540 FIND v(dout0_17) AT=275.025n

.meas tran vdout0_18ck540 FIND v(dout0_18) AT=275.025n

.meas tran vdout0_19ck540 FIND v(dout0_19) AT=275.025n

.meas tran vdout0_20ck540 FIND v(dout0_20) AT=275.025n

.meas tran vdout0_21ck540 FIND v(dout0_21) AT=275.025n

.meas tran vdout0_22ck540 FIND v(dout0_22) AT=275.025n

.meas tran vdout0_23ck540 FIND v(dout0_23) AT=275.025n

.meas tran vdout0_24ck540 FIND v(dout0_24) AT=275.025n

.meas tran vdout0_25ck540 FIND v(dout0_25) AT=275.025n

.meas tran vdout0_26ck540 FIND v(dout0_26) AT=275.025n

.meas tran vdout0_27ck540 FIND v(dout0_27) AT=275.025n

.meas tran vdout0_28ck540 FIND v(dout0_28) AT=275.025n

.meas tran vdout0_29ck540 FIND v(dout0_29) AT=275.025n

.meas tran vdout0_30ck540 FIND v(dout0_30) AT=275.025n

.meas tran vdout0_31ck540 FIND v(dout0_31) AT=275.025n

.meas tran vdout0_0ck550 FIND v(dout0_0) AT=280.025n

.meas tran vdout0_1ck550 FIND v(dout0_1) AT=280.025n

.meas tran vdout0_2ck550 FIND v(dout0_2) AT=280.025n

.meas tran vdout0_3ck550 FIND v(dout0_3) AT=280.025n

.meas tran vdout0_4ck550 FIND v(dout0_4) AT=280.025n

.meas tran vdout0_5ck550 FIND v(dout0_5) AT=280.025n

.meas tran vdout0_6ck550 FIND v(dout0_6) AT=280.025n

.meas tran vdout0_7ck550 FIND v(dout0_7) AT=280.025n

.meas tran vdout0_8ck550 FIND v(dout0_8) AT=280.025n

.meas tran vdout0_9ck550 FIND v(dout0_9) AT=280.025n

.meas tran vdout0_10ck550 FIND v(dout0_10) AT=280.025n

.meas tran vdout0_11ck550 FIND v(dout0_11) AT=280.025n

.meas tran vdout0_12ck550 FIND v(dout0_12) AT=280.025n

.meas tran vdout0_13ck550 FIND v(dout0_13) AT=280.025n

.meas tran vdout0_14ck550 FIND v(dout0_14) AT=280.025n

.meas tran vdout0_15ck550 FIND v(dout0_15) AT=280.025n

.meas tran vdout0_16ck550 FIND v(dout0_16) AT=280.025n

.meas tran vdout0_17ck550 FIND v(dout0_17) AT=280.025n

.meas tran vdout0_18ck550 FIND v(dout0_18) AT=280.025n

.meas tran vdout0_19ck550 FIND v(dout0_19) AT=280.025n

.meas tran vdout0_20ck550 FIND v(dout0_20) AT=280.025n

.meas tran vdout0_21ck550 FIND v(dout0_21) AT=280.025n

.meas tran vdout0_22ck550 FIND v(dout0_22) AT=280.025n

.meas tran vdout0_23ck550 FIND v(dout0_23) AT=280.025n

.meas tran vdout0_24ck550 FIND v(dout0_24) AT=280.025n

.meas tran vdout0_25ck550 FIND v(dout0_25) AT=280.025n

.meas tran vdout0_26ck550 FIND v(dout0_26) AT=280.025n

.meas tran vdout0_27ck550 FIND v(dout0_27) AT=280.025n

.meas tran vdout0_28ck550 FIND v(dout0_28) AT=280.025n

.meas tran vdout0_29ck550 FIND v(dout0_29) AT=280.025n

.meas tran vdout0_30ck550 FIND v(dout0_30) AT=280.025n

.meas tran vdout0_31ck550 FIND v(dout0_31) AT=280.025n

.meas tran vdout0_0ck560 FIND v(dout0_0) AT=285.025n

.meas tran vdout0_1ck560 FIND v(dout0_1) AT=285.025n

.meas tran vdout0_2ck560 FIND v(dout0_2) AT=285.025n

.meas tran vdout0_3ck560 FIND v(dout0_3) AT=285.025n

.meas tran vdout0_4ck560 FIND v(dout0_4) AT=285.025n

.meas tran vdout0_5ck560 FIND v(dout0_5) AT=285.025n

.meas tran vdout0_6ck560 FIND v(dout0_6) AT=285.025n

.meas tran vdout0_7ck560 FIND v(dout0_7) AT=285.025n

.meas tran vdout0_8ck560 FIND v(dout0_8) AT=285.025n

.meas tran vdout0_9ck560 FIND v(dout0_9) AT=285.025n

.meas tran vdout0_10ck560 FIND v(dout0_10) AT=285.025n

.meas tran vdout0_11ck560 FIND v(dout0_11) AT=285.025n

.meas tran vdout0_12ck560 FIND v(dout0_12) AT=285.025n

.meas tran vdout0_13ck560 FIND v(dout0_13) AT=285.025n

.meas tran vdout0_14ck560 FIND v(dout0_14) AT=285.025n

.meas tran vdout0_15ck560 FIND v(dout0_15) AT=285.025n

.meas tran vdout0_16ck560 FIND v(dout0_16) AT=285.025n

.meas tran vdout0_17ck560 FIND v(dout0_17) AT=285.025n

.meas tran vdout0_18ck560 FIND v(dout0_18) AT=285.025n

.meas tran vdout0_19ck560 FIND v(dout0_19) AT=285.025n

.meas tran vdout0_20ck560 FIND v(dout0_20) AT=285.025n

.meas tran vdout0_21ck560 FIND v(dout0_21) AT=285.025n

.meas tran vdout0_22ck560 FIND v(dout0_22) AT=285.025n

.meas tran vdout0_23ck560 FIND v(dout0_23) AT=285.025n

.meas tran vdout0_24ck560 FIND v(dout0_24) AT=285.025n

.meas tran vdout0_25ck560 FIND v(dout0_25) AT=285.025n

.meas tran vdout0_26ck560 FIND v(dout0_26) AT=285.025n

.meas tran vdout0_27ck560 FIND v(dout0_27) AT=285.025n

.meas tran vdout0_28ck560 FIND v(dout0_28) AT=285.025n

.meas tran vdout0_29ck560 FIND v(dout0_29) AT=285.025n

.meas tran vdout0_30ck560 FIND v(dout0_30) AT=285.025n

.meas tran vdout0_31ck560 FIND v(dout0_31) AT=285.025n

.meas tran vdout0_0ck590 FIND v(dout0_0) AT=300.025n

.meas tran vdout0_1ck590 FIND v(dout0_1) AT=300.025n

.meas tran vdout0_2ck590 FIND v(dout0_2) AT=300.025n

.meas tran vdout0_3ck590 FIND v(dout0_3) AT=300.025n

.meas tran vdout0_4ck590 FIND v(dout0_4) AT=300.025n

.meas tran vdout0_5ck590 FIND v(dout0_5) AT=300.025n

.meas tran vdout0_6ck590 FIND v(dout0_6) AT=300.025n

.meas tran vdout0_7ck590 FIND v(dout0_7) AT=300.025n

.meas tran vdout0_8ck590 FIND v(dout0_8) AT=300.025n

.meas tran vdout0_9ck590 FIND v(dout0_9) AT=300.025n

.meas tran vdout0_10ck590 FIND v(dout0_10) AT=300.025n

.meas tran vdout0_11ck590 FIND v(dout0_11) AT=300.025n

.meas tran vdout0_12ck590 FIND v(dout0_12) AT=300.025n

.meas tran vdout0_13ck590 FIND v(dout0_13) AT=300.025n

.meas tran vdout0_14ck590 FIND v(dout0_14) AT=300.025n

.meas tran vdout0_15ck590 FIND v(dout0_15) AT=300.025n

.meas tran vdout0_16ck590 FIND v(dout0_16) AT=300.025n

.meas tran vdout0_17ck590 FIND v(dout0_17) AT=300.025n

.meas tran vdout0_18ck590 FIND v(dout0_18) AT=300.025n

.meas tran vdout0_19ck590 FIND v(dout0_19) AT=300.025n

.meas tran vdout0_20ck590 FIND v(dout0_20) AT=300.025n

.meas tran vdout0_21ck590 FIND v(dout0_21) AT=300.025n

.meas tran vdout0_22ck590 FIND v(dout0_22) AT=300.025n

.meas tran vdout0_23ck590 FIND v(dout0_23) AT=300.025n

.meas tran vdout0_24ck590 FIND v(dout0_24) AT=300.025n

.meas tran vdout0_25ck590 FIND v(dout0_25) AT=300.025n

.meas tran vdout0_26ck590 FIND v(dout0_26) AT=300.025n

.meas tran vdout0_27ck590 FIND v(dout0_27) AT=300.025n

.meas tran vdout0_28ck590 FIND v(dout0_28) AT=300.025n

.meas tran vdout0_29ck590 FIND v(dout0_29) AT=300.025n

.meas tran vdout0_30ck590 FIND v(dout0_30) AT=300.025n

.meas tran vdout0_31ck590 FIND v(dout0_31) AT=300.025n

.meas tran vdout0_0ck600 FIND v(dout0_0) AT=305.025n

.meas tran vdout0_1ck600 FIND v(dout0_1) AT=305.025n

.meas tran vdout0_2ck600 FIND v(dout0_2) AT=305.025n

.meas tran vdout0_3ck600 FIND v(dout0_3) AT=305.025n

.meas tran vdout0_4ck600 FIND v(dout0_4) AT=305.025n

.meas tran vdout0_5ck600 FIND v(dout0_5) AT=305.025n

.meas tran vdout0_6ck600 FIND v(dout0_6) AT=305.025n

.meas tran vdout0_7ck600 FIND v(dout0_7) AT=305.025n

.meas tran vdout0_8ck600 FIND v(dout0_8) AT=305.025n

.meas tran vdout0_9ck600 FIND v(dout0_9) AT=305.025n

.meas tran vdout0_10ck600 FIND v(dout0_10) AT=305.025n

.meas tran vdout0_11ck600 FIND v(dout0_11) AT=305.025n

.meas tran vdout0_12ck600 FIND v(dout0_12) AT=305.025n

.meas tran vdout0_13ck600 FIND v(dout0_13) AT=305.025n

.meas tran vdout0_14ck600 FIND v(dout0_14) AT=305.025n

.meas tran vdout0_15ck600 FIND v(dout0_15) AT=305.025n

.meas tran vdout0_16ck600 FIND v(dout0_16) AT=305.025n

.meas tran vdout0_17ck600 FIND v(dout0_17) AT=305.025n

.meas tran vdout0_18ck600 FIND v(dout0_18) AT=305.025n

.meas tran vdout0_19ck600 FIND v(dout0_19) AT=305.025n

.meas tran vdout0_20ck600 FIND v(dout0_20) AT=305.025n

.meas tran vdout0_21ck600 FIND v(dout0_21) AT=305.025n

.meas tran vdout0_22ck600 FIND v(dout0_22) AT=305.025n

.meas tran vdout0_23ck600 FIND v(dout0_23) AT=305.025n

.meas tran vdout0_24ck600 FIND v(dout0_24) AT=305.025n

.meas tran vdout0_25ck600 FIND v(dout0_25) AT=305.025n

.meas tran vdout0_26ck600 FIND v(dout0_26) AT=305.025n

.meas tran vdout0_27ck600 FIND v(dout0_27) AT=305.025n

.meas tran vdout0_28ck600 FIND v(dout0_28) AT=305.025n

.meas tran vdout0_29ck600 FIND v(dout0_29) AT=305.025n

.meas tran vdout0_30ck600 FIND v(dout0_30) AT=305.025n

.meas tran vdout0_31ck600 FIND v(dout0_31) AT=305.025n

.meas tran vdout0_0ck610 FIND v(dout0_0) AT=310.025n

.meas tran vdout0_1ck610 FIND v(dout0_1) AT=310.025n

.meas tran vdout0_2ck610 FIND v(dout0_2) AT=310.025n

.meas tran vdout0_3ck610 FIND v(dout0_3) AT=310.025n

.meas tran vdout0_4ck610 FIND v(dout0_4) AT=310.025n

.meas tran vdout0_5ck610 FIND v(dout0_5) AT=310.025n

.meas tran vdout0_6ck610 FIND v(dout0_6) AT=310.025n

.meas tran vdout0_7ck610 FIND v(dout0_7) AT=310.025n

.meas tran vdout0_8ck610 FIND v(dout0_8) AT=310.025n

.meas tran vdout0_9ck610 FIND v(dout0_9) AT=310.025n

.meas tran vdout0_10ck610 FIND v(dout0_10) AT=310.025n

.meas tran vdout0_11ck610 FIND v(dout0_11) AT=310.025n

.meas tran vdout0_12ck610 FIND v(dout0_12) AT=310.025n

.meas tran vdout0_13ck610 FIND v(dout0_13) AT=310.025n

.meas tran vdout0_14ck610 FIND v(dout0_14) AT=310.025n

.meas tran vdout0_15ck610 FIND v(dout0_15) AT=310.025n

.meas tran vdout0_16ck610 FIND v(dout0_16) AT=310.025n

.meas tran vdout0_17ck610 FIND v(dout0_17) AT=310.025n

.meas tran vdout0_18ck610 FIND v(dout0_18) AT=310.025n

.meas tran vdout0_19ck610 FIND v(dout0_19) AT=310.025n

.meas tran vdout0_20ck610 FIND v(dout0_20) AT=310.025n

.meas tran vdout0_21ck610 FIND v(dout0_21) AT=310.025n

.meas tran vdout0_22ck610 FIND v(dout0_22) AT=310.025n

.meas tran vdout0_23ck610 FIND v(dout0_23) AT=310.025n

.meas tran vdout0_24ck610 FIND v(dout0_24) AT=310.025n

.meas tran vdout0_25ck610 FIND v(dout0_25) AT=310.025n

.meas tran vdout0_26ck610 FIND v(dout0_26) AT=310.025n

.meas tran vdout0_27ck610 FIND v(dout0_27) AT=310.025n

.meas tran vdout0_28ck610 FIND v(dout0_28) AT=310.025n

.meas tran vdout0_29ck610 FIND v(dout0_29) AT=310.025n

.meas tran vdout0_30ck610 FIND v(dout0_30) AT=310.025n

.meas tran vdout0_31ck610 FIND v(dout0_31) AT=310.025n

.meas tran vdout0_0ck620 FIND v(dout0_0) AT=315.025n

.meas tran vdout0_1ck620 FIND v(dout0_1) AT=315.025n

.meas tran vdout0_2ck620 FIND v(dout0_2) AT=315.025n

.meas tran vdout0_3ck620 FIND v(dout0_3) AT=315.025n

.meas tran vdout0_4ck620 FIND v(dout0_4) AT=315.025n

.meas tran vdout0_5ck620 FIND v(dout0_5) AT=315.025n

.meas tran vdout0_6ck620 FIND v(dout0_6) AT=315.025n

.meas tran vdout0_7ck620 FIND v(dout0_7) AT=315.025n

.meas tran vdout0_8ck620 FIND v(dout0_8) AT=315.025n

.meas tran vdout0_9ck620 FIND v(dout0_9) AT=315.025n

.meas tran vdout0_10ck620 FIND v(dout0_10) AT=315.025n

.meas tran vdout0_11ck620 FIND v(dout0_11) AT=315.025n

.meas tran vdout0_12ck620 FIND v(dout0_12) AT=315.025n

.meas tran vdout0_13ck620 FIND v(dout0_13) AT=315.025n

.meas tran vdout0_14ck620 FIND v(dout0_14) AT=315.025n

.meas tran vdout0_15ck620 FIND v(dout0_15) AT=315.025n

.meas tran vdout0_16ck620 FIND v(dout0_16) AT=315.025n

.meas tran vdout0_17ck620 FIND v(dout0_17) AT=315.025n

.meas tran vdout0_18ck620 FIND v(dout0_18) AT=315.025n

.meas tran vdout0_19ck620 FIND v(dout0_19) AT=315.025n

.meas tran vdout0_20ck620 FIND v(dout0_20) AT=315.025n

.meas tran vdout0_21ck620 FIND v(dout0_21) AT=315.025n

.meas tran vdout0_22ck620 FIND v(dout0_22) AT=315.025n

.meas tran vdout0_23ck620 FIND v(dout0_23) AT=315.025n

.meas tran vdout0_24ck620 FIND v(dout0_24) AT=315.025n

.meas tran vdout0_25ck620 FIND v(dout0_25) AT=315.025n

.meas tran vdout0_26ck620 FIND v(dout0_26) AT=315.025n

.meas tran vdout0_27ck620 FIND v(dout0_27) AT=315.025n

.meas tran vdout0_28ck620 FIND v(dout0_28) AT=315.025n

.meas tran vdout0_29ck620 FIND v(dout0_29) AT=315.025n

.meas tran vdout0_30ck620 FIND v(dout0_30) AT=315.025n

.meas tran vdout0_31ck620 FIND v(dout0_31) AT=315.025n

.meas tran vdout0_0ck690 FIND v(dout0_0) AT=350.025n

.meas tran vdout0_1ck690 FIND v(dout0_1) AT=350.025n

.meas tran vdout0_2ck690 FIND v(dout0_2) AT=350.025n

.meas tran vdout0_3ck690 FIND v(dout0_3) AT=350.025n

.meas tran vdout0_4ck690 FIND v(dout0_4) AT=350.025n

.meas tran vdout0_5ck690 FIND v(dout0_5) AT=350.025n

.meas tran vdout0_6ck690 FIND v(dout0_6) AT=350.025n

.meas tran vdout0_7ck690 FIND v(dout0_7) AT=350.025n

.meas tran vdout0_8ck690 FIND v(dout0_8) AT=350.025n

.meas tran vdout0_9ck690 FIND v(dout0_9) AT=350.025n

.meas tran vdout0_10ck690 FIND v(dout0_10) AT=350.025n

.meas tran vdout0_11ck690 FIND v(dout0_11) AT=350.025n

.meas tran vdout0_12ck690 FIND v(dout0_12) AT=350.025n

.meas tran vdout0_13ck690 FIND v(dout0_13) AT=350.025n

.meas tran vdout0_14ck690 FIND v(dout0_14) AT=350.025n

.meas tran vdout0_15ck690 FIND v(dout0_15) AT=350.025n

.meas tran vdout0_16ck690 FIND v(dout0_16) AT=350.025n

.meas tran vdout0_17ck690 FIND v(dout0_17) AT=350.025n

.meas tran vdout0_18ck690 FIND v(dout0_18) AT=350.025n

.meas tran vdout0_19ck690 FIND v(dout0_19) AT=350.025n

.meas tran vdout0_20ck690 FIND v(dout0_20) AT=350.025n

.meas tran vdout0_21ck690 FIND v(dout0_21) AT=350.025n

.meas tran vdout0_22ck690 FIND v(dout0_22) AT=350.025n

.meas tran vdout0_23ck690 FIND v(dout0_23) AT=350.025n

.meas tran vdout0_24ck690 FIND v(dout0_24) AT=350.025n

.meas tran vdout0_25ck690 FIND v(dout0_25) AT=350.025n

.meas tran vdout0_26ck690 FIND v(dout0_26) AT=350.025n

.meas tran vdout0_27ck690 FIND v(dout0_27) AT=350.025n

.meas tran vdout0_28ck690 FIND v(dout0_28) AT=350.025n

.meas tran vdout0_29ck690 FIND v(dout0_29) AT=350.025n

.meas tran vdout0_30ck690 FIND v(dout0_30) AT=350.025n

.meas tran vdout0_31ck690 FIND v(dout0_31) AT=350.025n

.meas tran vdout0_0ck710 FIND v(dout0_0) AT=360.025n

.meas tran vdout0_1ck710 FIND v(dout0_1) AT=360.025n

.meas tran vdout0_2ck710 FIND v(dout0_2) AT=360.025n

.meas tran vdout0_3ck710 FIND v(dout0_3) AT=360.025n

.meas tran vdout0_4ck710 FIND v(dout0_4) AT=360.025n

.meas tran vdout0_5ck710 FIND v(dout0_5) AT=360.025n

.meas tran vdout0_6ck710 FIND v(dout0_6) AT=360.025n

.meas tran vdout0_7ck710 FIND v(dout0_7) AT=360.025n

.meas tran vdout0_8ck710 FIND v(dout0_8) AT=360.025n

.meas tran vdout0_9ck710 FIND v(dout0_9) AT=360.025n

.meas tran vdout0_10ck710 FIND v(dout0_10) AT=360.025n

.meas tran vdout0_11ck710 FIND v(dout0_11) AT=360.025n

.meas tran vdout0_12ck710 FIND v(dout0_12) AT=360.025n

.meas tran vdout0_13ck710 FIND v(dout0_13) AT=360.025n

.meas tran vdout0_14ck710 FIND v(dout0_14) AT=360.025n

.meas tran vdout0_15ck710 FIND v(dout0_15) AT=360.025n

.meas tran vdout0_16ck710 FIND v(dout0_16) AT=360.025n

.meas tran vdout0_17ck710 FIND v(dout0_17) AT=360.025n

.meas tran vdout0_18ck710 FIND v(dout0_18) AT=360.025n

.meas tran vdout0_19ck710 FIND v(dout0_19) AT=360.025n

.meas tran vdout0_20ck710 FIND v(dout0_20) AT=360.025n

.meas tran vdout0_21ck710 FIND v(dout0_21) AT=360.025n

.meas tran vdout0_22ck710 FIND v(dout0_22) AT=360.025n

.meas tran vdout0_23ck710 FIND v(dout0_23) AT=360.025n

.meas tran vdout0_24ck710 FIND v(dout0_24) AT=360.025n

.meas tran vdout0_25ck710 FIND v(dout0_25) AT=360.025n

.meas tran vdout0_26ck710 FIND v(dout0_26) AT=360.025n

.meas tran vdout0_27ck710 FIND v(dout0_27) AT=360.025n

.meas tran vdout0_28ck710 FIND v(dout0_28) AT=360.025n

.meas tran vdout0_29ck710 FIND v(dout0_29) AT=360.025n

.meas tran vdout0_30ck710 FIND v(dout0_30) AT=360.025n

.meas tran vdout0_31ck710 FIND v(dout0_31) AT=360.025n

.meas tran vdout0_0ck720 FIND v(dout0_0) AT=365.025n

.meas tran vdout0_1ck720 FIND v(dout0_1) AT=365.025n

.meas tran vdout0_2ck720 FIND v(dout0_2) AT=365.025n

.meas tran vdout0_3ck720 FIND v(dout0_3) AT=365.025n

.meas tran vdout0_4ck720 FIND v(dout0_4) AT=365.025n

.meas tran vdout0_5ck720 FIND v(dout0_5) AT=365.025n

.meas tran vdout0_6ck720 FIND v(dout0_6) AT=365.025n

.meas tran vdout0_7ck720 FIND v(dout0_7) AT=365.025n

.meas tran vdout0_8ck720 FIND v(dout0_8) AT=365.025n

.meas tran vdout0_9ck720 FIND v(dout0_9) AT=365.025n

.meas tran vdout0_10ck720 FIND v(dout0_10) AT=365.025n

.meas tran vdout0_11ck720 FIND v(dout0_11) AT=365.025n

.meas tran vdout0_12ck720 FIND v(dout0_12) AT=365.025n

.meas tran vdout0_13ck720 FIND v(dout0_13) AT=365.025n

.meas tran vdout0_14ck720 FIND v(dout0_14) AT=365.025n

.meas tran vdout0_15ck720 FIND v(dout0_15) AT=365.025n

.meas tran vdout0_16ck720 FIND v(dout0_16) AT=365.025n

.meas tran vdout0_17ck720 FIND v(dout0_17) AT=365.025n

.meas tran vdout0_18ck720 FIND v(dout0_18) AT=365.025n

.meas tran vdout0_19ck720 FIND v(dout0_19) AT=365.025n

.meas tran vdout0_20ck720 FIND v(dout0_20) AT=365.025n

.meas tran vdout0_21ck720 FIND v(dout0_21) AT=365.025n

.meas tran vdout0_22ck720 FIND v(dout0_22) AT=365.025n

.meas tran vdout0_23ck720 FIND v(dout0_23) AT=365.025n

.meas tran vdout0_24ck720 FIND v(dout0_24) AT=365.025n

.meas tran vdout0_25ck720 FIND v(dout0_25) AT=365.025n

.meas tran vdout0_26ck720 FIND v(dout0_26) AT=365.025n

.meas tran vdout0_27ck720 FIND v(dout0_27) AT=365.025n

.meas tran vdout0_28ck720 FIND v(dout0_28) AT=365.025n

.meas tran vdout0_29ck720 FIND v(dout0_29) AT=365.025n

.meas tran vdout0_30ck720 FIND v(dout0_30) AT=365.025n

.meas tran vdout0_31ck720 FIND v(dout0_31) AT=365.025n

.meas tran vdout0_0ck730 FIND v(dout0_0) AT=370.025n

.meas tran vdout0_1ck730 FIND v(dout0_1) AT=370.025n

.meas tran vdout0_2ck730 FIND v(dout0_2) AT=370.025n

.meas tran vdout0_3ck730 FIND v(dout0_3) AT=370.025n

.meas tran vdout0_4ck730 FIND v(dout0_4) AT=370.025n

.meas tran vdout0_5ck730 FIND v(dout0_5) AT=370.025n

.meas tran vdout0_6ck730 FIND v(dout0_6) AT=370.025n

.meas tran vdout0_7ck730 FIND v(dout0_7) AT=370.025n

.meas tran vdout0_8ck730 FIND v(dout0_8) AT=370.025n

.meas tran vdout0_9ck730 FIND v(dout0_9) AT=370.025n

.meas tran vdout0_10ck730 FIND v(dout0_10) AT=370.025n

.meas tran vdout0_11ck730 FIND v(dout0_11) AT=370.025n

.meas tran vdout0_12ck730 FIND v(dout0_12) AT=370.025n

.meas tran vdout0_13ck730 FIND v(dout0_13) AT=370.025n

.meas tran vdout0_14ck730 FIND v(dout0_14) AT=370.025n

.meas tran vdout0_15ck730 FIND v(dout0_15) AT=370.025n

.meas tran vdout0_16ck730 FIND v(dout0_16) AT=370.025n

.meas tran vdout0_17ck730 FIND v(dout0_17) AT=370.025n

.meas tran vdout0_18ck730 FIND v(dout0_18) AT=370.025n

.meas tran vdout0_19ck730 FIND v(dout0_19) AT=370.025n

.meas tran vdout0_20ck730 FIND v(dout0_20) AT=370.025n

.meas tran vdout0_21ck730 FIND v(dout0_21) AT=370.025n

.meas tran vdout0_22ck730 FIND v(dout0_22) AT=370.025n

.meas tran vdout0_23ck730 FIND v(dout0_23) AT=370.025n

.meas tran vdout0_24ck730 FIND v(dout0_24) AT=370.025n

.meas tran vdout0_25ck730 FIND v(dout0_25) AT=370.025n

.meas tran vdout0_26ck730 FIND v(dout0_26) AT=370.025n

.meas tran vdout0_27ck730 FIND v(dout0_27) AT=370.025n

.meas tran vdout0_28ck730 FIND v(dout0_28) AT=370.025n

.meas tran vdout0_29ck730 FIND v(dout0_29) AT=370.025n

.meas tran vdout0_30ck730 FIND v(dout0_30) AT=370.025n

.meas tran vdout0_31ck730 FIND v(dout0_31) AT=370.025n

.meas tran vdout0_0ck740 FIND v(dout0_0) AT=375.025n

.meas tran vdout0_1ck740 FIND v(dout0_1) AT=375.025n

.meas tran vdout0_2ck740 FIND v(dout0_2) AT=375.025n

.meas tran vdout0_3ck740 FIND v(dout0_3) AT=375.025n

.meas tran vdout0_4ck740 FIND v(dout0_4) AT=375.025n

.meas tran vdout0_5ck740 FIND v(dout0_5) AT=375.025n

.meas tran vdout0_6ck740 FIND v(dout0_6) AT=375.025n

.meas tran vdout0_7ck740 FIND v(dout0_7) AT=375.025n

.meas tran vdout0_8ck740 FIND v(dout0_8) AT=375.025n

.meas tran vdout0_9ck740 FIND v(dout0_9) AT=375.025n

.meas tran vdout0_10ck740 FIND v(dout0_10) AT=375.025n

.meas tran vdout0_11ck740 FIND v(dout0_11) AT=375.025n

.meas tran vdout0_12ck740 FIND v(dout0_12) AT=375.025n

.meas tran vdout0_13ck740 FIND v(dout0_13) AT=375.025n

.meas tran vdout0_14ck740 FIND v(dout0_14) AT=375.025n

.meas tran vdout0_15ck740 FIND v(dout0_15) AT=375.025n

.meas tran vdout0_16ck740 FIND v(dout0_16) AT=375.025n

.meas tran vdout0_17ck740 FIND v(dout0_17) AT=375.025n

.meas tran vdout0_18ck740 FIND v(dout0_18) AT=375.025n

.meas tran vdout0_19ck740 FIND v(dout0_19) AT=375.025n

.meas tran vdout0_20ck740 FIND v(dout0_20) AT=375.025n

.meas tran vdout0_21ck740 FIND v(dout0_21) AT=375.025n

.meas tran vdout0_22ck740 FIND v(dout0_22) AT=375.025n

.meas tran vdout0_23ck740 FIND v(dout0_23) AT=375.025n

.meas tran vdout0_24ck740 FIND v(dout0_24) AT=375.025n

.meas tran vdout0_25ck740 FIND v(dout0_25) AT=375.025n

.meas tran vdout0_26ck740 FIND v(dout0_26) AT=375.025n

.meas tran vdout0_27ck740 FIND v(dout0_27) AT=375.025n

.meas tran vdout0_28ck740 FIND v(dout0_28) AT=375.025n

.meas tran vdout0_29ck740 FIND v(dout0_29) AT=375.025n

.meas tran vdout0_30ck740 FIND v(dout0_30) AT=375.025n

.meas tran vdout0_31ck740 FIND v(dout0_31) AT=375.025n

.meas tran vdout0_0ck750 FIND v(dout0_0) AT=380.025n

.meas tran vdout0_1ck750 FIND v(dout0_1) AT=380.025n

.meas tran vdout0_2ck750 FIND v(dout0_2) AT=380.025n

.meas tran vdout0_3ck750 FIND v(dout0_3) AT=380.025n

.meas tran vdout0_4ck750 FIND v(dout0_4) AT=380.025n

.meas tran vdout0_5ck750 FIND v(dout0_5) AT=380.025n

.meas tran vdout0_6ck750 FIND v(dout0_6) AT=380.025n

.meas tran vdout0_7ck750 FIND v(dout0_7) AT=380.025n

.meas tran vdout0_8ck750 FIND v(dout0_8) AT=380.025n

.meas tran vdout0_9ck750 FIND v(dout0_9) AT=380.025n

.meas tran vdout0_10ck750 FIND v(dout0_10) AT=380.025n

.meas tran vdout0_11ck750 FIND v(dout0_11) AT=380.025n

.meas tran vdout0_12ck750 FIND v(dout0_12) AT=380.025n

.meas tran vdout0_13ck750 FIND v(dout0_13) AT=380.025n

.meas tran vdout0_14ck750 FIND v(dout0_14) AT=380.025n

.meas tran vdout0_15ck750 FIND v(dout0_15) AT=380.025n

.meas tran vdout0_16ck750 FIND v(dout0_16) AT=380.025n

.meas tran vdout0_17ck750 FIND v(dout0_17) AT=380.025n

.meas tran vdout0_18ck750 FIND v(dout0_18) AT=380.025n

.meas tran vdout0_19ck750 FIND v(dout0_19) AT=380.025n

.meas tran vdout0_20ck750 FIND v(dout0_20) AT=380.025n

.meas tran vdout0_21ck750 FIND v(dout0_21) AT=380.025n

.meas tran vdout0_22ck750 FIND v(dout0_22) AT=380.025n

.meas tran vdout0_23ck750 FIND v(dout0_23) AT=380.025n

.meas tran vdout0_24ck750 FIND v(dout0_24) AT=380.025n

.meas tran vdout0_25ck750 FIND v(dout0_25) AT=380.025n

.meas tran vdout0_26ck750 FIND v(dout0_26) AT=380.025n

.meas tran vdout0_27ck750 FIND v(dout0_27) AT=380.025n

.meas tran vdout0_28ck750 FIND v(dout0_28) AT=380.025n

.meas tran vdout0_29ck750 FIND v(dout0_29) AT=380.025n

.meas tran vdout0_30ck750 FIND v(dout0_30) AT=380.025n

.meas tran vdout0_31ck750 FIND v(dout0_31) AT=380.025n

.meas tran vdout0_0ck770 FIND v(dout0_0) AT=390.025n

.meas tran vdout0_1ck770 FIND v(dout0_1) AT=390.025n

.meas tran vdout0_2ck770 FIND v(dout0_2) AT=390.025n

.meas tran vdout0_3ck770 FIND v(dout0_3) AT=390.025n

.meas tran vdout0_4ck770 FIND v(dout0_4) AT=390.025n

.meas tran vdout0_5ck770 FIND v(dout0_5) AT=390.025n

.meas tran vdout0_6ck770 FIND v(dout0_6) AT=390.025n

.meas tran vdout0_7ck770 FIND v(dout0_7) AT=390.025n

.meas tran vdout0_8ck770 FIND v(dout0_8) AT=390.025n

.meas tran vdout0_9ck770 FIND v(dout0_9) AT=390.025n

.meas tran vdout0_10ck770 FIND v(dout0_10) AT=390.025n

.meas tran vdout0_11ck770 FIND v(dout0_11) AT=390.025n

.meas tran vdout0_12ck770 FIND v(dout0_12) AT=390.025n

.meas tran vdout0_13ck770 FIND v(dout0_13) AT=390.025n

.meas tran vdout0_14ck770 FIND v(dout0_14) AT=390.025n

.meas tran vdout0_15ck770 FIND v(dout0_15) AT=390.025n

.meas tran vdout0_16ck770 FIND v(dout0_16) AT=390.025n

.meas tran vdout0_17ck770 FIND v(dout0_17) AT=390.025n

.meas tran vdout0_18ck770 FIND v(dout0_18) AT=390.025n

.meas tran vdout0_19ck770 FIND v(dout0_19) AT=390.025n

.meas tran vdout0_20ck770 FIND v(dout0_20) AT=390.025n

.meas tran vdout0_21ck770 FIND v(dout0_21) AT=390.025n

.meas tran vdout0_22ck770 FIND v(dout0_22) AT=390.025n

.meas tran vdout0_23ck770 FIND v(dout0_23) AT=390.025n

.meas tran vdout0_24ck770 FIND v(dout0_24) AT=390.025n

.meas tran vdout0_25ck770 FIND v(dout0_25) AT=390.025n

.meas tran vdout0_26ck770 FIND v(dout0_26) AT=390.025n

.meas tran vdout0_27ck770 FIND v(dout0_27) AT=390.025n

.meas tran vdout0_28ck770 FIND v(dout0_28) AT=390.025n

.meas tran vdout0_29ck770 FIND v(dout0_29) AT=390.025n

.meas tran vdout0_30ck770 FIND v(dout0_30) AT=390.025n

.meas tran vdout0_31ck770 FIND v(dout0_31) AT=390.025n

.meas tran vdout0_0ck790 FIND v(dout0_0) AT=400.025n

.meas tran vdout0_1ck790 FIND v(dout0_1) AT=400.025n

.meas tran vdout0_2ck790 FIND v(dout0_2) AT=400.025n

.meas tran vdout0_3ck790 FIND v(dout0_3) AT=400.025n

.meas tran vdout0_4ck790 FIND v(dout0_4) AT=400.025n

.meas tran vdout0_5ck790 FIND v(dout0_5) AT=400.025n

.meas tran vdout0_6ck790 FIND v(dout0_6) AT=400.025n

.meas tran vdout0_7ck790 FIND v(dout0_7) AT=400.025n

.meas tran vdout0_8ck790 FIND v(dout0_8) AT=400.025n

.meas tran vdout0_9ck790 FIND v(dout0_9) AT=400.025n

.meas tran vdout0_10ck790 FIND v(dout0_10) AT=400.025n

.meas tran vdout0_11ck790 FIND v(dout0_11) AT=400.025n

.meas tran vdout0_12ck790 FIND v(dout0_12) AT=400.025n

.meas tran vdout0_13ck790 FIND v(dout0_13) AT=400.025n

.meas tran vdout0_14ck790 FIND v(dout0_14) AT=400.025n

.meas tran vdout0_15ck790 FIND v(dout0_15) AT=400.025n

.meas tran vdout0_16ck790 FIND v(dout0_16) AT=400.025n

.meas tran vdout0_17ck790 FIND v(dout0_17) AT=400.025n

.meas tran vdout0_18ck790 FIND v(dout0_18) AT=400.025n

.meas tran vdout0_19ck790 FIND v(dout0_19) AT=400.025n

.meas tran vdout0_20ck790 FIND v(dout0_20) AT=400.025n

.meas tran vdout0_21ck790 FIND v(dout0_21) AT=400.025n

.meas tran vdout0_22ck790 FIND v(dout0_22) AT=400.025n

.meas tran vdout0_23ck790 FIND v(dout0_23) AT=400.025n

.meas tran vdout0_24ck790 FIND v(dout0_24) AT=400.025n

.meas tran vdout0_25ck790 FIND v(dout0_25) AT=400.025n

.meas tran vdout0_26ck790 FIND v(dout0_26) AT=400.025n

.meas tran vdout0_27ck790 FIND v(dout0_27) AT=400.025n

.meas tran vdout0_28ck790 FIND v(dout0_28) AT=400.025n

.meas tran vdout0_29ck790 FIND v(dout0_29) AT=400.025n

.meas tran vdout0_30ck790 FIND v(dout0_30) AT=400.025n

.meas tran vdout0_31ck790 FIND v(dout0_31) AT=400.025n

.meas tran vdout0_0ck800 FIND v(dout0_0) AT=405.025n

.meas tran vdout0_1ck800 FIND v(dout0_1) AT=405.025n

.meas tran vdout0_2ck800 FIND v(dout0_2) AT=405.025n

.meas tran vdout0_3ck800 FIND v(dout0_3) AT=405.025n

.meas tran vdout0_4ck800 FIND v(dout0_4) AT=405.025n

.meas tran vdout0_5ck800 FIND v(dout0_5) AT=405.025n

.meas tran vdout0_6ck800 FIND v(dout0_6) AT=405.025n

.meas tran vdout0_7ck800 FIND v(dout0_7) AT=405.025n

.meas tran vdout0_8ck800 FIND v(dout0_8) AT=405.025n

.meas tran vdout0_9ck800 FIND v(dout0_9) AT=405.025n

.meas tran vdout0_10ck800 FIND v(dout0_10) AT=405.025n

.meas tran vdout0_11ck800 FIND v(dout0_11) AT=405.025n

.meas tran vdout0_12ck800 FIND v(dout0_12) AT=405.025n

.meas tran vdout0_13ck800 FIND v(dout0_13) AT=405.025n

.meas tran vdout0_14ck800 FIND v(dout0_14) AT=405.025n

.meas tran vdout0_15ck800 FIND v(dout0_15) AT=405.025n

.meas tran vdout0_16ck800 FIND v(dout0_16) AT=405.025n

.meas tran vdout0_17ck800 FIND v(dout0_17) AT=405.025n

.meas tran vdout0_18ck800 FIND v(dout0_18) AT=405.025n

.meas tran vdout0_19ck800 FIND v(dout0_19) AT=405.025n

.meas tran vdout0_20ck800 FIND v(dout0_20) AT=405.025n

.meas tran vdout0_21ck800 FIND v(dout0_21) AT=405.025n

.meas tran vdout0_22ck800 FIND v(dout0_22) AT=405.025n

.meas tran vdout0_23ck800 FIND v(dout0_23) AT=405.025n

.meas tran vdout0_24ck800 FIND v(dout0_24) AT=405.025n

.meas tran vdout0_25ck800 FIND v(dout0_25) AT=405.025n

.meas tran vdout0_26ck800 FIND v(dout0_26) AT=405.025n

.meas tran vdout0_27ck800 FIND v(dout0_27) AT=405.025n

.meas tran vdout0_28ck800 FIND v(dout0_28) AT=405.025n

.meas tran vdout0_29ck800 FIND v(dout0_29) AT=405.025n

.meas tran vdout0_30ck800 FIND v(dout0_30) AT=405.025n

.meas tran vdout0_31ck800 FIND v(dout0_31) AT=405.025n

.meas tran vdout0_0ck830 FIND v(dout0_0) AT=420.025n

.meas tran vdout0_1ck830 FIND v(dout0_1) AT=420.025n

.meas tran vdout0_2ck830 FIND v(dout0_2) AT=420.025n

.meas tran vdout0_3ck830 FIND v(dout0_3) AT=420.025n

.meas tran vdout0_4ck830 FIND v(dout0_4) AT=420.025n

.meas tran vdout0_5ck830 FIND v(dout0_5) AT=420.025n

.meas tran vdout0_6ck830 FIND v(dout0_6) AT=420.025n

.meas tran vdout0_7ck830 FIND v(dout0_7) AT=420.025n

.meas tran vdout0_8ck830 FIND v(dout0_8) AT=420.025n

.meas tran vdout0_9ck830 FIND v(dout0_9) AT=420.025n

.meas tran vdout0_10ck830 FIND v(dout0_10) AT=420.025n

.meas tran vdout0_11ck830 FIND v(dout0_11) AT=420.025n

.meas tran vdout0_12ck830 FIND v(dout0_12) AT=420.025n

.meas tran vdout0_13ck830 FIND v(dout0_13) AT=420.025n

.meas tran vdout0_14ck830 FIND v(dout0_14) AT=420.025n

.meas tran vdout0_15ck830 FIND v(dout0_15) AT=420.025n

.meas tran vdout0_16ck830 FIND v(dout0_16) AT=420.025n

.meas tran vdout0_17ck830 FIND v(dout0_17) AT=420.025n

.meas tran vdout0_18ck830 FIND v(dout0_18) AT=420.025n

.meas tran vdout0_19ck830 FIND v(dout0_19) AT=420.025n

.meas tran vdout0_20ck830 FIND v(dout0_20) AT=420.025n

.meas tran vdout0_21ck830 FIND v(dout0_21) AT=420.025n

.meas tran vdout0_22ck830 FIND v(dout0_22) AT=420.025n

.meas tran vdout0_23ck830 FIND v(dout0_23) AT=420.025n

.meas tran vdout0_24ck830 FIND v(dout0_24) AT=420.025n

.meas tran vdout0_25ck830 FIND v(dout0_25) AT=420.025n

.meas tran vdout0_26ck830 FIND v(dout0_26) AT=420.025n

.meas tran vdout0_27ck830 FIND v(dout0_27) AT=420.025n

.meas tran vdout0_28ck830 FIND v(dout0_28) AT=420.025n

.meas tran vdout0_29ck830 FIND v(dout0_29) AT=420.025n

.meas tran vdout0_30ck830 FIND v(dout0_30) AT=420.025n

.meas tran vdout0_31ck830 FIND v(dout0_31) AT=420.025n

.meas tran vdout0_0ck840 FIND v(dout0_0) AT=425.025n

.meas tran vdout0_1ck840 FIND v(dout0_1) AT=425.025n

.meas tran vdout0_2ck840 FIND v(dout0_2) AT=425.025n

.meas tran vdout0_3ck840 FIND v(dout0_3) AT=425.025n

.meas tran vdout0_4ck840 FIND v(dout0_4) AT=425.025n

.meas tran vdout0_5ck840 FIND v(dout0_5) AT=425.025n

.meas tran vdout0_6ck840 FIND v(dout0_6) AT=425.025n

.meas tran vdout0_7ck840 FIND v(dout0_7) AT=425.025n

.meas tran vdout0_8ck840 FIND v(dout0_8) AT=425.025n

.meas tran vdout0_9ck840 FIND v(dout0_9) AT=425.025n

.meas tran vdout0_10ck840 FIND v(dout0_10) AT=425.025n

.meas tran vdout0_11ck840 FIND v(dout0_11) AT=425.025n

.meas tran vdout0_12ck840 FIND v(dout0_12) AT=425.025n

.meas tran vdout0_13ck840 FIND v(dout0_13) AT=425.025n

.meas tran vdout0_14ck840 FIND v(dout0_14) AT=425.025n

.meas tran vdout0_15ck840 FIND v(dout0_15) AT=425.025n

.meas tran vdout0_16ck840 FIND v(dout0_16) AT=425.025n

.meas tran vdout0_17ck840 FIND v(dout0_17) AT=425.025n

.meas tran vdout0_18ck840 FIND v(dout0_18) AT=425.025n

.meas tran vdout0_19ck840 FIND v(dout0_19) AT=425.025n

.meas tran vdout0_20ck840 FIND v(dout0_20) AT=425.025n

.meas tran vdout0_21ck840 FIND v(dout0_21) AT=425.025n

.meas tran vdout0_22ck840 FIND v(dout0_22) AT=425.025n

.meas tran vdout0_23ck840 FIND v(dout0_23) AT=425.025n

.meas tran vdout0_24ck840 FIND v(dout0_24) AT=425.025n

.meas tran vdout0_25ck840 FIND v(dout0_25) AT=425.025n

.meas tran vdout0_26ck840 FIND v(dout0_26) AT=425.025n

.meas tran vdout0_27ck840 FIND v(dout0_27) AT=425.025n

.meas tran vdout0_28ck840 FIND v(dout0_28) AT=425.025n

.meas tran vdout0_29ck840 FIND v(dout0_29) AT=425.025n

.meas tran vdout0_30ck840 FIND v(dout0_30) AT=425.025n

.meas tran vdout0_31ck840 FIND v(dout0_31) AT=425.025n

.meas tran vdout0_0ck870 FIND v(dout0_0) AT=440.025n

.meas tran vdout0_1ck870 FIND v(dout0_1) AT=440.025n

.meas tran vdout0_2ck870 FIND v(dout0_2) AT=440.025n

.meas tran vdout0_3ck870 FIND v(dout0_3) AT=440.025n

.meas tran vdout0_4ck870 FIND v(dout0_4) AT=440.025n

.meas tran vdout0_5ck870 FIND v(dout0_5) AT=440.025n

.meas tran vdout0_6ck870 FIND v(dout0_6) AT=440.025n

.meas tran vdout0_7ck870 FIND v(dout0_7) AT=440.025n

.meas tran vdout0_8ck870 FIND v(dout0_8) AT=440.025n

.meas tran vdout0_9ck870 FIND v(dout0_9) AT=440.025n

.meas tran vdout0_10ck870 FIND v(dout0_10) AT=440.025n

.meas tran vdout0_11ck870 FIND v(dout0_11) AT=440.025n

.meas tran vdout0_12ck870 FIND v(dout0_12) AT=440.025n

.meas tran vdout0_13ck870 FIND v(dout0_13) AT=440.025n

.meas tran vdout0_14ck870 FIND v(dout0_14) AT=440.025n

.meas tran vdout0_15ck870 FIND v(dout0_15) AT=440.025n

.meas tran vdout0_16ck870 FIND v(dout0_16) AT=440.025n

.meas tran vdout0_17ck870 FIND v(dout0_17) AT=440.025n

.meas tran vdout0_18ck870 FIND v(dout0_18) AT=440.025n

.meas tran vdout0_19ck870 FIND v(dout0_19) AT=440.025n

.meas tran vdout0_20ck870 FIND v(dout0_20) AT=440.025n

.meas tran vdout0_21ck870 FIND v(dout0_21) AT=440.025n

.meas tran vdout0_22ck870 FIND v(dout0_22) AT=440.025n

.meas tran vdout0_23ck870 FIND v(dout0_23) AT=440.025n

.meas tran vdout0_24ck870 FIND v(dout0_24) AT=440.025n

.meas tran vdout0_25ck870 FIND v(dout0_25) AT=440.025n

.meas tran vdout0_26ck870 FIND v(dout0_26) AT=440.025n

.meas tran vdout0_27ck870 FIND v(dout0_27) AT=440.025n

.meas tran vdout0_28ck870 FIND v(dout0_28) AT=440.025n

.meas tran vdout0_29ck870 FIND v(dout0_29) AT=440.025n

.meas tran vdout0_30ck870 FIND v(dout0_30) AT=440.025n

.meas tran vdout0_31ck870 FIND v(dout0_31) AT=440.025n

.meas tran vdout0_0ck900 FIND v(dout0_0) AT=455.025n

.meas tran vdout0_1ck900 FIND v(dout0_1) AT=455.025n

.meas tran vdout0_2ck900 FIND v(dout0_2) AT=455.025n

.meas tran vdout0_3ck900 FIND v(dout0_3) AT=455.025n

.meas tran vdout0_4ck900 FIND v(dout0_4) AT=455.025n

.meas tran vdout0_5ck900 FIND v(dout0_5) AT=455.025n

.meas tran vdout0_6ck900 FIND v(dout0_6) AT=455.025n

.meas tran vdout0_7ck900 FIND v(dout0_7) AT=455.025n

.meas tran vdout0_8ck900 FIND v(dout0_8) AT=455.025n

.meas tran vdout0_9ck900 FIND v(dout0_9) AT=455.025n

.meas tran vdout0_10ck900 FIND v(dout0_10) AT=455.025n

.meas tran vdout0_11ck900 FIND v(dout0_11) AT=455.025n

.meas tran vdout0_12ck900 FIND v(dout0_12) AT=455.025n

.meas tran vdout0_13ck900 FIND v(dout0_13) AT=455.025n

.meas tran vdout0_14ck900 FIND v(dout0_14) AT=455.025n

.meas tran vdout0_15ck900 FIND v(dout0_15) AT=455.025n

.meas tran vdout0_16ck900 FIND v(dout0_16) AT=455.025n

.meas tran vdout0_17ck900 FIND v(dout0_17) AT=455.025n

.meas tran vdout0_18ck900 FIND v(dout0_18) AT=455.025n

.meas tran vdout0_19ck900 FIND v(dout0_19) AT=455.025n

.meas tran vdout0_20ck900 FIND v(dout0_20) AT=455.025n

.meas tran vdout0_21ck900 FIND v(dout0_21) AT=455.025n

.meas tran vdout0_22ck900 FIND v(dout0_22) AT=455.025n

.meas tran vdout0_23ck900 FIND v(dout0_23) AT=455.025n

.meas tran vdout0_24ck900 FIND v(dout0_24) AT=455.025n

.meas tran vdout0_25ck900 FIND v(dout0_25) AT=455.025n

.meas tran vdout0_26ck900 FIND v(dout0_26) AT=455.025n

.meas tran vdout0_27ck900 FIND v(dout0_27) AT=455.025n

.meas tran vdout0_28ck900 FIND v(dout0_28) AT=455.025n

.meas tran vdout0_29ck900 FIND v(dout0_29) AT=455.025n

.meas tran vdout0_30ck900 FIND v(dout0_30) AT=455.025n

.meas tran vdout0_31ck900 FIND v(dout0_31) AT=455.025n

.meas tran vdout0_0ck920 FIND v(dout0_0) AT=465.025n

.meas tran vdout0_1ck920 FIND v(dout0_1) AT=465.025n

.meas tran vdout0_2ck920 FIND v(dout0_2) AT=465.025n

.meas tran vdout0_3ck920 FIND v(dout0_3) AT=465.025n

.meas tran vdout0_4ck920 FIND v(dout0_4) AT=465.025n

.meas tran vdout0_5ck920 FIND v(dout0_5) AT=465.025n

.meas tran vdout0_6ck920 FIND v(dout0_6) AT=465.025n

.meas tran vdout0_7ck920 FIND v(dout0_7) AT=465.025n

.meas tran vdout0_8ck920 FIND v(dout0_8) AT=465.025n

.meas tran vdout0_9ck920 FIND v(dout0_9) AT=465.025n

.meas tran vdout0_10ck920 FIND v(dout0_10) AT=465.025n

.meas tran vdout0_11ck920 FIND v(dout0_11) AT=465.025n

.meas tran vdout0_12ck920 FIND v(dout0_12) AT=465.025n

.meas tran vdout0_13ck920 FIND v(dout0_13) AT=465.025n

.meas tran vdout0_14ck920 FIND v(dout0_14) AT=465.025n

.meas tran vdout0_15ck920 FIND v(dout0_15) AT=465.025n

.meas tran vdout0_16ck920 FIND v(dout0_16) AT=465.025n

.meas tran vdout0_17ck920 FIND v(dout0_17) AT=465.025n

.meas tran vdout0_18ck920 FIND v(dout0_18) AT=465.025n

.meas tran vdout0_19ck920 FIND v(dout0_19) AT=465.025n

.meas tran vdout0_20ck920 FIND v(dout0_20) AT=465.025n

.meas tran vdout0_21ck920 FIND v(dout0_21) AT=465.025n

.meas tran vdout0_22ck920 FIND v(dout0_22) AT=465.025n

.meas tran vdout0_23ck920 FIND v(dout0_23) AT=465.025n

.meas tran vdout0_24ck920 FIND v(dout0_24) AT=465.025n

.meas tran vdout0_25ck920 FIND v(dout0_25) AT=465.025n

.meas tran vdout0_26ck920 FIND v(dout0_26) AT=465.025n

.meas tran vdout0_27ck920 FIND v(dout0_27) AT=465.025n

.meas tran vdout0_28ck920 FIND v(dout0_28) AT=465.025n

.meas tran vdout0_29ck920 FIND v(dout0_29) AT=465.025n

.meas tran vdout0_30ck920 FIND v(dout0_30) AT=465.025n

.meas tran vdout0_31ck920 FIND v(dout0_31) AT=465.025n

.meas tran vdout0_0ck930 FIND v(dout0_0) AT=470.025n

.meas tran vdout0_1ck930 FIND v(dout0_1) AT=470.025n

.meas tran vdout0_2ck930 FIND v(dout0_2) AT=470.025n

.meas tran vdout0_3ck930 FIND v(dout0_3) AT=470.025n

.meas tran vdout0_4ck930 FIND v(dout0_4) AT=470.025n

.meas tran vdout0_5ck930 FIND v(dout0_5) AT=470.025n

.meas tran vdout0_6ck930 FIND v(dout0_6) AT=470.025n

.meas tran vdout0_7ck930 FIND v(dout0_7) AT=470.025n

.meas tran vdout0_8ck930 FIND v(dout0_8) AT=470.025n

.meas tran vdout0_9ck930 FIND v(dout0_9) AT=470.025n

.meas tran vdout0_10ck930 FIND v(dout0_10) AT=470.025n

.meas tran vdout0_11ck930 FIND v(dout0_11) AT=470.025n

.meas tran vdout0_12ck930 FIND v(dout0_12) AT=470.025n

.meas tran vdout0_13ck930 FIND v(dout0_13) AT=470.025n

.meas tran vdout0_14ck930 FIND v(dout0_14) AT=470.025n

.meas tran vdout0_15ck930 FIND v(dout0_15) AT=470.025n

.meas tran vdout0_16ck930 FIND v(dout0_16) AT=470.025n

.meas tran vdout0_17ck930 FIND v(dout0_17) AT=470.025n

.meas tran vdout0_18ck930 FIND v(dout0_18) AT=470.025n

.meas tran vdout0_19ck930 FIND v(dout0_19) AT=470.025n

.meas tran vdout0_20ck930 FIND v(dout0_20) AT=470.025n

.meas tran vdout0_21ck930 FIND v(dout0_21) AT=470.025n

.meas tran vdout0_22ck930 FIND v(dout0_22) AT=470.025n

.meas tran vdout0_23ck930 FIND v(dout0_23) AT=470.025n

.meas tran vdout0_24ck930 FIND v(dout0_24) AT=470.025n

.meas tran vdout0_25ck930 FIND v(dout0_25) AT=470.025n

.meas tran vdout0_26ck930 FIND v(dout0_26) AT=470.025n

.meas tran vdout0_27ck930 FIND v(dout0_27) AT=470.025n

.meas tran vdout0_28ck930 FIND v(dout0_28) AT=470.025n

.meas tran vdout0_29ck930 FIND v(dout0_29) AT=470.025n

.meas tran vdout0_30ck930 FIND v(dout0_30) AT=470.025n

.meas tran vdout0_31ck930 FIND v(dout0_31) AT=470.025n

.meas tran vdout0_0ck940 FIND v(dout0_0) AT=475.025n

.meas tran vdout0_1ck940 FIND v(dout0_1) AT=475.025n

.meas tran vdout0_2ck940 FIND v(dout0_2) AT=475.025n

.meas tran vdout0_3ck940 FIND v(dout0_3) AT=475.025n

.meas tran vdout0_4ck940 FIND v(dout0_4) AT=475.025n

.meas tran vdout0_5ck940 FIND v(dout0_5) AT=475.025n

.meas tran vdout0_6ck940 FIND v(dout0_6) AT=475.025n

.meas tran vdout0_7ck940 FIND v(dout0_7) AT=475.025n

.meas tran vdout0_8ck940 FIND v(dout0_8) AT=475.025n

.meas tran vdout0_9ck940 FIND v(dout0_9) AT=475.025n

.meas tran vdout0_10ck940 FIND v(dout0_10) AT=475.025n

.meas tran vdout0_11ck940 FIND v(dout0_11) AT=475.025n

.meas tran vdout0_12ck940 FIND v(dout0_12) AT=475.025n

.meas tran vdout0_13ck940 FIND v(dout0_13) AT=475.025n

.meas tran vdout0_14ck940 FIND v(dout0_14) AT=475.025n

.meas tran vdout0_15ck940 FIND v(dout0_15) AT=475.025n

.meas tran vdout0_16ck940 FIND v(dout0_16) AT=475.025n

.meas tran vdout0_17ck940 FIND v(dout0_17) AT=475.025n

.meas tran vdout0_18ck940 FIND v(dout0_18) AT=475.025n

.meas tran vdout0_19ck940 FIND v(dout0_19) AT=475.025n

.meas tran vdout0_20ck940 FIND v(dout0_20) AT=475.025n

.meas tran vdout0_21ck940 FIND v(dout0_21) AT=475.025n

.meas tran vdout0_22ck940 FIND v(dout0_22) AT=475.025n

.meas tran vdout0_23ck940 FIND v(dout0_23) AT=475.025n

.meas tran vdout0_24ck940 FIND v(dout0_24) AT=475.025n

.meas tran vdout0_25ck940 FIND v(dout0_25) AT=475.025n

.meas tran vdout0_26ck940 FIND v(dout0_26) AT=475.025n

.meas tran vdout0_27ck940 FIND v(dout0_27) AT=475.025n

.meas tran vdout0_28ck940 FIND v(dout0_28) AT=475.025n

.meas tran vdout0_29ck940 FIND v(dout0_29) AT=475.025n

.meas tran vdout0_30ck940 FIND v(dout0_30) AT=475.025n

.meas tran vdout0_31ck940 FIND v(dout0_31) AT=475.025n

.meas tran vdout0_0ck950 FIND v(dout0_0) AT=480.025n

.meas tran vdout0_1ck950 FIND v(dout0_1) AT=480.025n

.meas tran vdout0_2ck950 FIND v(dout0_2) AT=480.025n

.meas tran vdout0_3ck950 FIND v(dout0_3) AT=480.025n

.meas tran vdout0_4ck950 FIND v(dout0_4) AT=480.025n

.meas tran vdout0_5ck950 FIND v(dout0_5) AT=480.025n

.meas tran vdout0_6ck950 FIND v(dout0_6) AT=480.025n

.meas tran vdout0_7ck950 FIND v(dout0_7) AT=480.025n

.meas tran vdout0_8ck950 FIND v(dout0_8) AT=480.025n

.meas tran vdout0_9ck950 FIND v(dout0_9) AT=480.025n

.meas tran vdout0_10ck950 FIND v(dout0_10) AT=480.025n

.meas tran vdout0_11ck950 FIND v(dout0_11) AT=480.025n

.meas tran vdout0_12ck950 FIND v(dout0_12) AT=480.025n

.meas tran vdout0_13ck950 FIND v(dout0_13) AT=480.025n

.meas tran vdout0_14ck950 FIND v(dout0_14) AT=480.025n

.meas tran vdout0_15ck950 FIND v(dout0_15) AT=480.025n

.meas tran vdout0_16ck950 FIND v(dout0_16) AT=480.025n

.meas tran vdout0_17ck950 FIND v(dout0_17) AT=480.025n

.meas tran vdout0_18ck950 FIND v(dout0_18) AT=480.025n

.meas tran vdout0_19ck950 FIND v(dout0_19) AT=480.025n

.meas tran vdout0_20ck950 FIND v(dout0_20) AT=480.025n

.meas tran vdout0_21ck950 FIND v(dout0_21) AT=480.025n

.meas tran vdout0_22ck950 FIND v(dout0_22) AT=480.025n

.meas tran vdout0_23ck950 FIND v(dout0_23) AT=480.025n

.meas tran vdout0_24ck950 FIND v(dout0_24) AT=480.025n

.meas tran vdout0_25ck950 FIND v(dout0_25) AT=480.025n

.meas tran vdout0_26ck950 FIND v(dout0_26) AT=480.025n

.meas tran vdout0_27ck950 FIND v(dout0_27) AT=480.025n

.meas tran vdout0_28ck950 FIND v(dout0_28) AT=480.025n

.meas tran vdout0_29ck950 FIND v(dout0_29) AT=480.025n

.meas tran vdout0_30ck950 FIND v(dout0_30) AT=480.025n

.meas tran vdout0_31ck950 FIND v(dout0_31) AT=480.025n

.meas tran vdout0_0ck960 FIND v(dout0_0) AT=485.025n

.meas tran vdout0_1ck960 FIND v(dout0_1) AT=485.025n

.meas tran vdout0_2ck960 FIND v(dout0_2) AT=485.025n

.meas tran vdout0_3ck960 FIND v(dout0_3) AT=485.025n

.meas tran vdout0_4ck960 FIND v(dout0_4) AT=485.025n

.meas tran vdout0_5ck960 FIND v(dout0_5) AT=485.025n

.meas tran vdout0_6ck960 FIND v(dout0_6) AT=485.025n

.meas tran vdout0_7ck960 FIND v(dout0_7) AT=485.025n

.meas tran vdout0_8ck960 FIND v(dout0_8) AT=485.025n

.meas tran vdout0_9ck960 FIND v(dout0_9) AT=485.025n

.meas tran vdout0_10ck960 FIND v(dout0_10) AT=485.025n

.meas tran vdout0_11ck960 FIND v(dout0_11) AT=485.025n

.meas tran vdout0_12ck960 FIND v(dout0_12) AT=485.025n

.meas tran vdout0_13ck960 FIND v(dout0_13) AT=485.025n

.meas tran vdout0_14ck960 FIND v(dout0_14) AT=485.025n

.meas tran vdout0_15ck960 FIND v(dout0_15) AT=485.025n

.meas tran vdout0_16ck960 FIND v(dout0_16) AT=485.025n

.meas tran vdout0_17ck960 FIND v(dout0_17) AT=485.025n

.meas tran vdout0_18ck960 FIND v(dout0_18) AT=485.025n

.meas tran vdout0_19ck960 FIND v(dout0_19) AT=485.025n

.meas tran vdout0_20ck960 FIND v(dout0_20) AT=485.025n

.meas tran vdout0_21ck960 FIND v(dout0_21) AT=485.025n

.meas tran vdout0_22ck960 FIND v(dout0_22) AT=485.025n

.meas tran vdout0_23ck960 FIND v(dout0_23) AT=485.025n

.meas tran vdout0_24ck960 FIND v(dout0_24) AT=485.025n

.meas tran vdout0_25ck960 FIND v(dout0_25) AT=485.025n

.meas tran vdout0_26ck960 FIND v(dout0_26) AT=485.025n

.meas tran vdout0_27ck960 FIND v(dout0_27) AT=485.025n

.meas tran vdout0_28ck960 FIND v(dout0_28) AT=485.025n

.meas tran vdout0_29ck960 FIND v(dout0_29) AT=485.025n

.meas tran vdout0_30ck960 FIND v(dout0_30) AT=485.025n

.meas tran vdout0_31ck960 FIND v(dout0_31) AT=485.025n

.meas tran vdout0_0ck970 FIND v(dout0_0) AT=490.025n

.meas tran vdout0_1ck970 FIND v(dout0_1) AT=490.025n

.meas tran vdout0_2ck970 FIND v(dout0_2) AT=490.025n

.meas tran vdout0_3ck970 FIND v(dout0_3) AT=490.025n

.meas tran vdout0_4ck970 FIND v(dout0_4) AT=490.025n

.meas tran vdout0_5ck970 FIND v(dout0_5) AT=490.025n

.meas tran vdout0_6ck970 FIND v(dout0_6) AT=490.025n

.meas tran vdout0_7ck970 FIND v(dout0_7) AT=490.025n

.meas tran vdout0_8ck970 FIND v(dout0_8) AT=490.025n

.meas tran vdout0_9ck970 FIND v(dout0_9) AT=490.025n

.meas tran vdout0_10ck970 FIND v(dout0_10) AT=490.025n

.meas tran vdout0_11ck970 FIND v(dout0_11) AT=490.025n

.meas tran vdout0_12ck970 FIND v(dout0_12) AT=490.025n

.meas tran vdout0_13ck970 FIND v(dout0_13) AT=490.025n

.meas tran vdout0_14ck970 FIND v(dout0_14) AT=490.025n

.meas tran vdout0_15ck970 FIND v(dout0_15) AT=490.025n

.meas tran vdout0_16ck970 FIND v(dout0_16) AT=490.025n

.meas tran vdout0_17ck970 FIND v(dout0_17) AT=490.025n

.meas tran vdout0_18ck970 FIND v(dout0_18) AT=490.025n

.meas tran vdout0_19ck970 FIND v(dout0_19) AT=490.025n

.meas tran vdout0_20ck970 FIND v(dout0_20) AT=490.025n

.meas tran vdout0_21ck970 FIND v(dout0_21) AT=490.025n

.meas tran vdout0_22ck970 FIND v(dout0_22) AT=490.025n

.meas tran vdout0_23ck970 FIND v(dout0_23) AT=490.025n

.meas tran vdout0_24ck970 FIND v(dout0_24) AT=490.025n

.meas tran vdout0_25ck970 FIND v(dout0_25) AT=490.025n

.meas tran vdout0_26ck970 FIND v(dout0_26) AT=490.025n

.meas tran vdout0_27ck970 FIND v(dout0_27) AT=490.025n

.meas tran vdout0_28ck970 FIND v(dout0_28) AT=490.025n

.meas tran vdout0_29ck970 FIND v(dout0_29) AT=490.025n

.meas tran vdout0_30ck970 FIND v(dout0_30) AT=490.025n

.meas tran vdout0_31ck970 FIND v(dout0_31) AT=490.025n

.meas tran vdout0_0ck980 FIND v(dout0_0) AT=495.025n

.meas tran vdout0_1ck980 FIND v(dout0_1) AT=495.025n

.meas tran vdout0_2ck980 FIND v(dout0_2) AT=495.025n

.meas tran vdout0_3ck980 FIND v(dout0_3) AT=495.025n

.meas tran vdout0_4ck980 FIND v(dout0_4) AT=495.025n

.meas tran vdout0_5ck980 FIND v(dout0_5) AT=495.025n

.meas tran vdout0_6ck980 FIND v(dout0_6) AT=495.025n

.meas tran vdout0_7ck980 FIND v(dout0_7) AT=495.025n

.meas tran vdout0_8ck980 FIND v(dout0_8) AT=495.025n

.meas tran vdout0_9ck980 FIND v(dout0_9) AT=495.025n

.meas tran vdout0_10ck980 FIND v(dout0_10) AT=495.025n

.meas tran vdout0_11ck980 FIND v(dout0_11) AT=495.025n

.meas tran vdout0_12ck980 FIND v(dout0_12) AT=495.025n

.meas tran vdout0_13ck980 FIND v(dout0_13) AT=495.025n

.meas tran vdout0_14ck980 FIND v(dout0_14) AT=495.025n

.meas tran vdout0_15ck980 FIND v(dout0_15) AT=495.025n

.meas tran vdout0_16ck980 FIND v(dout0_16) AT=495.025n

.meas tran vdout0_17ck980 FIND v(dout0_17) AT=495.025n

.meas tran vdout0_18ck980 FIND v(dout0_18) AT=495.025n

.meas tran vdout0_19ck980 FIND v(dout0_19) AT=495.025n

.meas tran vdout0_20ck980 FIND v(dout0_20) AT=495.025n

.meas tran vdout0_21ck980 FIND v(dout0_21) AT=495.025n

.meas tran vdout0_22ck980 FIND v(dout0_22) AT=495.025n

.meas tran vdout0_23ck980 FIND v(dout0_23) AT=495.025n

.meas tran vdout0_24ck980 FIND v(dout0_24) AT=495.025n

.meas tran vdout0_25ck980 FIND v(dout0_25) AT=495.025n

.meas tran vdout0_26ck980 FIND v(dout0_26) AT=495.025n

.meas tran vdout0_27ck980 FIND v(dout0_27) AT=495.025n

.meas tran vdout0_28ck980 FIND v(dout0_28) AT=495.025n

.meas tran vdout0_29ck980 FIND v(dout0_29) AT=495.025n

.meas tran vdout0_30ck980 FIND v(dout0_30) AT=495.025n

.meas tran vdout0_31ck980 FIND v(dout0_31) AT=495.025n

.meas tran vdout0_0ck990 FIND v(dout0_0) AT=500.025n

.meas tran vdout0_1ck990 FIND v(dout0_1) AT=500.025n

.meas tran vdout0_2ck990 FIND v(dout0_2) AT=500.025n

.meas tran vdout0_3ck990 FIND v(dout0_3) AT=500.025n

.meas tran vdout0_4ck990 FIND v(dout0_4) AT=500.025n

.meas tran vdout0_5ck990 FIND v(dout0_5) AT=500.025n

.meas tran vdout0_6ck990 FIND v(dout0_6) AT=500.025n

.meas tran vdout0_7ck990 FIND v(dout0_7) AT=500.025n

.meas tran vdout0_8ck990 FIND v(dout0_8) AT=500.025n

.meas tran vdout0_9ck990 FIND v(dout0_9) AT=500.025n

.meas tran vdout0_10ck990 FIND v(dout0_10) AT=500.025n

.meas tran vdout0_11ck990 FIND v(dout0_11) AT=500.025n

.meas tran vdout0_12ck990 FIND v(dout0_12) AT=500.025n

.meas tran vdout0_13ck990 FIND v(dout0_13) AT=500.025n

.meas tran vdout0_14ck990 FIND v(dout0_14) AT=500.025n

.meas tran vdout0_15ck990 FIND v(dout0_15) AT=500.025n

.meas tran vdout0_16ck990 FIND v(dout0_16) AT=500.025n

.meas tran vdout0_17ck990 FIND v(dout0_17) AT=500.025n

.meas tran vdout0_18ck990 FIND v(dout0_18) AT=500.025n

.meas tran vdout0_19ck990 FIND v(dout0_19) AT=500.025n

.meas tran vdout0_20ck990 FIND v(dout0_20) AT=500.025n

.meas tran vdout0_21ck990 FIND v(dout0_21) AT=500.025n

.meas tran vdout0_22ck990 FIND v(dout0_22) AT=500.025n

.meas tran vdout0_23ck990 FIND v(dout0_23) AT=500.025n

.meas tran vdout0_24ck990 FIND v(dout0_24) AT=500.025n

.meas tran vdout0_25ck990 FIND v(dout0_25) AT=500.025n

.meas tran vdout0_26ck990 FIND v(dout0_26) AT=500.025n

.meas tran vdout0_27ck990 FIND v(dout0_27) AT=500.025n

.meas tran vdout0_28ck990 FIND v(dout0_28) AT=500.025n

.meas tran vdout0_29ck990 FIND v(dout0_29) AT=500.025n

.meas tran vdout0_30ck990 FIND v(dout0_30) AT=500.025n

.meas tran vdout0_31ck990 FIND v(dout0_31) AT=500.025n

.meas tran vdout0_0ck1010 FIND v(dout0_0) AT=510.025n

.meas tran vdout0_1ck1010 FIND v(dout0_1) AT=510.025n

.meas tran vdout0_2ck1010 FIND v(dout0_2) AT=510.025n

.meas tran vdout0_3ck1010 FIND v(dout0_3) AT=510.025n

.meas tran vdout0_4ck1010 FIND v(dout0_4) AT=510.025n

.meas tran vdout0_5ck1010 FIND v(dout0_5) AT=510.025n

.meas tran vdout0_6ck1010 FIND v(dout0_6) AT=510.025n

.meas tran vdout0_7ck1010 FIND v(dout0_7) AT=510.025n

.meas tran vdout0_8ck1010 FIND v(dout0_8) AT=510.025n

.meas tran vdout0_9ck1010 FIND v(dout0_9) AT=510.025n

.meas tran vdout0_10ck1010 FIND v(dout0_10) AT=510.025n

.meas tran vdout0_11ck1010 FIND v(dout0_11) AT=510.025n

.meas tran vdout0_12ck1010 FIND v(dout0_12) AT=510.025n

.meas tran vdout0_13ck1010 FIND v(dout0_13) AT=510.025n

.meas tran vdout0_14ck1010 FIND v(dout0_14) AT=510.025n

.meas tran vdout0_15ck1010 FIND v(dout0_15) AT=510.025n

.meas tran vdout0_16ck1010 FIND v(dout0_16) AT=510.025n

.meas tran vdout0_17ck1010 FIND v(dout0_17) AT=510.025n

.meas tran vdout0_18ck1010 FIND v(dout0_18) AT=510.025n

.meas tran vdout0_19ck1010 FIND v(dout0_19) AT=510.025n

.meas tran vdout0_20ck1010 FIND v(dout0_20) AT=510.025n

.meas tran vdout0_21ck1010 FIND v(dout0_21) AT=510.025n

.meas tran vdout0_22ck1010 FIND v(dout0_22) AT=510.025n

.meas tran vdout0_23ck1010 FIND v(dout0_23) AT=510.025n

.meas tran vdout0_24ck1010 FIND v(dout0_24) AT=510.025n

.meas tran vdout0_25ck1010 FIND v(dout0_25) AT=510.025n

.meas tran vdout0_26ck1010 FIND v(dout0_26) AT=510.025n

.meas tran vdout0_27ck1010 FIND v(dout0_27) AT=510.025n

.meas tran vdout0_28ck1010 FIND v(dout0_28) AT=510.025n

.meas tran vdout0_29ck1010 FIND v(dout0_29) AT=510.025n

.meas tran vdout0_30ck1010 FIND v(dout0_30) AT=510.025n

.meas tran vdout0_31ck1010 FIND v(dout0_31) AT=510.025n

.meas tran vdout0_0ck1040 FIND v(dout0_0) AT=525.025n

.meas tran vdout0_1ck1040 FIND v(dout0_1) AT=525.025n

.meas tran vdout0_2ck1040 FIND v(dout0_2) AT=525.025n

.meas tran vdout0_3ck1040 FIND v(dout0_3) AT=525.025n

.meas tran vdout0_4ck1040 FIND v(dout0_4) AT=525.025n

.meas tran vdout0_5ck1040 FIND v(dout0_5) AT=525.025n

.meas tran vdout0_6ck1040 FIND v(dout0_6) AT=525.025n

.meas tran vdout0_7ck1040 FIND v(dout0_7) AT=525.025n

.meas tran vdout0_8ck1040 FIND v(dout0_8) AT=525.025n

.meas tran vdout0_9ck1040 FIND v(dout0_9) AT=525.025n

.meas tran vdout0_10ck1040 FIND v(dout0_10) AT=525.025n

.meas tran vdout0_11ck1040 FIND v(dout0_11) AT=525.025n

.meas tran vdout0_12ck1040 FIND v(dout0_12) AT=525.025n

.meas tran vdout0_13ck1040 FIND v(dout0_13) AT=525.025n

.meas tran vdout0_14ck1040 FIND v(dout0_14) AT=525.025n

.meas tran vdout0_15ck1040 FIND v(dout0_15) AT=525.025n

.meas tran vdout0_16ck1040 FIND v(dout0_16) AT=525.025n

.meas tran vdout0_17ck1040 FIND v(dout0_17) AT=525.025n

.meas tran vdout0_18ck1040 FIND v(dout0_18) AT=525.025n

.meas tran vdout0_19ck1040 FIND v(dout0_19) AT=525.025n

.meas tran vdout0_20ck1040 FIND v(dout0_20) AT=525.025n

.meas tran vdout0_21ck1040 FIND v(dout0_21) AT=525.025n

.meas tran vdout0_22ck1040 FIND v(dout0_22) AT=525.025n

.meas tran vdout0_23ck1040 FIND v(dout0_23) AT=525.025n

.meas tran vdout0_24ck1040 FIND v(dout0_24) AT=525.025n

.meas tran vdout0_25ck1040 FIND v(dout0_25) AT=525.025n

.meas tran vdout0_26ck1040 FIND v(dout0_26) AT=525.025n

.meas tran vdout0_27ck1040 FIND v(dout0_27) AT=525.025n

.meas tran vdout0_28ck1040 FIND v(dout0_28) AT=525.025n

.meas tran vdout0_29ck1040 FIND v(dout0_29) AT=525.025n

.meas tran vdout0_30ck1040 FIND v(dout0_30) AT=525.025n

.meas tran vdout0_31ck1040 FIND v(dout0_31) AT=525.025n

.meas tran vdout0_0ck1070 FIND v(dout0_0) AT=540.025n

.meas tran vdout0_1ck1070 FIND v(dout0_1) AT=540.025n

.meas tran vdout0_2ck1070 FIND v(dout0_2) AT=540.025n

.meas tran vdout0_3ck1070 FIND v(dout0_3) AT=540.025n

.meas tran vdout0_4ck1070 FIND v(dout0_4) AT=540.025n

.meas tran vdout0_5ck1070 FIND v(dout0_5) AT=540.025n

.meas tran vdout0_6ck1070 FIND v(dout0_6) AT=540.025n

.meas tran vdout0_7ck1070 FIND v(dout0_7) AT=540.025n

.meas tran vdout0_8ck1070 FIND v(dout0_8) AT=540.025n

.meas tran vdout0_9ck1070 FIND v(dout0_9) AT=540.025n

.meas tran vdout0_10ck1070 FIND v(dout0_10) AT=540.025n

.meas tran vdout0_11ck1070 FIND v(dout0_11) AT=540.025n

.meas tran vdout0_12ck1070 FIND v(dout0_12) AT=540.025n

.meas tran vdout0_13ck1070 FIND v(dout0_13) AT=540.025n

.meas tran vdout0_14ck1070 FIND v(dout0_14) AT=540.025n

.meas tran vdout0_15ck1070 FIND v(dout0_15) AT=540.025n

.meas tran vdout0_16ck1070 FIND v(dout0_16) AT=540.025n

.meas tran vdout0_17ck1070 FIND v(dout0_17) AT=540.025n

.meas tran vdout0_18ck1070 FIND v(dout0_18) AT=540.025n

.meas tran vdout0_19ck1070 FIND v(dout0_19) AT=540.025n

.meas tran vdout0_20ck1070 FIND v(dout0_20) AT=540.025n

.meas tran vdout0_21ck1070 FIND v(dout0_21) AT=540.025n

.meas tran vdout0_22ck1070 FIND v(dout0_22) AT=540.025n

.meas tran vdout0_23ck1070 FIND v(dout0_23) AT=540.025n

.meas tran vdout0_24ck1070 FIND v(dout0_24) AT=540.025n

.meas tran vdout0_25ck1070 FIND v(dout0_25) AT=540.025n

.meas tran vdout0_26ck1070 FIND v(dout0_26) AT=540.025n

.meas tran vdout0_27ck1070 FIND v(dout0_27) AT=540.025n

.meas tran vdout0_28ck1070 FIND v(dout0_28) AT=540.025n

.meas tran vdout0_29ck1070 FIND v(dout0_29) AT=540.025n

.meas tran vdout0_30ck1070 FIND v(dout0_30) AT=540.025n

.meas tran vdout0_31ck1070 FIND v(dout0_31) AT=540.025n

.meas tran vdout0_0ck1090 FIND v(dout0_0) AT=550.025n

.meas tran vdout0_1ck1090 FIND v(dout0_1) AT=550.025n

.meas tran vdout0_2ck1090 FIND v(dout0_2) AT=550.025n

.meas tran vdout0_3ck1090 FIND v(dout0_3) AT=550.025n

.meas tran vdout0_4ck1090 FIND v(dout0_4) AT=550.025n

.meas tran vdout0_5ck1090 FIND v(dout0_5) AT=550.025n

.meas tran vdout0_6ck1090 FIND v(dout0_6) AT=550.025n

.meas tran vdout0_7ck1090 FIND v(dout0_7) AT=550.025n

.meas tran vdout0_8ck1090 FIND v(dout0_8) AT=550.025n

.meas tran vdout0_9ck1090 FIND v(dout0_9) AT=550.025n

.meas tran vdout0_10ck1090 FIND v(dout0_10) AT=550.025n

.meas tran vdout0_11ck1090 FIND v(dout0_11) AT=550.025n

.meas tran vdout0_12ck1090 FIND v(dout0_12) AT=550.025n

.meas tran vdout0_13ck1090 FIND v(dout0_13) AT=550.025n

.meas tran vdout0_14ck1090 FIND v(dout0_14) AT=550.025n

.meas tran vdout0_15ck1090 FIND v(dout0_15) AT=550.025n

.meas tran vdout0_16ck1090 FIND v(dout0_16) AT=550.025n

.meas tran vdout0_17ck1090 FIND v(dout0_17) AT=550.025n

.meas tran vdout0_18ck1090 FIND v(dout0_18) AT=550.025n

.meas tran vdout0_19ck1090 FIND v(dout0_19) AT=550.025n

.meas tran vdout0_20ck1090 FIND v(dout0_20) AT=550.025n

.meas tran vdout0_21ck1090 FIND v(dout0_21) AT=550.025n

.meas tran vdout0_22ck1090 FIND v(dout0_22) AT=550.025n

.meas tran vdout0_23ck1090 FIND v(dout0_23) AT=550.025n

.meas tran vdout0_24ck1090 FIND v(dout0_24) AT=550.025n

.meas tran vdout0_25ck1090 FIND v(dout0_25) AT=550.025n

.meas tran vdout0_26ck1090 FIND v(dout0_26) AT=550.025n

.meas tran vdout0_27ck1090 FIND v(dout0_27) AT=550.025n

.meas tran vdout0_28ck1090 FIND v(dout0_28) AT=550.025n

.meas tran vdout0_29ck1090 FIND v(dout0_29) AT=550.025n

.meas tran vdout0_30ck1090 FIND v(dout0_30) AT=550.025n

.meas tran vdout0_31ck1090 FIND v(dout0_31) AT=550.025n

.meas tran vdout0_0ck1120 FIND v(dout0_0) AT=565.025n

.meas tran vdout0_1ck1120 FIND v(dout0_1) AT=565.025n

.meas tran vdout0_2ck1120 FIND v(dout0_2) AT=565.025n

.meas tran vdout0_3ck1120 FIND v(dout0_3) AT=565.025n

.meas tran vdout0_4ck1120 FIND v(dout0_4) AT=565.025n

.meas tran vdout0_5ck1120 FIND v(dout0_5) AT=565.025n

.meas tran vdout0_6ck1120 FIND v(dout0_6) AT=565.025n

.meas tran vdout0_7ck1120 FIND v(dout0_7) AT=565.025n

.meas tran vdout0_8ck1120 FIND v(dout0_8) AT=565.025n

.meas tran vdout0_9ck1120 FIND v(dout0_9) AT=565.025n

.meas tran vdout0_10ck1120 FIND v(dout0_10) AT=565.025n

.meas tran vdout0_11ck1120 FIND v(dout0_11) AT=565.025n

.meas tran vdout0_12ck1120 FIND v(dout0_12) AT=565.025n

.meas tran vdout0_13ck1120 FIND v(dout0_13) AT=565.025n

.meas tran vdout0_14ck1120 FIND v(dout0_14) AT=565.025n

.meas tran vdout0_15ck1120 FIND v(dout0_15) AT=565.025n

.meas tran vdout0_16ck1120 FIND v(dout0_16) AT=565.025n

.meas tran vdout0_17ck1120 FIND v(dout0_17) AT=565.025n

.meas tran vdout0_18ck1120 FIND v(dout0_18) AT=565.025n

.meas tran vdout0_19ck1120 FIND v(dout0_19) AT=565.025n

.meas tran vdout0_20ck1120 FIND v(dout0_20) AT=565.025n

.meas tran vdout0_21ck1120 FIND v(dout0_21) AT=565.025n

.meas tran vdout0_22ck1120 FIND v(dout0_22) AT=565.025n

.meas tran vdout0_23ck1120 FIND v(dout0_23) AT=565.025n

.meas tran vdout0_24ck1120 FIND v(dout0_24) AT=565.025n

.meas tran vdout0_25ck1120 FIND v(dout0_25) AT=565.025n

.meas tran vdout0_26ck1120 FIND v(dout0_26) AT=565.025n

.meas tran vdout0_27ck1120 FIND v(dout0_27) AT=565.025n

.meas tran vdout0_28ck1120 FIND v(dout0_28) AT=565.025n

.meas tran vdout0_29ck1120 FIND v(dout0_29) AT=565.025n

.meas tran vdout0_30ck1120 FIND v(dout0_30) AT=565.025n

.meas tran vdout0_31ck1120 FIND v(dout0_31) AT=565.025n

.meas tran vdout0_0ck1130 FIND v(dout0_0) AT=570.025n

.meas tran vdout0_1ck1130 FIND v(dout0_1) AT=570.025n

.meas tran vdout0_2ck1130 FIND v(dout0_2) AT=570.025n

.meas tran vdout0_3ck1130 FIND v(dout0_3) AT=570.025n

.meas tran vdout0_4ck1130 FIND v(dout0_4) AT=570.025n

.meas tran vdout0_5ck1130 FIND v(dout0_5) AT=570.025n

.meas tran vdout0_6ck1130 FIND v(dout0_6) AT=570.025n

.meas tran vdout0_7ck1130 FIND v(dout0_7) AT=570.025n

.meas tran vdout0_8ck1130 FIND v(dout0_8) AT=570.025n

.meas tran vdout0_9ck1130 FIND v(dout0_9) AT=570.025n

.meas tran vdout0_10ck1130 FIND v(dout0_10) AT=570.025n

.meas tran vdout0_11ck1130 FIND v(dout0_11) AT=570.025n

.meas tran vdout0_12ck1130 FIND v(dout0_12) AT=570.025n

.meas tran vdout0_13ck1130 FIND v(dout0_13) AT=570.025n

.meas tran vdout0_14ck1130 FIND v(dout0_14) AT=570.025n

.meas tran vdout0_15ck1130 FIND v(dout0_15) AT=570.025n

.meas tran vdout0_16ck1130 FIND v(dout0_16) AT=570.025n

.meas tran vdout0_17ck1130 FIND v(dout0_17) AT=570.025n

.meas tran vdout0_18ck1130 FIND v(dout0_18) AT=570.025n

.meas tran vdout0_19ck1130 FIND v(dout0_19) AT=570.025n

.meas tran vdout0_20ck1130 FIND v(dout0_20) AT=570.025n

.meas tran vdout0_21ck1130 FIND v(dout0_21) AT=570.025n

.meas tran vdout0_22ck1130 FIND v(dout0_22) AT=570.025n

.meas tran vdout0_23ck1130 FIND v(dout0_23) AT=570.025n

.meas tran vdout0_24ck1130 FIND v(dout0_24) AT=570.025n

.meas tran vdout0_25ck1130 FIND v(dout0_25) AT=570.025n

.meas tran vdout0_26ck1130 FIND v(dout0_26) AT=570.025n

.meas tran vdout0_27ck1130 FIND v(dout0_27) AT=570.025n

.meas tran vdout0_28ck1130 FIND v(dout0_28) AT=570.025n

.meas tran vdout0_29ck1130 FIND v(dout0_29) AT=570.025n

.meas tran vdout0_30ck1130 FIND v(dout0_30) AT=570.025n

.meas tran vdout0_31ck1130 FIND v(dout0_31) AT=570.025n

.meas tran vdout0_0ck1160 FIND v(dout0_0) AT=585.025n

.meas tran vdout0_1ck1160 FIND v(dout0_1) AT=585.025n

.meas tran vdout0_2ck1160 FIND v(dout0_2) AT=585.025n

.meas tran vdout0_3ck1160 FIND v(dout0_3) AT=585.025n

.meas tran vdout0_4ck1160 FIND v(dout0_4) AT=585.025n

.meas tran vdout0_5ck1160 FIND v(dout0_5) AT=585.025n

.meas tran vdout0_6ck1160 FIND v(dout0_6) AT=585.025n

.meas tran vdout0_7ck1160 FIND v(dout0_7) AT=585.025n

.meas tran vdout0_8ck1160 FIND v(dout0_8) AT=585.025n

.meas tran vdout0_9ck1160 FIND v(dout0_9) AT=585.025n

.meas tran vdout0_10ck1160 FIND v(dout0_10) AT=585.025n

.meas tran vdout0_11ck1160 FIND v(dout0_11) AT=585.025n

.meas tran vdout0_12ck1160 FIND v(dout0_12) AT=585.025n

.meas tran vdout0_13ck1160 FIND v(dout0_13) AT=585.025n

.meas tran vdout0_14ck1160 FIND v(dout0_14) AT=585.025n

.meas tran vdout0_15ck1160 FIND v(dout0_15) AT=585.025n

.meas tran vdout0_16ck1160 FIND v(dout0_16) AT=585.025n

.meas tran vdout0_17ck1160 FIND v(dout0_17) AT=585.025n

.meas tran vdout0_18ck1160 FIND v(dout0_18) AT=585.025n

.meas tran vdout0_19ck1160 FIND v(dout0_19) AT=585.025n

.meas tran vdout0_20ck1160 FIND v(dout0_20) AT=585.025n

.meas tran vdout0_21ck1160 FIND v(dout0_21) AT=585.025n

.meas tran vdout0_22ck1160 FIND v(dout0_22) AT=585.025n

.meas tran vdout0_23ck1160 FIND v(dout0_23) AT=585.025n

.meas tran vdout0_24ck1160 FIND v(dout0_24) AT=585.025n

.meas tran vdout0_25ck1160 FIND v(dout0_25) AT=585.025n

.meas tran vdout0_26ck1160 FIND v(dout0_26) AT=585.025n

.meas tran vdout0_27ck1160 FIND v(dout0_27) AT=585.025n

.meas tran vdout0_28ck1160 FIND v(dout0_28) AT=585.025n

.meas tran vdout0_29ck1160 FIND v(dout0_29) AT=585.025n

.meas tran vdout0_30ck1160 FIND v(dout0_30) AT=585.025n

.meas tran vdout0_31ck1160 FIND v(dout0_31) AT=585.025n

.meas tran vdout0_0ck1170 FIND v(dout0_0) AT=590.025n

.meas tran vdout0_1ck1170 FIND v(dout0_1) AT=590.025n

.meas tran vdout0_2ck1170 FIND v(dout0_2) AT=590.025n

.meas tran vdout0_3ck1170 FIND v(dout0_3) AT=590.025n

.meas tran vdout0_4ck1170 FIND v(dout0_4) AT=590.025n

.meas tran vdout0_5ck1170 FIND v(dout0_5) AT=590.025n

.meas tran vdout0_6ck1170 FIND v(dout0_6) AT=590.025n

.meas tran vdout0_7ck1170 FIND v(dout0_7) AT=590.025n

.meas tran vdout0_8ck1170 FIND v(dout0_8) AT=590.025n

.meas tran vdout0_9ck1170 FIND v(dout0_9) AT=590.025n

.meas tran vdout0_10ck1170 FIND v(dout0_10) AT=590.025n

.meas tran vdout0_11ck1170 FIND v(dout0_11) AT=590.025n

.meas tran vdout0_12ck1170 FIND v(dout0_12) AT=590.025n

.meas tran vdout0_13ck1170 FIND v(dout0_13) AT=590.025n

.meas tran vdout0_14ck1170 FIND v(dout0_14) AT=590.025n

.meas tran vdout0_15ck1170 FIND v(dout0_15) AT=590.025n

.meas tran vdout0_16ck1170 FIND v(dout0_16) AT=590.025n

.meas tran vdout0_17ck1170 FIND v(dout0_17) AT=590.025n

.meas tran vdout0_18ck1170 FIND v(dout0_18) AT=590.025n

.meas tran vdout0_19ck1170 FIND v(dout0_19) AT=590.025n

.meas tran vdout0_20ck1170 FIND v(dout0_20) AT=590.025n

.meas tran vdout0_21ck1170 FIND v(dout0_21) AT=590.025n

.meas tran vdout0_22ck1170 FIND v(dout0_22) AT=590.025n

.meas tran vdout0_23ck1170 FIND v(dout0_23) AT=590.025n

.meas tran vdout0_24ck1170 FIND v(dout0_24) AT=590.025n

.meas tran vdout0_25ck1170 FIND v(dout0_25) AT=590.025n

.meas tran vdout0_26ck1170 FIND v(dout0_26) AT=590.025n

.meas tran vdout0_27ck1170 FIND v(dout0_27) AT=590.025n

.meas tran vdout0_28ck1170 FIND v(dout0_28) AT=590.025n

.meas tran vdout0_29ck1170 FIND v(dout0_29) AT=590.025n

.meas tran vdout0_30ck1170 FIND v(dout0_30) AT=590.025n

.meas tran vdout0_31ck1170 FIND v(dout0_31) AT=590.025n

.meas tran vdout0_0ck1190 FIND v(dout0_0) AT=600.025n

.meas tran vdout0_1ck1190 FIND v(dout0_1) AT=600.025n

.meas tran vdout0_2ck1190 FIND v(dout0_2) AT=600.025n

.meas tran vdout0_3ck1190 FIND v(dout0_3) AT=600.025n

.meas tran vdout0_4ck1190 FIND v(dout0_4) AT=600.025n

.meas tran vdout0_5ck1190 FIND v(dout0_5) AT=600.025n

.meas tran vdout0_6ck1190 FIND v(dout0_6) AT=600.025n

.meas tran vdout0_7ck1190 FIND v(dout0_7) AT=600.025n

.meas tran vdout0_8ck1190 FIND v(dout0_8) AT=600.025n

.meas tran vdout0_9ck1190 FIND v(dout0_9) AT=600.025n

.meas tran vdout0_10ck1190 FIND v(dout0_10) AT=600.025n

.meas tran vdout0_11ck1190 FIND v(dout0_11) AT=600.025n

.meas tran vdout0_12ck1190 FIND v(dout0_12) AT=600.025n

.meas tran vdout0_13ck1190 FIND v(dout0_13) AT=600.025n

.meas tran vdout0_14ck1190 FIND v(dout0_14) AT=600.025n

.meas tran vdout0_15ck1190 FIND v(dout0_15) AT=600.025n

.meas tran vdout0_16ck1190 FIND v(dout0_16) AT=600.025n

.meas tran vdout0_17ck1190 FIND v(dout0_17) AT=600.025n

.meas tran vdout0_18ck1190 FIND v(dout0_18) AT=600.025n

.meas tran vdout0_19ck1190 FIND v(dout0_19) AT=600.025n

.meas tran vdout0_20ck1190 FIND v(dout0_20) AT=600.025n

.meas tran vdout0_21ck1190 FIND v(dout0_21) AT=600.025n

.meas tran vdout0_22ck1190 FIND v(dout0_22) AT=600.025n

.meas tran vdout0_23ck1190 FIND v(dout0_23) AT=600.025n

.meas tran vdout0_24ck1190 FIND v(dout0_24) AT=600.025n

.meas tran vdout0_25ck1190 FIND v(dout0_25) AT=600.025n

.meas tran vdout0_26ck1190 FIND v(dout0_26) AT=600.025n

.meas tran vdout0_27ck1190 FIND v(dout0_27) AT=600.025n

.meas tran vdout0_28ck1190 FIND v(dout0_28) AT=600.025n

.meas tran vdout0_29ck1190 FIND v(dout0_29) AT=600.025n

.meas tran vdout0_30ck1190 FIND v(dout0_30) AT=600.025n

.meas tran vdout0_31ck1190 FIND v(dout0_31) AT=600.025n

.meas tran vdout0_0ck1210 FIND v(dout0_0) AT=610.025n

.meas tran vdout0_1ck1210 FIND v(dout0_1) AT=610.025n

.meas tran vdout0_2ck1210 FIND v(dout0_2) AT=610.025n

.meas tran vdout0_3ck1210 FIND v(dout0_3) AT=610.025n

.meas tran vdout0_4ck1210 FIND v(dout0_4) AT=610.025n

.meas tran vdout0_5ck1210 FIND v(dout0_5) AT=610.025n

.meas tran vdout0_6ck1210 FIND v(dout0_6) AT=610.025n

.meas tran vdout0_7ck1210 FIND v(dout0_7) AT=610.025n

.meas tran vdout0_8ck1210 FIND v(dout0_8) AT=610.025n

.meas tran vdout0_9ck1210 FIND v(dout0_9) AT=610.025n

.meas tran vdout0_10ck1210 FIND v(dout0_10) AT=610.025n

.meas tran vdout0_11ck1210 FIND v(dout0_11) AT=610.025n

.meas tran vdout0_12ck1210 FIND v(dout0_12) AT=610.025n

.meas tran vdout0_13ck1210 FIND v(dout0_13) AT=610.025n

.meas tran vdout0_14ck1210 FIND v(dout0_14) AT=610.025n

.meas tran vdout0_15ck1210 FIND v(dout0_15) AT=610.025n

.meas tran vdout0_16ck1210 FIND v(dout0_16) AT=610.025n

.meas tran vdout0_17ck1210 FIND v(dout0_17) AT=610.025n

.meas tran vdout0_18ck1210 FIND v(dout0_18) AT=610.025n

.meas tran vdout0_19ck1210 FIND v(dout0_19) AT=610.025n

.meas tran vdout0_20ck1210 FIND v(dout0_20) AT=610.025n

.meas tran vdout0_21ck1210 FIND v(dout0_21) AT=610.025n

.meas tran vdout0_22ck1210 FIND v(dout0_22) AT=610.025n

.meas tran vdout0_23ck1210 FIND v(dout0_23) AT=610.025n

.meas tran vdout0_24ck1210 FIND v(dout0_24) AT=610.025n

.meas tran vdout0_25ck1210 FIND v(dout0_25) AT=610.025n

.meas tran vdout0_26ck1210 FIND v(dout0_26) AT=610.025n

.meas tran vdout0_27ck1210 FIND v(dout0_27) AT=610.025n

.meas tran vdout0_28ck1210 FIND v(dout0_28) AT=610.025n

.meas tran vdout0_29ck1210 FIND v(dout0_29) AT=610.025n

.meas tran vdout0_30ck1210 FIND v(dout0_30) AT=610.025n

.meas tran vdout0_31ck1210 FIND v(dout0_31) AT=610.025n

.meas tran vdout0_0ck1220 FIND v(dout0_0) AT=615.025n

.meas tran vdout0_1ck1220 FIND v(dout0_1) AT=615.025n

.meas tran vdout0_2ck1220 FIND v(dout0_2) AT=615.025n

.meas tran vdout0_3ck1220 FIND v(dout0_3) AT=615.025n

.meas tran vdout0_4ck1220 FIND v(dout0_4) AT=615.025n

.meas tran vdout0_5ck1220 FIND v(dout0_5) AT=615.025n

.meas tran vdout0_6ck1220 FIND v(dout0_6) AT=615.025n

.meas tran vdout0_7ck1220 FIND v(dout0_7) AT=615.025n

.meas tran vdout0_8ck1220 FIND v(dout0_8) AT=615.025n

.meas tran vdout0_9ck1220 FIND v(dout0_9) AT=615.025n

.meas tran vdout0_10ck1220 FIND v(dout0_10) AT=615.025n

.meas tran vdout0_11ck1220 FIND v(dout0_11) AT=615.025n

.meas tran vdout0_12ck1220 FIND v(dout0_12) AT=615.025n

.meas tran vdout0_13ck1220 FIND v(dout0_13) AT=615.025n

.meas tran vdout0_14ck1220 FIND v(dout0_14) AT=615.025n

.meas tran vdout0_15ck1220 FIND v(dout0_15) AT=615.025n

.meas tran vdout0_16ck1220 FIND v(dout0_16) AT=615.025n

.meas tran vdout0_17ck1220 FIND v(dout0_17) AT=615.025n

.meas tran vdout0_18ck1220 FIND v(dout0_18) AT=615.025n

.meas tran vdout0_19ck1220 FIND v(dout0_19) AT=615.025n

.meas tran vdout0_20ck1220 FIND v(dout0_20) AT=615.025n

.meas tran vdout0_21ck1220 FIND v(dout0_21) AT=615.025n

.meas tran vdout0_22ck1220 FIND v(dout0_22) AT=615.025n

.meas tran vdout0_23ck1220 FIND v(dout0_23) AT=615.025n

.meas tran vdout0_24ck1220 FIND v(dout0_24) AT=615.025n

.meas tran vdout0_25ck1220 FIND v(dout0_25) AT=615.025n

.meas tran vdout0_26ck1220 FIND v(dout0_26) AT=615.025n

.meas tran vdout0_27ck1220 FIND v(dout0_27) AT=615.025n

.meas tran vdout0_28ck1220 FIND v(dout0_28) AT=615.025n

.meas tran vdout0_29ck1220 FIND v(dout0_29) AT=615.025n

.meas tran vdout0_30ck1220 FIND v(dout0_30) AT=615.025n

.meas tran vdout0_31ck1220 FIND v(dout0_31) AT=615.025n

.meas tran vdout0_0ck1250 FIND v(dout0_0) AT=630.025n

.meas tran vdout0_1ck1250 FIND v(dout0_1) AT=630.025n

.meas tran vdout0_2ck1250 FIND v(dout0_2) AT=630.025n

.meas tran vdout0_3ck1250 FIND v(dout0_3) AT=630.025n

.meas tran vdout0_4ck1250 FIND v(dout0_4) AT=630.025n

.meas tran vdout0_5ck1250 FIND v(dout0_5) AT=630.025n

.meas tran vdout0_6ck1250 FIND v(dout0_6) AT=630.025n

.meas tran vdout0_7ck1250 FIND v(dout0_7) AT=630.025n

.meas tran vdout0_8ck1250 FIND v(dout0_8) AT=630.025n

.meas tran vdout0_9ck1250 FIND v(dout0_9) AT=630.025n

.meas tran vdout0_10ck1250 FIND v(dout0_10) AT=630.025n

.meas tran vdout0_11ck1250 FIND v(dout0_11) AT=630.025n

.meas tran vdout0_12ck1250 FIND v(dout0_12) AT=630.025n

.meas tran vdout0_13ck1250 FIND v(dout0_13) AT=630.025n

.meas tran vdout0_14ck1250 FIND v(dout0_14) AT=630.025n

.meas tran vdout0_15ck1250 FIND v(dout0_15) AT=630.025n

.meas tran vdout0_16ck1250 FIND v(dout0_16) AT=630.025n

.meas tran vdout0_17ck1250 FIND v(dout0_17) AT=630.025n

.meas tran vdout0_18ck1250 FIND v(dout0_18) AT=630.025n

.meas tran vdout0_19ck1250 FIND v(dout0_19) AT=630.025n

.meas tran vdout0_20ck1250 FIND v(dout0_20) AT=630.025n

.meas tran vdout0_21ck1250 FIND v(dout0_21) AT=630.025n

.meas tran vdout0_22ck1250 FIND v(dout0_22) AT=630.025n

.meas tran vdout0_23ck1250 FIND v(dout0_23) AT=630.025n

.meas tran vdout0_24ck1250 FIND v(dout0_24) AT=630.025n

.meas tran vdout0_25ck1250 FIND v(dout0_25) AT=630.025n

.meas tran vdout0_26ck1250 FIND v(dout0_26) AT=630.025n

.meas tran vdout0_27ck1250 FIND v(dout0_27) AT=630.025n

.meas tran vdout0_28ck1250 FIND v(dout0_28) AT=630.025n

.meas tran vdout0_29ck1250 FIND v(dout0_29) AT=630.025n

.meas tran vdout0_30ck1250 FIND v(dout0_30) AT=630.025n

.meas tran vdout0_31ck1250 FIND v(dout0_31) AT=630.025n

.meas tran vdout0_0ck1260 FIND v(dout0_0) AT=635.025n

.meas tran vdout0_1ck1260 FIND v(dout0_1) AT=635.025n

.meas tran vdout0_2ck1260 FIND v(dout0_2) AT=635.025n

.meas tran vdout0_3ck1260 FIND v(dout0_3) AT=635.025n

.meas tran vdout0_4ck1260 FIND v(dout0_4) AT=635.025n

.meas tran vdout0_5ck1260 FIND v(dout0_5) AT=635.025n

.meas tran vdout0_6ck1260 FIND v(dout0_6) AT=635.025n

.meas tran vdout0_7ck1260 FIND v(dout0_7) AT=635.025n

.meas tran vdout0_8ck1260 FIND v(dout0_8) AT=635.025n

.meas tran vdout0_9ck1260 FIND v(dout0_9) AT=635.025n

.meas tran vdout0_10ck1260 FIND v(dout0_10) AT=635.025n

.meas tran vdout0_11ck1260 FIND v(dout0_11) AT=635.025n

.meas tran vdout0_12ck1260 FIND v(dout0_12) AT=635.025n

.meas tran vdout0_13ck1260 FIND v(dout0_13) AT=635.025n

.meas tran vdout0_14ck1260 FIND v(dout0_14) AT=635.025n

.meas tran vdout0_15ck1260 FIND v(dout0_15) AT=635.025n

.meas tran vdout0_16ck1260 FIND v(dout0_16) AT=635.025n

.meas tran vdout0_17ck1260 FIND v(dout0_17) AT=635.025n

.meas tran vdout0_18ck1260 FIND v(dout0_18) AT=635.025n

.meas tran vdout0_19ck1260 FIND v(dout0_19) AT=635.025n

.meas tran vdout0_20ck1260 FIND v(dout0_20) AT=635.025n

.meas tran vdout0_21ck1260 FIND v(dout0_21) AT=635.025n

.meas tran vdout0_22ck1260 FIND v(dout0_22) AT=635.025n

.meas tran vdout0_23ck1260 FIND v(dout0_23) AT=635.025n

.meas tran vdout0_24ck1260 FIND v(dout0_24) AT=635.025n

.meas tran vdout0_25ck1260 FIND v(dout0_25) AT=635.025n

.meas tran vdout0_26ck1260 FIND v(dout0_26) AT=635.025n

.meas tran vdout0_27ck1260 FIND v(dout0_27) AT=635.025n

.meas tran vdout0_28ck1260 FIND v(dout0_28) AT=635.025n

.meas tran vdout0_29ck1260 FIND v(dout0_29) AT=635.025n

.meas tran vdout0_30ck1260 FIND v(dout0_30) AT=635.025n

.meas tran vdout0_31ck1260 FIND v(dout0_31) AT=635.025n

.meas tran vdout0_0ck1270 FIND v(dout0_0) AT=640.025n

.meas tran vdout0_1ck1270 FIND v(dout0_1) AT=640.025n

.meas tran vdout0_2ck1270 FIND v(dout0_2) AT=640.025n

.meas tran vdout0_3ck1270 FIND v(dout0_3) AT=640.025n

.meas tran vdout0_4ck1270 FIND v(dout0_4) AT=640.025n

.meas tran vdout0_5ck1270 FIND v(dout0_5) AT=640.025n

.meas tran vdout0_6ck1270 FIND v(dout0_6) AT=640.025n

.meas tran vdout0_7ck1270 FIND v(dout0_7) AT=640.025n

.meas tran vdout0_8ck1270 FIND v(dout0_8) AT=640.025n

.meas tran vdout0_9ck1270 FIND v(dout0_9) AT=640.025n

.meas tran vdout0_10ck1270 FIND v(dout0_10) AT=640.025n

.meas tran vdout0_11ck1270 FIND v(dout0_11) AT=640.025n

.meas tran vdout0_12ck1270 FIND v(dout0_12) AT=640.025n

.meas tran vdout0_13ck1270 FIND v(dout0_13) AT=640.025n

.meas tran vdout0_14ck1270 FIND v(dout0_14) AT=640.025n

.meas tran vdout0_15ck1270 FIND v(dout0_15) AT=640.025n

.meas tran vdout0_16ck1270 FIND v(dout0_16) AT=640.025n

.meas tran vdout0_17ck1270 FIND v(dout0_17) AT=640.025n

.meas tran vdout0_18ck1270 FIND v(dout0_18) AT=640.025n

.meas tran vdout0_19ck1270 FIND v(dout0_19) AT=640.025n

.meas tran vdout0_20ck1270 FIND v(dout0_20) AT=640.025n

.meas tran vdout0_21ck1270 FIND v(dout0_21) AT=640.025n

.meas tran vdout0_22ck1270 FIND v(dout0_22) AT=640.025n

.meas tran vdout0_23ck1270 FIND v(dout0_23) AT=640.025n

.meas tran vdout0_24ck1270 FIND v(dout0_24) AT=640.025n

.meas tran vdout0_25ck1270 FIND v(dout0_25) AT=640.025n

.meas tran vdout0_26ck1270 FIND v(dout0_26) AT=640.025n

.meas tran vdout0_27ck1270 FIND v(dout0_27) AT=640.025n

.meas tran vdout0_28ck1270 FIND v(dout0_28) AT=640.025n

.meas tran vdout0_29ck1270 FIND v(dout0_29) AT=640.025n

.meas tran vdout0_30ck1270 FIND v(dout0_30) AT=640.025n

.meas tran vdout0_31ck1270 FIND v(dout0_31) AT=640.025n

.meas tran vdout0_0ck1280 FIND v(dout0_0) AT=645.025n

.meas tran vdout0_1ck1280 FIND v(dout0_1) AT=645.025n

.meas tran vdout0_2ck1280 FIND v(dout0_2) AT=645.025n

.meas tran vdout0_3ck1280 FIND v(dout0_3) AT=645.025n

.meas tran vdout0_4ck1280 FIND v(dout0_4) AT=645.025n

.meas tran vdout0_5ck1280 FIND v(dout0_5) AT=645.025n

.meas tran vdout0_6ck1280 FIND v(dout0_6) AT=645.025n

.meas tran vdout0_7ck1280 FIND v(dout0_7) AT=645.025n

.meas tran vdout0_8ck1280 FIND v(dout0_8) AT=645.025n

.meas tran vdout0_9ck1280 FIND v(dout0_9) AT=645.025n

.meas tran vdout0_10ck1280 FIND v(dout0_10) AT=645.025n

.meas tran vdout0_11ck1280 FIND v(dout0_11) AT=645.025n

.meas tran vdout0_12ck1280 FIND v(dout0_12) AT=645.025n

.meas tran vdout0_13ck1280 FIND v(dout0_13) AT=645.025n

.meas tran vdout0_14ck1280 FIND v(dout0_14) AT=645.025n

.meas tran vdout0_15ck1280 FIND v(dout0_15) AT=645.025n

.meas tran vdout0_16ck1280 FIND v(dout0_16) AT=645.025n

.meas tran vdout0_17ck1280 FIND v(dout0_17) AT=645.025n

.meas tran vdout0_18ck1280 FIND v(dout0_18) AT=645.025n

.meas tran vdout0_19ck1280 FIND v(dout0_19) AT=645.025n

.meas tran vdout0_20ck1280 FIND v(dout0_20) AT=645.025n

.meas tran vdout0_21ck1280 FIND v(dout0_21) AT=645.025n

.meas tran vdout0_22ck1280 FIND v(dout0_22) AT=645.025n

.meas tran vdout0_23ck1280 FIND v(dout0_23) AT=645.025n

.meas tran vdout0_24ck1280 FIND v(dout0_24) AT=645.025n

.meas tran vdout0_25ck1280 FIND v(dout0_25) AT=645.025n

.meas tran vdout0_26ck1280 FIND v(dout0_26) AT=645.025n

.meas tran vdout0_27ck1280 FIND v(dout0_27) AT=645.025n

.meas tran vdout0_28ck1280 FIND v(dout0_28) AT=645.025n

.meas tran vdout0_29ck1280 FIND v(dout0_29) AT=645.025n

.meas tran vdout0_30ck1280 FIND v(dout0_30) AT=645.025n

.meas tran vdout0_31ck1280 FIND v(dout0_31) AT=645.025n

.meas tran vdout0_0ck1290 FIND v(dout0_0) AT=650.025n

.meas tran vdout0_1ck1290 FIND v(dout0_1) AT=650.025n

.meas tran vdout0_2ck1290 FIND v(dout0_2) AT=650.025n

.meas tran vdout0_3ck1290 FIND v(dout0_3) AT=650.025n

.meas tran vdout0_4ck1290 FIND v(dout0_4) AT=650.025n

.meas tran vdout0_5ck1290 FIND v(dout0_5) AT=650.025n

.meas tran vdout0_6ck1290 FIND v(dout0_6) AT=650.025n

.meas tran vdout0_7ck1290 FIND v(dout0_7) AT=650.025n

.meas tran vdout0_8ck1290 FIND v(dout0_8) AT=650.025n

.meas tran vdout0_9ck1290 FIND v(dout0_9) AT=650.025n

.meas tran vdout0_10ck1290 FIND v(dout0_10) AT=650.025n

.meas tran vdout0_11ck1290 FIND v(dout0_11) AT=650.025n

.meas tran vdout0_12ck1290 FIND v(dout0_12) AT=650.025n

.meas tran vdout0_13ck1290 FIND v(dout0_13) AT=650.025n

.meas tran vdout0_14ck1290 FIND v(dout0_14) AT=650.025n

.meas tran vdout0_15ck1290 FIND v(dout0_15) AT=650.025n

.meas tran vdout0_16ck1290 FIND v(dout0_16) AT=650.025n

.meas tran vdout0_17ck1290 FIND v(dout0_17) AT=650.025n

.meas tran vdout0_18ck1290 FIND v(dout0_18) AT=650.025n

.meas tran vdout0_19ck1290 FIND v(dout0_19) AT=650.025n

.meas tran vdout0_20ck1290 FIND v(dout0_20) AT=650.025n

.meas tran vdout0_21ck1290 FIND v(dout0_21) AT=650.025n

.meas tran vdout0_22ck1290 FIND v(dout0_22) AT=650.025n

.meas tran vdout0_23ck1290 FIND v(dout0_23) AT=650.025n

.meas tran vdout0_24ck1290 FIND v(dout0_24) AT=650.025n

.meas tran vdout0_25ck1290 FIND v(dout0_25) AT=650.025n

.meas tran vdout0_26ck1290 FIND v(dout0_26) AT=650.025n

.meas tran vdout0_27ck1290 FIND v(dout0_27) AT=650.025n

.meas tran vdout0_28ck1290 FIND v(dout0_28) AT=650.025n

.meas tran vdout0_29ck1290 FIND v(dout0_29) AT=650.025n

.meas tran vdout0_30ck1290 FIND v(dout0_30) AT=650.025n

.meas tran vdout0_31ck1290 FIND v(dout0_31) AT=650.025n

.meas tran vdout0_0ck1320 FIND v(dout0_0) AT=665.025n

.meas tran vdout0_1ck1320 FIND v(dout0_1) AT=665.025n

.meas tran vdout0_2ck1320 FIND v(dout0_2) AT=665.025n

.meas tran vdout0_3ck1320 FIND v(dout0_3) AT=665.025n

.meas tran vdout0_4ck1320 FIND v(dout0_4) AT=665.025n

.meas tran vdout0_5ck1320 FIND v(dout0_5) AT=665.025n

.meas tran vdout0_6ck1320 FIND v(dout0_6) AT=665.025n

.meas tran vdout0_7ck1320 FIND v(dout0_7) AT=665.025n

.meas tran vdout0_8ck1320 FIND v(dout0_8) AT=665.025n

.meas tran vdout0_9ck1320 FIND v(dout0_9) AT=665.025n

.meas tran vdout0_10ck1320 FIND v(dout0_10) AT=665.025n

.meas tran vdout0_11ck1320 FIND v(dout0_11) AT=665.025n

.meas tran vdout0_12ck1320 FIND v(dout0_12) AT=665.025n

.meas tran vdout0_13ck1320 FIND v(dout0_13) AT=665.025n

.meas tran vdout0_14ck1320 FIND v(dout0_14) AT=665.025n

.meas tran vdout0_15ck1320 FIND v(dout0_15) AT=665.025n

.meas tran vdout0_16ck1320 FIND v(dout0_16) AT=665.025n

.meas tran vdout0_17ck1320 FIND v(dout0_17) AT=665.025n

.meas tran vdout0_18ck1320 FIND v(dout0_18) AT=665.025n

.meas tran vdout0_19ck1320 FIND v(dout0_19) AT=665.025n

.meas tran vdout0_20ck1320 FIND v(dout0_20) AT=665.025n

.meas tran vdout0_21ck1320 FIND v(dout0_21) AT=665.025n

.meas tran vdout0_22ck1320 FIND v(dout0_22) AT=665.025n

.meas tran vdout0_23ck1320 FIND v(dout0_23) AT=665.025n

.meas tran vdout0_24ck1320 FIND v(dout0_24) AT=665.025n

.meas tran vdout0_25ck1320 FIND v(dout0_25) AT=665.025n

.meas tran vdout0_26ck1320 FIND v(dout0_26) AT=665.025n

.meas tran vdout0_27ck1320 FIND v(dout0_27) AT=665.025n

.meas tran vdout0_28ck1320 FIND v(dout0_28) AT=665.025n

.meas tran vdout0_29ck1320 FIND v(dout0_29) AT=665.025n

.meas tran vdout0_30ck1320 FIND v(dout0_30) AT=665.025n

.meas tran vdout0_31ck1320 FIND v(dout0_31) AT=665.025n

.meas tran vdout0_0ck1330 FIND v(dout0_0) AT=670.025n

.meas tran vdout0_1ck1330 FIND v(dout0_1) AT=670.025n

.meas tran vdout0_2ck1330 FIND v(dout0_2) AT=670.025n

.meas tran vdout0_3ck1330 FIND v(dout0_3) AT=670.025n

.meas tran vdout0_4ck1330 FIND v(dout0_4) AT=670.025n

.meas tran vdout0_5ck1330 FIND v(dout0_5) AT=670.025n

.meas tran vdout0_6ck1330 FIND v(dout0_6) AT=670.025n

.meas tran vdout0_7ck1330 FIND v(dout0_7) AT=670.025n

.meas tran vdout0_8ck1330 FIND v(dout0_8) AT=670.025n

.meas tran vdout0_9ck1330 FIND v(dout0_9) AT=670.025n

.meas tran vdout0_10ck1330 FIND v(dout0_10) AT=670.025n

.meas tran vdout0_11ck1330 FIND v(dout0_11) AT=670.025n

.meas tran vdout0_12ck1330 FIND v(dout0_12) AT=670.025n

.meas tran vdout0_13ck1330 FIND v(dout0_13) AT=670.025n

.meas tran vdout0_14ck1330 FIND v(dout0_14) AT=670.025n

.meas tran vdout0_15ck1330 FIND v(dout0_15) AT=670.025n

.meas tran vdout0_16ck1330 FIND v(dout0_16) AT=670.025n

.meas tran vdout0_17ck1330 FIND v(dout0_17) AT=670.025n

.meas tran vdout0_18ck1330 FIND v(dout0_18) AT=670.025n

.meas tran vdout0_19ck1330 FIND v(dout0_19) AT=670.025n

.meas tran vdout0_20ck1330 FIND v(dout0_20) AT=670.025n

.meas tran vdout0_21ck1330 FIND v(dout0_21) AT=670.025n

.meas tran vdout0_22ck1330 FIND v(dout0_22) AT=670.025n

.meas tran vdout0_23ck1330 FIND v(dout0_23) AT=670.025n

.meas tran vdout0_24ck1330 FIND v(dout0_24) AT=670.025n

.meas tran vdout0_25ck1330 FIND v(dout0_25) AT=670.025n

.meas tran vdout0_26ck1330 FIND v(dout0_26) AT=670.025n

.meas tran vdout0_27ck1330 FIND v(dout0_27) AT=670.025n

.meas tran vdout0_28ck1330 FIND v(dout0_28) AT=670.025n

.meas tran vdout0_29ck1330 FIND v(dout0_29) AT=670.025n

.meas tran vdout0_30ck1330 FIND v(dout0_30) AT=670.025n

.meas tran vdout0_31ck1330 FIND v(dout0_31) AT=670.025n

.meas tran vdout0_0ck1340 FIND v(dout0_0) AT=675.025n

.meas tran vdout0_1ck1340 FIND v(dout0_1) AT=675.025n

.meas tran vdout0_2ck1340 FIND v(dout0_2) AT=675.025n

.meas tran vdout0_3ck1340 FIND v(dout0_3) AT=675.025n

.meas tran vdout0_4ck1340 FIND v(dout0_4) AT=675.025n

.meas tran vdout0_5ck1340 FIND v(dout0_5) AT=675.025n

.meas tran vdout0_6ck1340 FIND v(dout0_6) AT=675.025n

.meas tran vdout0_7ck1340 FIND v(dout0_7) AT=675.025n

.meas tran vdout0_8ck1340 FIND v(dout0_8) AT=675.025n

.meas tran vdout0_9ck1340 FIND v(dout0_9) AT=675.025n

.meas tran vdout0_10ck1340 FIND v(dout0_10) AT=675.025n

.meas tran vdout0_11ck1340 FIND v(dout0_11) AT=675.025n

.meas tran vdout0_12ck1340 FIND v(dout0_12) AT=675.025n

.meas tran vdout0_13ck1340 FIND v(dout0_13) AT=675.025n

.meas tran vdout0_14ck1340 FIND v(dout0_14) AT=675.025n

.meas tran vdout0_15ck1340 FIND v(dout0_15) AT=675.025n

.meas tran vdout0_16ck1340 FIND v(dout0_16) AT=675.025n

.meas tran vdout0_17ck1340 FIND v(dout0_17) AT=675.025n

.meas tran vdout0_18ck1340 FIND v(dout0_18) AT=675.025n

.meas tran vdout0_19ck1340 FIND v(dout0_19) AT=675.025n

.meas tran vdout0_20ck1340 FIND v(dout0_20) AT=675.025n

.meas tran vdout0_21ck1340 FIND v(dout0_21) AT=675.025n

.meas tran vdout0_22ck1340 FIND v(dout0_22) AT=675.025n

.meas tran vdout0_23ck1340 FIND v(dout0_23) AT=675.025n

.meas tran vdout0_24ck1340 FIND v(dout0_24) AT=675.025n

.meas tran vdout0_25ck1340 FIND v(dout0_25) AT=675.025n

.meas tran vdout0_26ck1340 FIND v(dout0_26) AT=675.025n

.meas tran vdout0_27ck1340 FIND v(dout0_27) AT=675.025n

.meas tran vdout0_28ck1340 FIND v(dout0_28) AT=675.025n

.meas tran vdout0_29ck1340 FIND v(dout0_29) AT=675.025n

.meas tran vdout0_30ck1340 FIND v(dout0_30) AT=675.025n

.meas tran vdout0_31ck1340 FIND v(dout0_31) AT=675.025n

.meas tran vdout0_0ck1350 FIND v(dout0_0) AT=680.025n

.meas tran vdout0_1ck1350 FIND v(dout0_1) AT=680.025n

.meas tran vdout0_2ck1350 FIND v(dout0_2) AT=680.025n

.meas tran vdout0_3ck1350 FIND v(dout0_3) AT=680.025n

.meas tran vdout0_4ck1350 FIND v(dout0_4) AT=680.025n

.meas tran vdout0_5ck1350 FIND v(dout0_5) AT=680.025n

.meas tran vdout0_6ck1350 FIND v(dout0_6) AT=680.025n

.meas tran vdout0_7ck1350 FIND v(dout0_7) AT=680.025n

.meas tran vdout0_8ck1350 FIND v(dout0_8) AT=680.025n

.meas tran vdout0_9ck1350 FIND v(dout0_9) AT=680.025n

.meas tran vdout0_10ck1350 FIND v(dout0_10) AT=680.025n

.meas tran vdout0_11ck1350 FIND v(dout0_11) AT=680.025n

.meas tran vdout0_12ck1350 FIND v(dout0_12) AT=680.025n

.meas tran vdout0_13ck1350 FIND v(dout0_13) AT=680.025n

.meas tran vdout0_14ck1350 FIND v(dout0_14) AT=680.025n

.meas tran vdout0_15ck1350 FIND v(dout0_15) AT=680.025n

.meas tran vdout0_16ck1350 FIND v(dout0_16) AT=680.025n

.meas tran vdout0_17ck1350 FIND v(dout0_17) AT=680.025n

.meas tran vdout0_18ck1350 FIND v(dout0_18) AT=680.025n

.meas tran vdout0_19ck1350 FIND v(dout0_19) AT=680.025n

.meas tran vdout0_20ck1350 FIND v(dout0_20) AT=680.025n

.meas tran vdout0_21ck1350 FIND v(dout0_21) AT=680.025n

.meas tran vdout0_22ck1350 FIND v(dout0_22) AT=680.025n

.meas tran vdout0_23ck1350 FIND v(dout0_23) AT=680.025n

.meas tran vdout0_24ck1350 FIND v(dout0_24) AT=680.025n

.meas tran vdout0_25ck1350 FIND v(dout0_25) AT=680.025n

.meas tran vdout0_26ck1350 FIND v(dout0_26) AT=680.025n

.meas tran vdout0_27ck1350 FIND v(dout0_27) AT=680.025n

.meas tran vdout0_28ck1350 FIND v(dout0_28) AT=680.025n

.meas tran vdout0_29ck1350 FIND v(dout0_29) AT=680.025n

.meas tran vdout0_30ck1350 FIND v(dout0_30) AT=680.025n

.meas tran vdout0_31ck1350 FIND v(dout0_31) AT=680.025n

.meas tran vdout0_0ck1360 FIND v(dout0_0) AT=685.025n

.meas tran vdout0_1ck1360 FIND v(dout0_1) AT=685.025n

.meas tran vdout0_2ck1360 FIND v(dout0_2) AT=685.025n

.meas tran vdout0_3ck1360 FIND v(dout0_3) AT=685.025n

.meas tran vdout0_4ck1360 FIND v(dout0_4) AT=685.025n

.meas tran vdout0_5ck1360 FIND v(dout0_5) AT=685.025n

.meas tran vdout0_6ck1360 FIND v(dout0_6) AT=685.025n

.meas tran vdout0_7ck1360 FIND v(dout0_7) AT=685.025n

.meas tran vdout0_8ck1360 FIND v(dout0_8) AT=685.025n

.meas tran vdout0_9ck1360 FIND v(dout0_9) AT=685.025n

.meas tran vdout0_10ck1360 FIND v(dout0_10) AT=685.025n

.meas tran vdout0_11ck1360 FIND v(dout0_11) AT=685.025n

.meas tran vdout0_12ck1360 FIND v(dout0_12) AT=685.025n

.meas tran vdout0_13ck1360 FIND v(dout0_13) AT=685.025n

.meas tran vdout0_14ck1360 FIND v(dout0_14) AT=685.025n

.meas tran vdout0_15ck1360 FIND v(dout0_15) AT=685.025n

.meas tran vdout0_16ck1360 FIND v(dout0_16) AT=685.025n

.meas tran vdout0_17ck1360 FIND v(dout0_17) AT=685.025n

.meas tran vdout0_18ck1360 FIND v(dout0_18) AT=685.025n

.meas tran vdout0_19ck1360 FIND v(dout0_19) AT=685.025n

.meas tran vdout0_20ck1360 FIND v(dout0_20) AT=685.025n

.meas tran vdout0_21ck1360 FIND v(dout0_21) AT=685.025n

.meas tran vdout0_22ck1360 FIND v(dout0_22) AT=685.025n

.meas tran vdout0_23ck1360 FIND v(dout0_23) AT=685.025n

.meas tran vdout0_24ck1360 FIND v(dout0_24) AT=685.025n

.meas tran vdout0_25ck1360 FIND v(dout0_25) AT=685.025n

.meas tran vdout0_26ck1360 FIND v(dout0_26) AT=685.025n

.meas tran vdout0_27ck1360 FIND v(dout0_27) AT=685.025n

.meas tran vdout0_28ck1360 FIND v(dout0_28) AT=685.025n

.meas tran vdout0_29ck1360 FIND v(dout0_29) AT=685.025n

.meas tran vdout0_30ck1360 FIND v(dout0_30) AT=685.025n

.meas tran vdout0_31ck1360 FIND v(dout0_31) AT=685.025n

.meas tran vdout0_0ck1390 FIND v(dout0_0) AT=700.025n

.meas tran vdout0_1ck1390 FIND v(dout0_1) AT=700.025n

.meas tran vdout0_2ck1390 FIND v(dout0_2) AT=700.025n

.meas tran vdout0_3ck1390 FIND v(dout0_3) AT=700.025n

.meas tran vdout0_4ck1390 FIND v(dout0_4) AT=700.025n

.meas tran vdout0_5ck1390 FIND v(dout0_5) AT=700.025n

.meas tran vdout0_6ck1390 FIND v(dout0_6) AT=700.025n

.meas tran vdout0_7ck1390 FIND v(dout0_7) AT=700.025n

.meas tran vdout0_8ck1390 FIND v(dout0_8) AT=700.025n

.meas tran vdout0_9ck1390 FIND v(dout0_9) AT=700.025n

.meas tran vdout0_10ck1390 FIND v(dout0_10) AT=700.025n

.meas tran vdout0_11ck1390 FIND v(dout0_11) AT=700.025n

.meas tran vdout0_12ck1390 FIND v(dout0_12) AT=700.025n

.meas tran vdout0_13ck1390 FIND v(dout0_13) AT=700.025n

.meas tran vdout0_14ck1390 FIND v(dout0_14) AT=700.025n

.meas tran vdout0_15ck1390 FIND v(dout0_15) AT=700.025n

.meas tran vdout0_16ck1390 FIND v(dout0_16) AT=700.025n

.meas tran vdout0_17ck1390 FIND v(dout0_17) AT=700.025n

.meas tran vdout0_18ck1390 FIND v(dout0_18) AT=700.025n

.meas tran vdout0_19ck1390 FIND v(dout0_19) AT=700.025n

.meas tran vdout0_20ck1390 FIND v(dout0_20) AT=700.025n

.meas tran vdout0_21ck1390 FIND v(dout0_21) AT=700.025n

.meas tran vdout0_22ck1390 FIND v(dout0_22) AT=700.025n

.meas tran vdout0_23ck1390 FIND v(dout0_23) AT=700.025n

.meas tran vdout0_24ck1390 FIND v(dout0_24) AT=700.025n

.meas tran vdout0_25ck1390 FIND v(dout0_25) AT=700.025n

.meas tran vdout0_26ck1390 FIND v(dout0_26) AT=700.025n

.meas tran vdout0_27ck1390 FIND v(dout0_27) AT=700.025n

.meas tran vdout0_28ck1390 FIND v(dout0_28) AT=700.025n

.meas tran vdout0_29ck1390 FIND v(dout0_29) AT=700.025n

.meas tran vdout0_30ck1390 FIND v(dout0_30) AT=700.025n

.meas tran vdout0_31ck1390 FIND v(dout0_31) AT=700.025n

.meas tran vdout0_0ck1400 FIND v(dout0_0) AT=705.025n

.meas tran vdout0_1ck1400 FIND v(dout0_1) AT=705.025n

.meas tran vdout0_2ck1400 FIND v(dout0_2) AT=705.025n

.meas tran vdout0_3ck1400 FIND v(dout0_3) AT=705.025n

.meas tran vdout0_4ck1400 FIND v(dout0_4) AT=705.025n

.meas tran vdout0_5ck1400 FIND v(dout0_5) AT=705.025n

.meas tran vdout0_6ck1400 FIND v(dout0_6) AT=705.025n

.meas tran vdout0_7ck1400 FIND v(dout0_7) AT=705.025n

.meas tran vdout0_8ck1400 FIND v(dout0_8) AT=705.025n

.meas tran vdout0_9ck1400 FIND v(dout0_9) AT=705.025n

.meas tran vdout0_10ck1400 FIND v(dout0_10) AT=705.025n

.meas tran vdout0_11ck1400 FIND v(dout0_11) AT=705.025n

.meas tran vdout0_12ck1400 FIND v(dout0_12) AT=705.025n

.meas tran vdout0_13ck1400 FIND v(dout0_13) AT=705.025n

.meas tran vdout0_14ck1400 FIND v(dout0_14) AT=705.025n

.meas tran vdout0_15ck1400 FIND v(dout0_15) AT=705.025n

.meas tran vdout0_16ck1400 FIND v(dout0_16) AT=705.025n

.meas tran vdout0_17ck1400 FIND v(dout0_17) AT=705.025n

.meas tran vdout0_18ck1400 FIND v(dout0_18) AT=705.025n

.meas tran vdout0_19ck1400 FIND v(dout0_19) AT=705.025n

.meas tran vdout0_20ck1400 FIND v(dout0_20) AT=705.025n

.meas tran vdout0_21ck1400 FIND v(dout0_21) AT=705.025n

.meas tran vdout0_22ck1400 FIND v(dout0_22) AT=705.025n

.meas tran vdout0_23ck1400 FIND v(dout0_23) AT=705.025n

.meas tran vdout0_24ck1400 FIND v(dout0_24) AT=705.025n

.meas tran vdout0_25ck1400 FIND v(dout0_25) AT=705.025n

.meas tran vdout0_26ck1400 FIND v(dout0_26) AT=705.025n

.meas tran vdout0_27ck1400 FIND v(dout0_27) AT=705.025n

.meas tran vdout0_28ck1400 FIND v(dout0_28) AT=705.025n

.meas tran vdout0_29ck1400 FIND v(dout0_29) AT=705.025n

.meas tran vdout0_30ck1400 FIND v(dout0_30) AT=705.025n

.meas tran vdout0_31ck1400 FIND v(dout0_31) AT=705.025n

.meas tran vdout0_0ck1420 FIND v(dout0_0) AT=715.025n

.meas tran vdout0_1ck1420 FIND v(dout0_1) AT=715.025n

.meas tran vdout0_2ck1420 FIND v(dout0_2) AT=715.025n

.meas tran vdout0_3ck1420 FIND v(dout0_3) AT=715.025n

.meas tran vdout0_4ck1420 FIND v(dout0_4) AT=715.025n

.meas tran vdout0_5ck1420 FIND v(dout0_5) AT=715.025n

.meas tran vdout0_6ck1420 FIND v(dout0_6) AT=715.025n

.meas tran vdout0_7ck1420 FIND v(dout0_7) AT=715.025n

.meas tran vdout0_8ck1420 FIND v(dout0_8) AT=715.025n

.meas tran vdout0_9ck1420 FIND v(dout0_9) AT=715.025n

.meas tran vdout0_10ck1420 FIND v(dout0_10) AT=715.025n

.meas tran vdout0_11ck1420 FIND v(dout0_11) AT=715.025n

.meas tran vdout0_12ck1420 FIND v(dout0_12) AT=715.025n

.meas tran vdout0_13ck1420 FIND v(dout0_13) AT=715.025n

.meas tran vdout0_14ck1420 FIND v(dout0_14) AT=715.025n

.meas tran vdout0_15ck1420 FIND v(dout0_15) AT=715.025n

.meas tran vdout0_16ck1420 FIND v(dout0_16) AT=715.025n

.meas tran vdout0_17ck1420 FIND v(dout0_17) AT=715.025n

.meas tran vdout0_18ck1420 FIND v(dout0_18) AT=715.025n

.meas tran vdout0_19ck1420 FIND v(dout0_19) AT=715.025n

.meas tran vdout0_20ck1420 FIND v(dout0_20) AT=715.025n

.meas tran vdout0_21ck1420 FIND v(dout0_21) AT=715.025n

.meas tran vdout0_22ck1420 FIND v(dout0_22) AT=715.025n

.meas tran vdout0_23ck1420 FIND v(dout0_23) AT=715.025n

.meas tran vdout0_24ck1420 FIND v(dout0_24) AT=715.025n

.meas tran vdout0_25ck1420 FIND v(dout0_25) AT=715.025n

.meas tran vdout0_26ck1420 FIND v(dout0_26) AT=715.025n

.meas tran vdout0_27ck1420 FIND v(dout0_27) AT=715.025n

.meas tran vdout0_28ck1420 FIND v(dout0_28) AT=715.025n

.meas tran vdout0_29ck1420 FIND v(dout0_29) AT=715.025n

.meas tran vdout0_30ck1420 FIND v(dout0_30) AT=715.025n

.meas tran vdout0_31ck1420 FIND v(dout0_31) AT=715.025n

.meas tran vdout0_0ck1450 FIND v(dout0_0) AT=730.025n

.meas tran vdout0_1ck1450 FIND v(dout0_1) AT=730.025n

.meas tran vdout0_2ck1450 FIND v(dout0_2) AT=730.025n

.meas tran vdout0_3ck1450 FIND v(dout0_3) AT=730.025n

.meas tran vdout0_4ck1450 FIND v(dout0_4) AT=730.025n

.meas tran vdout0_5ck1450 FIND v(dout0_5) AT=730.025n

.meas tran vdout0_6ck1450 FIND v(dout0_6) AT=730.025n

.meas tran vdout0_7ck1450 FIND v(dout0_7) AT=730.025n

.meas tran vdout0_8ck1450 FIND v(dout0_8) AT=730.025n

.meas tran vdout0_9ck1450 FIND v(dout0_9) AT=730.025n

.meas tran vdout0_10ck1450 FIND v(dout0_10) AT=730.025n

.meas tran vdout0_11ck1450 FIND v(dout0_11) AT=730.025n

.meas tran vdout0_12ck1450 FIND v(dout0_12) AT=730.025n

.meas tran vdout0_13ck1450 FIND v(dout0_13) AT=730.025n

.meas tran vdout0_14ck1450 FIND v(dout0_14) AT=730.025n

.meas tran vdout0_15ck1450 FIND v(dout0_15) AT=730.025n

.meas tran vdout0_16ck1450 FIND v(dout0_16) AT=730.025n

.meas tran vdout0_17ck1450 FIND v(dout0_17) AT=730.025n

.meas tran vdout0_18ck1450 FIND v(dout0_18) AT=730.025n

.meas tran vdout0_19ck1450 FIND v(dout0_19) AT=730.025n

.meas tran vdout0_20ck1450 FIND v(dout0_20) AT=730.025n

.meas tran vdout0_21ck1450 FIND v(dout0_21) AT=730.025n

.meas tran vdout0_22ck1450 FIND v(dout0_22) AT=730.025n

.meas tran vdout0_23ck1450 FIND v(dout0_23) AT=730.025n

.meas tran vdout0_24ck1450 FIND v(dout0_24) AT=730.025n

.meas tran vdout0_25ck1450 FIND v(dout0_25) AT=730.025n

.meas tran vdout0_26ck1450 FIND v(dout0_26) AT=730.025n

.meas tran vdout0_27ck1450 FIND v(dout0_27) AT=730.025n

.meas tran vdout0_28ck1450 FIND v(dout0_28) AT=730.025n

.meas tran vdout0_29ck1450 FIND v(dout0_29) AT=730.025n

.meas tran vdout0_30ck1450 FIND v(dout0_30) AT=730.025n

.meas tran vdout0_31ck1450 FIND v(dout0_31) AT=730.025n

.meas tran vdout0_0ck1470 FIND v(dout0_0) AT=740.025n

.meas tran vdout0_1ck1470 FIND v(dout0_1) AT=740.025n

.meas tran vdout0_2ck1470 FIND v(dout0_2) AT=740.025n

.meas tran vdout0_3ck1470 FIND v(dout0_3) AT=740.025n

.meas tran vdout0_4ck1470 FIND v(dout0_4) AT=740.025n

.meas tran vdout0_5ck1470 FIND v(dout0_5) AT=740.025n

.meas tran vdout0_6ck1470 FIND v(dout0_6) AT=740.025n

.meas tran vdout0_7ck1470 FIND v(dout0_7) AT=740.025n

.meas tran vdout0_8ck1470 FIND v(dout0_8) AT=740.025n

.meas tran vdout0_9ck1470 FIND v(dout0_9) AT=740.025n

.meas tran vdout0_10ck1470 FIND v(dout0_10) AT=740.025n

.meas tran vdout0_11ck1470 FIND v(dout0_11) AT=740.025n

.meas tran vdout0_12ck1470 FIND v(dout0_12) AT=740.025n

.meas tran vdout0_13ck1470 FIND v(dout0_13) AT=740.025n

.meas tran vdout0_14ck1470 FIND v(dout0_14) AT=740.025n

.meas tran vdout0_15ck1470 FIND v(dout0_15) AT=740.025n

.meas tran vdout0_16ck1470 FIND v(dout0_16) AT=740.025n

.meas tran vdout0_17ck1470 FIND v(dout0_17) AT=740.025n

.meas tran vdout0_18ck1470 FIND v(dout0_18) AT=740.025n

.meas tran vdout0_19ck1470 FIND v(dout0_19) AT=740.025n

.meas tran vdout0_20ck1470 FIND v(dout0_20) AT=740.025n

.meas tran vdout0_21ck1470 FIND v(dout0_21) AT=740.025n

.meas tran vdout0_22ck1470 FIND v(dout0_22) AT=740.025n

.meas tran vdout0_23ck1470 FIND v(dout0_23) AT=740.025n

.meas tran vdout0_24ck1470 FIND v(dout0_24) AT=740.025n

.meas tran vdout0_25ck1470 FIND v(dout0_25) AT=740.025n

.meas tran vdout0_26ck1470 FIND v(dout0_26) AT=740.025n

.meas tran vdout0_27ck1470 FIND v(dout0_27) AT=740.025n

.meas tran vdout0_28ck1470 FIND v(dout0_28) AT=740.025n

.meas tran vdout0_29ck1470 FIND v(dout0_29) AT=740.025n

.meas tran vdout0_30ck1470 FIND v(dout0_30) AT=740.025n

.meas tran vdout0_31ck1470 FIND v(dout0_31) AT=740.025n

.meas tran vdout0_0ck1480 FIND v(dout0_0) AT=745.025n

.meas tran vdout0_1ck1480 FIND v(dout0_1) AT=745.025n

.meas tran vdout0_2ck1480 FIND v(dout0_2) AT=745.025n

.meas tran vdout0_3ck1480 FIND v(dout0_3) AT=745.025n

.meas tran vdout0_4ck1480 FIND v(dout0_4) AT=745.025n

.meas tran vdout0_5ck1480 FIND v(dout0_5) AT=745.025n

.meas tran vdout0_6ck1480 FIND v(dout0_6) AT=745.025n

.meas tran vdout0_7ck1480 FIND v(dout0_7) AT=745.025n

.meas tran vdout0_8ck1480 FIND v(dout0_8) AT=745.025n

.meas tran vdout0_9ck1480 FIND v(dout0_9) AT=745.025n

.meas tran vdout0_10ck1480 FIND v(dout0_10) AT=745.025n

.meas tran vdout0_11ck1480 FIND v(dout0_11) AT=745.025n

.meas tran vdout0_12ck1480 FIND v(dout0_12) AT=745.025n

.meas tran vdout0_13ck1480 FIND v(dout0_13) AT=745.025n

.meas tran vdout0_14ck1480 FIND v(dout0_14) AT=745.025n

.meas tran vdout0_15ck1480 FIND v(dout0_15) AT=745.025n

.meas tran vdout0_16ck1480 FIND v(dout0_16) AT=745.025n

.meas tran vdout0_17ck1480 FIND v(dout0_17) AT=745.025n

.meas tran vdout0_18ck1480 FIND v(dout0_18) AT=745.025n

.meas tran vdout0_19ck1480 FIND v(dout0_19) AT=745.025n

.meas tran vdout0_20ck1480 FIND v(dout0_20) AT=745.025n

.meas tran vdout0_21ck1480 FIND v(dout0_21) AT=745.025n

.meas tran vdout0_22ck1480 FIND v(dout0_22) AT=745.025n

.meas tran vdout0_23ck1480 FIND v(dout0_23) AT=745.025n

.meas tran vdout0_24ck1480 FIND v(dout0_24) AT=745.025n

.meas tran vdout0_25ck1480 FIND v(dout0_25) AT=745.025n

.meas tran vdout0_26ck1480 FIND v(dout0_26) AT=745.025n

.meas tran vdout0_27ck1480 FIND v(dout0_27) AT=745.025n

.meas tran vdout0_28ck1480 FIND v(dout0_28) AT=745.025n

.meas tran vdout0_29ck1480 FIND v(dout0_29) AT=745.025n

.meas tran vdout0_30ck1480 FIND v(dout0_30) AT=745.025n

.meas tran vdout0_31ck1480 FIND v(dout0_31) AT=745.025n

.meas tran vdout0_0ck1500 FIND v(dout0_0) AT=755.025n

.meas tran vdout0_1ck1500 FIND v(dout0_1) AT=755.025n

.meas tran vdout0_2ck1500 FIND v(dout0_2) AT=755.025n

.meas tran vdout0_3ck1500 FIND v(dout0_3) AT=755.025n

.meas tran vdout0_4ck1500 FIND v(dout0_4) AT=755.025n

.meas tran vdout0_5ck1500 FIND v(dout0_5) AT=755.025n

.meas tran vdout0_6ck1500 FIND v(dout0_6) AT=755.025n

.meas tran vdout0_7ck1500 FIND v(dout0_7) AT=755.025n

.meas tran vdout0_8ck1500 FIND v(dout0_8) AT=755.025n

.meas tran vdout0_9ck1500 FIND v(dout0_9) AT=755.025n

.meas tran vdout0_10ck1500 FIND v(dout0_10) AT=755.025n

.meas tran vdout0_11ck1500 FIND v(dout0_11) AT=755.025n

.meas tran vdout0_12ck1500 FIND v(dout0_12) AT=755.025n

.meas tran vdout0_13ck1500 FIND v(dout0_13) AT=755.025n

.meas tran vdout0_14ck1500 FIND v(dout0_14) AT=755.025n

.meas tran vdout0_15ck1500 FIND v(dout0_15) AT=755.025n

.meas tran vdout0_16ck1500 FIND v(dout0_16) AT=755.025n

.meas tran vdout0_17ck1500 FIND v(dout0_17) AT=755.025n

.meas tran vdout0_18ck1500 FIND v(dout0_18) AT=755.025n

.meas tran vdout0_19ck1500 FIND v(dout0_19) AT=755.025n

.meas tran vdout0_20ck1500 FIND v(dout0_20) AT=755.025n

.meas tran vdout0_21ck1500 FIND v(dout0_21) AT=755.025n

.meas tran vdout0_22ck1500 FIND v(dout0_22) AT=755.025n

.meas tran vdout0_23ck1500 FIND v(dout0_23) AT=755.025n

.meas tran vdout0_24ck1500 FIND v(dout0_24) AT=755.025n

.meas tran vdout0_25ck1500 FIND v(dout0_25) AT=755.025n

.meas tran vdout0_26ck1500 FIND v(dout0_26) AT=755.025n

.meas tran vdout0_27ck1500 FIND v(dout0_27) AT=755.025n

.meas tran vdout0_28ck1500 FIND v(dout0_28) AT=755.025n

.meas tran vdout0_29ck1500 FIND v(dout0_29) AT=755.025n

.meas tran vdout0_30ck1500 FIND v(dout0_30) AT=755.025n

.meas tran vdout0_31ck1500 FIND v(dout0_31) AT=755.025n

.meas tran vdout0_0ck1520 FIND v(dout0_0) AT=765.025n

.meas tran vdout0_1ck1520 FIND v(dout0_1) AT=765.025n

.meas tran vdout0_2ck1520 FIND v(dout0_2) AT=765.025n

.meas tran vdout0_3ck1520 FIND v(dout0_3) AT=765.025n

.meas tran vdout0_4ck1520 FIND v(dout0_4) AT=765.025n

.meas tran vdout0_5ck1520 FIND v(dout0_5) AT=765.025n

.meas tran vdout0_6ck1520 FIND v(dout0_6) AT=765.025n

.meas tran vdout0_7ck1520 FIND v(dout0_7) AT=765.025n

.meas tran vdout0_8ck1520 FIND v(dout0_8) AT=765.025n

.meas tran vdout0_9ck1520 FIND v(dout0_9) AT=765.025n

.meas tran vdout0_10ck1520 FIND v(dout0_10) AT=765.025n

.meas tran vdout0_11ck1520 FIND v(dout0_11) AT=765.025n

.meas tran vdout0_12ck1520 FIND v(dout0_12) AT=765.025n

.meas tran vdout0_13ck1520 FIND v(dout0_13) AT=765.025n

.meas tran vdout0_14ck1520 FIND v(dout0_14) AT=765.025n

.meas tran vdout0_15ck1520 FIND v(dout0_15) AT=765.025n

.meas tran vdout0_16ck1520 FIND v(dout0_16) AT=765.025n

.meas tran vdout0_17ck1520 FIND v(dout0_17) AT=765.025n

.meas tran vdout0_18ck1520 FIND v(dout0_18) AT=765.025n

.meas tran vdout0_19ck1520 FIND v(dout0_19) AT=765.025n

.meas tran vdout0_20ck1520 FIND v(dout0_20) AT=765.025n

.meas tran vdout0_21ck1520 FIND v(dout0_21) AT=765.025n

.meas tran vdout0_22ck1520 FIND v(dout0_22) AT=765.025n

.meas tran vdout0_23ck1520 FIND v(dout0_23) AT=765.025n

.meas tran vdout0_24ck1520 FIND v(dout0_24) AT=765.025n

.meas tran vdout0_25ck1520 FIND v(dout0_25) AT=765.025n

.meas tran vdout0_26ck1520 FIND v(dout0_26) AT=765.025n

.meas tran vdout0_27ck1520 FIND v(dout0_27) AT=765.025n

.meas tran vdout0_28ck1520 FIND v(dout0_28) AT=765.025n

.meas tran vdout0_29ck1520 FIND v(dout0_29) AT=765.025n

.meas tran vdout0_30ck1520 FIND v(dout0_30) AT=765.025n

.meas tran vdout0_31ck1520 FIND v(dout0_31) AT=765.025n

.meas tran vdout0_0ck1530 FIND v(dout0_0) AT=770.025n

.meas tran vdout0_1ck1530 FIND v(dout0_1) AT=770.025n

.meas tran vdout0_2ck1530 FIND v(dout0_2) AT=770.025n

.meas tran vdout0_3ck1530 FIND v(dout0_3) AT=770.025n

.meas tran vdout0_4ck1530 FIND v(dout0_4) AT=770.025n

.meas tran vdout0_5ck1530 FIND v(dout0_5) AT=770.025n

.meas tran vdout0_6ck1530 FIND v(dout0_6) AT=770.025n

.meas tran vdout0_7ck1530 FIND v(dout0_7) AT=770.025n

.meas tran vdout0_8ck1530 FIND v(dout0_8) AT=770.025n

.meas tran vdout0_9ck1530 FIND v(dout0_9) AT=770.025n

.meas tran vdout0_10ck1530 FIND v(dout0_10) AT=770.025n

.meas tran vdout0_11ck1530 FIND v(dout0_11) AT=770.025n

.meas tran vdout0_12ck1530 FIND v(dout0_12) AT=770.025n

.meas tran vdout0_13ck1530 FIND v(dout0_13) AT=770.025n

.meas tran vdout0_14ck1530 FIND v(dout0_14) AT=770.025n

.meas tran vdout0_15ck1530 FIND v(dout0_15) AT=770.025n

.meas tran vdout0_16ck1530 FIND v(dout0_16) AT=770.025n

.meas tran vdout0_17ck1530 FIND v(dout0_17) AT=770.025n

.meas tran vdout0_18ck1530 FIND v(dout0_18) AT=770.025n

.meas tran vdout0_19ck1530 FIND v(dout0_19) AT=770.025n

.meas tran vdout0_20ck1530 FIND v(dout0_20) AT=770.025n

.meas tran vdout0_21ck1530 FIND v(dout0_21) AT=770.025n

.meas tran vdout0_22ck1530 FIND v(dout0_22) AT=770.025n

.meas tran vdout0_23ck1530 FIND v(dout0_23) AT=770.025n

.meas tran vdout0_24ck1530 FIND v(dout0_24) AT=770.025n

.meas tran vdout0_25ck1530 FIND v(dout0_25) AT=770.025n

.meas tran vdout0_26ck1530 FIND v(dout0_26) AT=770.025n

.meas tran vdout0_27ck1530 FIND v(dout0_27) AT=770.025n

.meas tran vdout0_28ck1530 FIND v(dout0_28) AT=770.025n

.meas tran vdout0_29ck1530 FIND v(dout0_29) AT=770.025n

.meas tran vdout0_30ck1530 FIND v(dout0_30) AT=770.025n

.meas tran vdout0_31ck1530 FIND v(dout0_31) AT=770.025n

.meas tran vdout0_0ck1550 FIND v(dout0_0) AT=780.025n

.meas tran vdout0_1ck1550 FIND v(dout0_1) AT=780.025n

.meas tran vdout0_2ck1550 FIND v(dout0_2) AT=780.025n

.meas tran vdout0_3ck1550 FIND v(dout0_3) AT=780.025n

.meas tran vdout0_4ck1550 FIND v(dout0_4) AT=780.025n

.meas tran vdout0_5ck1550 FIND v(dout0_5) AT=780.025n

.meas tran vdout0_6ck1550 FIND v(dout0_6) AT=780.025n

.meas tran vdout0_7ck1550 FIND v(dout0_7) AT=780.025n

.meas tran vdout0_8ck1550 FIND v(dout0_8) AT=780.025n

.meas tran vdout0_9ck1550 FIND v(dout0_9) AT=780.025n

.meas tran vdout0_10ck1550 FIND v(dout0_10) AT=780.025n

.meas tran vdout0_11ck1550 FIND v(dout0_11) AT=780.025n

.meas tran vdout0_12ck1550 FIND v(dout0_12) AT=780.025n

.meas tran vdout0_13ck1550 FIND v(dout0_13) AT=780.025n

.meas tran vdout0_14ck1550 FIND v(dout0_14) AT=780.025n

.meas tran vdout0_15ck1550 FIND v(dout0_15) AT=780.025n

.meas tran vdout0_16ck1550 FIND v(dout0_16) AT=780.025n

.meas tran vdout0_17ck1550 FIND v(dout0_17) AT=780.025n

.meas tran vdout0_18ck1550 FIND v(dout0_18) AT=780.025n

.meas tran vdout0_19ck1550 FIND v(dout0_19) AT=780.025n

.meas tran vdout0_20ck1550 FIND v(dout0_20) AT=780.025n

.meas tran vdout0_21ck1550 FIND v(dout0_21) AT=780.025n

.meas tran vdout0_22ck1550 FIND v(dout0_22) AT=780.025n

.meas tran vdout0_23ck1550 FIND v(dout0_23) AT=780.025n

.meas tran vdout0_24ck1550 FIND v(dout0_24) AT=780.025n

.meas tran vdout0_25ck1550 FIND v(dout0_25) AT=780.025n

.meas tran vdout0_26ck1550 FIND v(dout0_26) AT=780.025n

.meas tran vdout0_27ck1550 FIND v(dout0_27) AT=780.025n

.meas tran vdout0_28ck1550 FIND v(dout0_28) AT=780.025n

.meas tran vdout0_29ck1550 FIND v(dout0_29) AT=780.025n

.meas tran vdout0_30ck1550 FIND v(dout0_30) AT=780.025n

.meas tran vdout0_31ck1550 FIND v(dout0_31) AT=780.025n

.meas tran vdout0_0ck1560 FIND v(dout0_0) AT=785.025n

.meas tran vdout0_1ck1560 FIND v(dout0_1) AT=785.025n

.meas tran vdout0_2ck1560 FIND v(dout0_2) AT=785.025n

.meas tran vdout0_3ck1560 FIND v(dout0_3) AT=785.025n

.meas tran vdout0_4ck1560 FIND v(dout0_4) AT=785.025n

.meas tran vdout0_5ck1560 FIND v(dout0_5) AT=785.025n

.meas tran vdout0_6ck1560 FIND v(dout0_6) AT=785.025n

.meas tran vdout0_7ck1560 FIND v(dout0_7) AT=785.025n

.meas tran vdout0_8ck1560 FIND v(dout0_8) AT=785.025n

.meas tran vdout0_9ck1560 FIND v(dout0_9) AT=785.025n

.meas tran vdout0_10ck1560 FIND v(dout0_10) AT=785.025n

.meas tran vdout0_11ck1560 FIND v(dout0_11) AT=785.025n

.meas tran vdout0_12ck1560 FIND v(dout0_12) AT=785.025n

.meas tran vdout0_13ck1560 FIND v(dout0_13) AT=785.025n

.meas tran vdout0_14ck1560 FIND v(dout0_14) AT=785.025n

.meas tran vdout0_15ck1560 FIND v(dout0_15) AT=785.025n

.meas tran vdout0_16ck1560 FIND v(dout0_16) AT=785.025n

.meas tran vdout0_17ck1560 FIND v(dout0_17) AT=785.025n

.meas tran vdout0_18ck1560 FIND v(dout0_18) AT=785.025n

.meas tran vdout0_19ck1560 FIND v(dout0_19) AT=785.025n

.meas tran vdout0_20ck1560 FIND v(dout0_20) AT=785.025n

.meas tran vdout0_21ck1560 FIND v(dout0_21) AT=785.025n

.meas tran vdout0_22ck1560 FIND v(dout0_22) AT=785.025n

.meas tran vdout0_23ck1560 FIND v(dout0_23) AT=785.025n

.meas tran vdout0_24ck1560 FIND v(dout0_24) AT=785.025n

.meas tran vdout0_25ck1560 FIND v(dout0_25) AT=785.025n

.meas tran vdout0_26ck1560 FIND v(dout0_26) AT=785.025n

.meas tran vdout0_27ck1560 FIND v(dout0_27) AT=785.025n

.meas tran vdout0_28ck1560 FIND v(dout0_28) AT=785.025n

.meas tran vdout0_29ck1560 FIND v(dout0_29) AT=785.025n

.meas tran vdout0_30ck1560 FIND v(dout0_30) AT=785.025n

.meas tran vdout0_31ck1560 FIND v(dout0_31) AT=785.025n

.meas tran vdout0_0ck1570 FIND v(dout0_0) AT=790.025n

.meas tran vdout0_1ck1570 FIND v(dout0_1) AT=790.025n

.meas tran vdout0_2ck1570 FIND v(dout0_2) AT=790.025n

.meas tran vdout0_3ck1570 FIND v(dout0_3) AT=790.025n

.meas tran vdout0_4ck1570 FIND v(dout0_4) AT=790.025n

.meas tran vdout0_5ck1570 FIND v(dout0_5) AT=790.025n

.meas tran vdout0_6ck1570 FIND v(dout0_6) AT=790.025n

.meas tran vdout0_7ck1570 FIND v(dout0_7) AT=790.025n

.meas tran vdout0_8ck1570 FIND v(dout0_8) AT=790.025n

.meas tran vdout0_9ck1570 FIND v(dout0_9) AT=790.025n

.meas tran vdout0_10ck1570 FIND v(dout0_10) AT=790.025n

.meas tran vdout0_11ck1570 FIND v(dout0_11) AT=790.025n

.meas tran vdout0_12ck1570 FIND v(dout0_12) AT=790.025n

.meas tran vdout0_13ck1570 FIND v(dout0_13) AT=790.025n

.meas tran vdout0_14ck1570 FIND v(dout0_14) AT=790.025n

.meas tran vdout0_15ck1570 FIND v(dout0_15) AT=790.025n

.meas tran vdout0_16ck1570 FIND v(dout0_16) AT=790.025n

.meas tran vdout0_17ck1570 FIND v(dout0_17) AT=790.025n

.meas tran vdout0_18ck1570 FIND v(dout0_18) AT=790.025n

.meas tran vdout0_19ck1570 FIND v(dout0_19) AT=790.025n

.meas tran vdout0_20ck1570 FIND v(dout0_20) AT=790.025n

.meas tran vdout0_21ck1570 FIND v(dout0_21) AT=790.025n

.meas tran vdout0_22ck1570 FIND v(dout0_22) AT=790.025n

.meas tran vdout0_23ck1570 FIND v(dout0_23) AT=790.025n

.meas tran vdout0_24ck1570 FIND v(dout0_24) AT=790.025n

.meas tran vdout0_25ck1570 FIND v(dout0_25) AT=790.025n

.meas tran vdout0_26ck1570 FIND v(dout0_26) AT=790.025n

.meas tran vdout0_27ck1570 FIND v(dout0_27) AT=790.025n

.meas tran vdout0_28ck1570 FIND v(dout0_28) AT=790.025n

.meas tran vdout0_29ck1570 FIND v(dout0_29) AT=790.025n

.meas tran vdout0_30ck1570 FIND v(dout0_30) AT=790.025n

.meas tran vdout0_31ck1570 FIND v(dout0_31) AT=790.025n

.meas tran vdout0_0ck1590 FIND v(dout0_0) AT=800.025n

.meas tran vdout0_1ck1590 FIND v(dout0_1) AT=800.025n

.meas tran vdout0_2ck1590 FIND v(dout0_2) AT=800.025n

.meas tran vdout0_3ck1590 FIND v(dout0_3) AT=800.025n

.meas tran vdout0_4ck1590 FIND v(dout0_4) AT=800.025n

.meas tran vdout0_5ck1590 FIND v(dout0_5) AT=800.025n

.meas tran vdout0_6ck1590 FIND v(dout0_6) AT=800.025n

.meas tran vdout0_7ck1590 FIND v(dout0_7) AT=800.025n

.meas tran vdout0_8ck1590 FIND v(dout0_8) AT=800.025n

.meas tran vdout0_9ck1590 FIND v(dout0_9) AT=800.025n

.meas tran vdout0_10ck1590 FIND v(dout0_10) AT=800.025n

.meas tran vdout0_11ck1590 FIND v(dout0_11) AT=800.025n

.meas tran vdout0_12ck1590 FIND v(dout0_12) AT=800.025n

.meas tran vdout0_13ck1590 FIND v(dout0_13) AT=800.025n

.meas tran vdout0_14ck1590 FIND v(dout0_14) AT=800.025n

.meas tran vdout0_15ck1590 FIND v(dout0_15) AT=800.025n

.meas tran vdout0_16ck1590 FIND v(dout0_16) AT=800.025n

.meas tran vdout0_17ck1590 FIND v(dout0_17) AT=800.025n

.meas tran vdout0_18ck1590 FIND v(dout0_18) AT=800.025n

.meas tran vdout0_19ck1590 FIND v(dout0_19) AT=800.025n

.meas tran vdout0_20ck1590 FIND v(dout0_20) AT=800.025n

.meas tran vdout0_21ck1590 FIND v(dout0_21) AT=800.025n

.meas tran vdout0_22ck1590 FIND v(dout0_22) AT=800.025n

.meas tran vdout0_23ck1590 FIND v(dout0_23) AT=800.025n

.meas tran vdout0_24ck1590 FIND v(dout0_24) AT=800.025n

.meas tran vdout0_25ck1590 FIND v(dout0_25) AT=800.025n

.meas tran vdout0_26ck1590 FIND v(dout0_26) AT=800.025n

.meas tran vdout0_27ck1590 FIND v(dout0_27) AT=800.025n

.meas tran vdout0_28ck1590 FIND v(dout0_28) AT=800.025n

.meas tran vdout0_29ck1590 FIND v(dout0_29) AT=800.025n

.meas tran vdout0_30ck1590 FIND v(dout0_30) AT=800.025n

.meas tran vdout0_31ck1590 FIND v(dout0_31) AT=800.025n

.meas tran vdout0_0ck1600 FIND v(dout0_0) AT=805.025n

.meas tran vdout0_1ck1600 FIND v(dout0_1) AT=805.025n

.meas tran vdout0_2ck1600 FIND v(dout0_2) AT=805.025n

.meas tran vdout0_3ck1600 FIND v(dout0_3) AT=805.025n

.meas tran vdout0_4ck1600 FIND v(dout0_4) AT=805.025n

.meas tran vdout0_5ck1600 FIND v(dout0_5) AT=805.025n

.meas tran vdout0_6ck1600 FIND v(dout0_6) AT=805.025n

.meas tran vdout0_7ck1600 FIND v(dout0_7) AT=805.025n

.meas tran vdout0_8ck1600 FIND v(dout0_8) AT=805.025n

.meas tran vdout0_9ck1600 FIND v(dout0_9) AT=805.025n

.meas tran vdout0_10ck1600 FIND v(dout0_10) AT=805.025n

.meas tran vdout0_11ck1600 FIND v(dout0_11) AT=805.025n

.meas tran vdout0_12ck1600 FIND v(dout0_12) AT=805.025n

.meas tran vdout0_13ck1600 FIND v(dout0_13) AT=805.025n

.meas tran vdout0_14ck1600 FIND v(dout0_14) AT=805.025n

.meas tran vdout0_15ck1600 FIND v(dout0_15) AT=805.025n

.meas tran vdout0_16ck1600 FIND v(dout0_16) AT=805.025n

.meas tran vdout0_17ck1600 FIND v(dout0_17) AT=805.025n

.meas tran vdout0_18ck1600 FIND v(dout0_18) AT=805.025n

.meas tran vdout0_19ck1600 FIND v(dout0_19) AT=805.025n

.meas tran vdout0_20ck1600 FIND v(dout0_20) AT=805.025n

.meas tran vdout0_21ck1600 FIND v(dout0_21) AT=805.025n

.meas tran vdout0_22ck1600 FIND v(dout0_22) AT=805.025n

.meas tran vdout0_23ck1600 FIND v(dout0_23) AT=805.025n

.meas tran vdout0_24ck1600 FIND v(dout0_24) AT=805.025n

.meas tran vdout0_25ck1600 FIND v(dout0_25) AT=805.025n

.meas tran vdout0_26ck1600 FIND v(dout0_26) AT=805.025n

.meas tran vdout0_27ck1600 FIND v(dout0_27) AT=805.025n

.meas tran vdout0_28ck1600 FIND v(dout0_28) AT=805.025n

.meas tran vdout0_29ck1600 FIND v(dout0_29) AT=805.025n

.meas tran vdout0_30ck1600 FIND v(dout0_30) AT=805.025n

.meas tran vdout0_31ck1600 FIND v(dout0_31) AT=805.025n

.meas tran vdout0_0ck1620 FIND v(dout0_0) AT=815.025n

.meas tran vdout0_1ck1620 FIND v(dout0_1) AT=815.025n

.meas tran vdout0_2ck1620 FIND v(dout0_2) AT=815.025n

.meas tran vdout0_3ck1620 FIND v(dout0_3) AT=815.025n

.meas tran vdout0_4ck1620 FIND v(dout0_4) AT=815.025n

.meas tran vdout0_5ck1620 FIND v(dout0_5) AT=815.025n

.meas tran vdout0_6ck1620 FIND v(dout0_6) AT=815.025n

.meas tran vdout0_7ck1620 FIND v(dout0_7) AT=815.025n

.meas tran vdout0_8ck1620 FIND v(dout0_8) AT=815.025n

.meas tran vdout0_9ck1620 FIND v(dout0_9) AT=815.025n

.meas tran vdout0_10ck1620 FIND v(dout0_10) AT=815.025n

.meas tran vdout0_11ck1620 FIND v(dout0_11) AT=815.025n

.meas tran vdout0_12ck1620 FIND v(dout0_12) AT=815.025n

.meas tran vdout0_13ck1620 FIND v(dout0_13) AT=815.025n

.meas tran vdout0_14ck1620 FIND v(dout0_14) AT=815.025n

.meas tran vdout0_15ck1620 FIND v(dout0_15) AT=815.025n

.meas tran vdout0_16ck1620 FIND v(dout0_16) AT=815.025n

.meas tran vdout0_17ck1620 FIND v(dout0_17) AT=815.025n

.meas tran vdout0_18ck1620 FIND v(dout0_18) AT=815.025n

.meas tran vdout0_19ck1620 FIND v(dout0_19) AT=815.025n

.meas tran vdout0_20ck1620 FIND v(dout0_20) AT=815.025n

.meas tran vdout0_21ck1620 FIND v(dout0_21) AT=815.025n

.meas tran vdout0_22ck1620 FIND v(dout0_22) AT=815.025n

.meas tran vdout0_23ck1620 FIND v(dout0_23) AT=815.025n

.meas tran vdout0_24ck1620 FIND v(dout0_24) AT=815.025n

.meas tran vdout0_25ck1620 FIND v(dout0_25) AT=815.025n

.meas tran vdout0_26ck1620 FIND v(dout0_26) AT=815.025n

.meas tran vdout0_27ck1620 FIND v(dout0_27) AT=815.025n

.meas tran vdout0_28ck1620 FIND v(dout0_28) AT=815.025n

.meas tran vdout0_29ck1620 FIND v(dout0_29) AT=815.025n

.meas tran vdout0_30ck1620 FIND v(dout0_30) AT=815.025n

.meas tran vdout0_31ck1620 FIND v(dout0_31) AT=815.025n

.meas tran vdout0_0ck1630 FIND v(dout0_0) AT=820.025n

.meas tran vdout0_1ck1630 FIND v(dout0_1) AT=820.025n

.meas tran vdout0_2ck1630 FIND v(dout0_2) AT=820.025n

.meas tran vdout0_3ck1630 FIND v(dout0_3) AT=820.025n

.meas tran vdout0_4ck1630 FIND v(dout0_4) AT=820.025n

.meas tran vdout0_5ck1630 FIND v(dout0_5) AT=820.025n

.meas tran vdout0_6ck1630 FIND v(dout0_6) AT=820.025n

.meas tran vdout0_7ck1630 FIND v(dout0_7) AT=820.025n

.meas tran vdout0_8ck1630 FIND v(dout0_8) AT=820.025n

.meas tran vdout0_9ck1630 FIND v(dout0_9) AT=820.025n

.meas tran vdout0_10ck1630 FIND v(dout0_10) AT=820.025n

.meas tran vdout0_11ck1630 FIND v(dout0_11) AT=820.025n

.meas tran vdout0_12ck1630 FIND v(dout0_12) AT=820.025n

.meas tran vdout0_13ck1630 FIND v(dout0_13) AT=820.025n

.meas tran vdout0_14ck1630 FIND v(dout0_14) AT=820.025n

.meas tran vdout0_15ck1630 FIND v(dout0_15) AT=820.025n

.meas tran vdout0_16ck1630 FIND v(dout0_16) AT=820.025n

.meas tran vdout0_17ck1630 FIND v(dout0_17) AT=820.025n

.meas tran vdout0_18ck1630 FIND v(dout0_18) AT=820.025n

.meas tran vdout0_19ck1630 FIND v(dout0_19) AT=820.025n

.meas tran vdout0_20ck1630 FIND v(dout0_20) AT=820.025n

.meas tran vdout0_21ck1630 FIND v(dout0_21) AT=820.025n

.meas tran vdout0_22ck1630 FIND v(dout0_22) AT=820.025n

.meas tran vdout0_23ck1630 FIND v(dout0_23) AT=820.025n

.meas tran vdout0_24ck1630 FIND v(dout0_24) AT=820.025n

.meas tran vdout0_25ck1630 FIND v(dout0_25) AT=820.025n

.meas tran vdout0_26ck1630 FIND v(dout0_26) AT=820.025n

.meas tran vdout0_27ck1630 FIND v(dout0_27) AT=820.025n

.meas tran vdout0_28ck1630 FIND v(dout0_28) AT=820.025n

.meas tran vdout0_29ck1630 FIND v(dout0_29) AT=820.025n

.meas tran vdout0_30ck1630 FIND v(dout0_30) AT=820.025n

.meas tran vdout0_31ck1630 FIND v(dout0_31) AT=820.025n

.meas tran vdout0_0ck1650 FIND v(dout0_0) AT=830.025n

.meas tran vdout0_1ck1650 FIND v(dout0_1) AT=830.025n

.meas tran vdout0_2ck1650 FIND v(dout0_2) AT=830.025n

.meas tran vdout0_3ck1650 FIND v(dout0_3) AT=830.025n

.meas tran vdout0_4ck1650 FIND v(dout0_4) AT=830.025n

.meas tran vdout0_5ck1650 FIND v(dout0_5) AT=830.025n

.meas tran vdout0_6ck1650 FIND v(dout0_6) AT=830.025n

.meas tran vdout0_7ck1650 FIND v(dout0_7) AT=830.025n

.meas tran vdout0_8ck1650 FIND v(dout0_8) AT=830.025n

.meas tran vdout0_9ck1650 FIND v(dout0_9) AT=830.025n

.meas tran vdout0_10ck1650 FIND v(dout0_10) AT=830.025n

.meas tran vdout0_11ck1650 FIND v(dout0_11) AT=830.025n

.meas tran vdout0_12ck1650 FIND v(dout0_12) AT=830.025n

.meas tran vdout0_13ck1650 FIND v(dout0_13) AT=830.025n

.meas tran vdout0_14ck1650 FIND v(dout0_14) AT=830.025n

.meas tran vdout0_15ck1650 FIND v(dout0_15) AT=830.025n

.meas tran vdout0_16ck1650 FIND v(dout0_16) AT=830.025n

.meas tran vdout0_17ck1650 FIND v(dout0_17) AT=830.025n

.meas tran vdout0_18ck1650 FIND v(dout0_18) AT=830.025n

.meas tran vdout0_19ck1650 FIND v(dout0_19) AT=830.025n

.meas tran vdout0_20ck1650 FIND v(dout0_20) AT=830.025n

.meas tran vdout0_21ck1650 FIND v(dout0_21) AT=830.025n

.meas tran vdout0_22ck1650 FIND v(dout0_22) AT=830.025n

.meas tran vdout0_23ck1650 FIND v(dout0_23) AT=830.025n

.meas tran vdout0_24ck1650 FIND v(dout0_24) AT=830.025n

.meas tran vdout0_25ck1650 FIND v(dout0_25) AT=830.025n

.meas tran vdout0_26ck1650 FIND v(dout0_26) AT=830.025n

.meas tran vdout0_27ck1650 FIND v(dout0_27) AT=830.025n

.meas tran vdout0_28ck1650 FIND v(dout0_28) AT=830.025n

.meas tran vdout0_29ck1650 FIND v(dout0_29) AT=830.025n

.meas tran vdout0_30ck1650 FIND v(dout0_30) AT=830.025n

.meas tran vdout0_31ck1650 FIND v(dout0_31) AT=830.025n

.meas tran vdout0_0ck1670 FIND v(dout0_0) AT=840.025n

.meas tran vdout0_1ck1670 FIND v(dout0_1) AT=840.025n

.meas tran vdout0_2ck1670 FIND v(dout0_2) AT=840.025n

.meas tran vdout0_3ck1670 FIND v(dout0_3) AT=840.025n

.meas tran vdout0_4ck1670 FIND v(dout0_4) AT=840.025n

.meas tran vdout0_5ck1670 FIND v(dout0_5) AT=840.025n

.meas tran vdout0_6ck1670 FIND v(dout0_6) AT=840.025n

.meas tran vdout0_7ck1670 FIND v(dout0_7) AT=840.025n

.meas tran vdout0_8ck1670 FIND v(dout0_8) AT=840.025n

.meas tran vdout0_9ck1670 FIND v(dout0_9) AT=840.025n

.meas tran vdout0_10ck1670 FIND v(dout0_10) AT=840.025n

.meas tran vdout0_11ck1670 FIND v(dout0_11) AT=840.025n

.meas tran vdout0_12ck1670 FIND v(dout0_12) AT=840.025n

.meas tran vdout0_13ck1670 FIND v(dout0_13) AT=840.025n

.meas tran vdout0_14ck1670 FIND v(dout0_14) AT=840.025n

.meas tran vdout0_15ck1670 FIND v(dout0_15) AT=840.025n

.meas tran vdout0_16ck1670 FIND v(dout0_16) AT=840.025n

.meas tran vdout0_17ck1670 FIND v(dout0_17) AT=840.025n

.meas tran vdout0_18ck1670 FIND v(dout0_18) AT=840.025n

.meas tran vdout0_19ck1670 FIND v(dout0_19) AT=840.025n

.meas tran vdout0_20ck1670 FIND v(dout0_20) AT=840.025n

.meas tran vdout0_21ck1670 FIND v(dout0_21) AT=840.025n

.meas tran vdout0_22ck1670 FIND v(dout0_22) AT=840.025n

.meas tran vdout0_23ck1670 FIND v(dout0_23) AT=840.025n

.meas tran vdout0_24ck1670 FIND v(dout0_24) AT=840.025n

.meas tran vdout0_25ck1670 FIND v(dout0_25) AT=840.025n

.meas tran vdout0_26ck1670 FIND v(dout0_26) AT=840.025n

.meas tran vdout0_27ck1670 FIND v(dout0_27) AT=840.025n

.meas tran vdout0_28ck1670 FIND v(dout0_28) AT=840.025n

.meas tran vdout0_29ck1670 FIND v(dout0_29) AT=840.025n

.meas tran vdout0_30ck1670 FIND v(dout0_30) AT=840.025n

.meas tran vdout0_31ck1670 FIND v(dout0_31) AT=840.025n

.meas tran vdout0_0ck1680 FIND v(dout0_0) AT=845.025n

.meas tran vdout0_1ck1680 FIND v(dout0_1) AT=845.025n

.meas tran vdout0_2ck1680 FIND v(dout0_2) AT=845.025n

.meas tran vdout0_3ck1680 FIND v(dout0_3) AT=845.025n

.meas tran vdout0_4ck1680 FIND v(dout0_4) AT=845.025n

.meas tran vdout0_5ck1680 FIND v(dout0_5) AT=845.025n

.meas tran vdout0_6ck1680 FIND v(dout0_6) AT=845.025n

.meas tran vdout0_7ck1680 FIND v(dout0_7) AT=845.025n

.meas tran vdout0_8ck1680 FIND v(dout0_8) AT=845.025n

.meas tran vdout0_9ck1680 FIND v(dout0_9) AT=845.025n

.meas tran vdout0_10ck1680 FIND v(dout0_10) AT=845.025n

.meas tran vdout0_11ck1680 FIND v(dout0_11) AT=845.025n

.meas tran vdout0_12ck1680 FIND v(dout0_12) AT=845.025n

.meas tran vdout0_13ck1680 FIND v(dout0_13) AT=845.025n

.meas tran vdout0_14ck1680 FIND v(dout0_14) AT=845.025n

.meas tran vdout0_15ck1680 FIND v(dout0_15) AT=845.025n

.meas tran vdout0_16ck1680 FIND v(dout0_16) AT=845.025n

.meas tran vdout0_17ck1680 FIND v(dout0_17) AT=845.025n

.meas tran vdout0_18ck1680 FIND v(dout0_18) AT=845.025n

.meas tran vdout0_19ck1680 FIND v(dout0_19) AT=845.025n

.meas tran vdout0_20ck1680 FIND v(dout0_20) AT=845.025n

.meas tran vdout0_21ck1680 FIND v(dout0_21) AT=845.025n

.meas tran vdout0_22ck1680 FIND v(dout0_22) AT=845.025n

.meas tran vdout0_23ck1680 FIND v(dout0_23) AT=845.025n

.meas tran vdout0_24ck1680 FIND v(dout0_24) AT=845.025n

.meas tran vdout0_25ck1680 FIND v(dout0_25) AT=845.025n

.meas tran vdout0_26ck1680 FIND v(dout0_26) AT=845.025n

.meas tran vdout0_27ck1680 FIND v(dout0_27) AT=845.025n

.meas tran vdout0_28ck1680 FIND v(dout0_28) AT=845.025n

.meas tran vdout0_29ck1680 FIND v(dout0_29) AT=845.025n

.meas tran vdout0_30ck1680 FIND v(dout0_30) AT=845.025n

.meas tran vdout0_31ck1680 FIND v(dout0_31) AT=845.025n

.meas tran vdout0_0ck1700 FIND v(dout0_0) AT=855.025n

.meas tran vdout0_1ck1700 FIND v(dout0_1) AT=855.025n

.meas tran vdout0_2ck1700 FIND v(dout0_2) AT=855.025n

.meas tran vdout0_3ck1700 FIND v(dout0_3) AT=855.025n

.meas tran vdout0_4ck1700 FIND v(dout0_4) AT=855.025n

.meas tran vdout0_5ck1700 FIND v(dout0_5) AT=855.025n

.meas tran vdout0_6ck1700 FIND v(dout0_6) AT=855.025n

.meas tran vdout0_7ck1700 FIND v(dout0_7) AT=855.025n

.meas tran vdout0_8ck1700 FIND v(dout0_8) AT=855.025n

.meas tran vdout0_9ck1700 FIND v(dout0_9) AT=855.025n

.meas tran vdout0_10ck1700 FIND v(dout0_10) AT=855.025n

.meas tran vdout0_11ck1700 FIND v(dout0_11) AT=855.025n

.meas tran vdout0_12ck1700 FIND v(dout0_12) AT=855.025n

.meas tran vdout0_13ck1700 FIND v(dout0_13) AT=855.025n

.meas tran vdout0_14ck1700 FIND v(dout0_14) AT=855.025n

.meas tran vdout0_15ck1700 FIND v(dout0_15) AT=855.025n

.meas tran vdout0_16ck1700 FIND v(dout0_16) AT=855.025n

.meas tran vdout0_17ck1700 FIND v(dout0_17) AT=855.025n

.meas tran vdout0_18ck1700 FIND v(dout0_18) AT=855.025n

.meas tran vdout0_19ck1700 FIND v(dout0_19) AT=855.025n

.meas tran vdout0_20ck1700 FIND v(dout0_20) AT=855.025n

.meas tran vdout0_21ck1700 FIND v(dout0_21) AT=855.025n

.meas tran vdout0_22ck1700 FIND v(dout0_22) AT=855.025n

.meas tran vdout0_23ck1700 FIND v(dout0_23) AT=855.025n

.meas tran vdout0_24ck1700 FIND v(dout0_24) AT=855.025n

.meas tran vdout0_25ck1700 FIND v(dout0_25) AT=855.025n

.meas tran vdout0_26ck1700 FIND v(dout0_26) AT=855.025n

.meas tran vdout0_27ck1700 FIND v(dout0_27) AT=855.025n

.meas tran vdout0_28ck1700 FIND v(dout0_28) AT=855.025n

.meas tran vdout0_29ck1700 FIND v(dout0_29) AT=855.025n

.meas tran vdout0_30ck1700 FIND v(dout0_30) AT=855.025n

.meas tran vdout0_31ck1700 FIND v(dout0_31) AT=855.025n

.meas tran vdout0_0ck1730 FIND v(dout0_0) AT=870.025n

.meas tran vdout0_1ck1730 FIND v(dout0_1) AT=870.025n

.meas tran vdout0_2ck1730 FIND v(dout0_2) AT=870.025n

.meas tran vdout0_3ck1730 FIND v(dout0_3) AT=870.025n

.meas tran vdout0_4ck1730 FIND v(dout0_4) AT=870.025n

.meas tran vdout0_5ck1730 FIND v(dout0_5) AT=870.025n

.meas tran vdout0_6ck1730 FIND v(dout0_6) AT=870.025n

.meas tran vdout0_7ck1730 FIND v(dout0_7) AT=870.025n

.meas tran vdout0_8ck1730 FIND v(dout0_8) AT=870.025n

.meas tran vdout0_9ck1730 FIND v(dout0_9) AT=870.025n

.meas tran vdout0_10ck1730 FIND v(dout0_10) AT=870.025n

.meas tran vdout0_11ck1730 FIND v(dout0_11) AT=870.025n

.meas tran vdout0_12ck1730 FIND v(dout0_12) AT=870.025n

.meas tran vdout0_13ck1730 FIND v(dout0_13) AT=870.025n

.meas tran vdout0_14ck1730 FIND v(dout0_14) AT=870.025n

.meas tran vdout0_15ck1730 FIND v(dout0_15) AT=870.025n

.meas tran vdout0_16ck1730 FIND v(dout0_16) AT=870.025n

.meas tran vdout0_17ck1730 FIND v(dout0_17) AT=870.025n

.meas tran vdout0_18ck1730 FIND v(dout0_18) AT=870.025n

.meas tran vdout0_19ck1730 FIND v(dout0_19) AT=870.025n

.meas tran vdout0_20ck1730 FIND v(dout0_20) AT=870.025n

.meas tran vdout0_21ck1730 FIND v(dout0_21) AT=870.025n

.meas tran vdout0_22ck1730 FIND v(dout0_22) AT=870.025n

.meas tran vdout0_23ck1730 FIND v(dout0_23) AT=870.025n

.meas tran vdout0_24ck1730 FIND v(dout0_24) AT=870.025n

.meas tran vdout0_25ck1730 FIND v(dout0_25) AT=870.025n

.meas tran vdout0_26ck1730 FIND v(dout0_26) AT=870.025n

.meas tran vdout0_27ck1730 FIND v(dout0_27) AT=870.025n

.meas tran vdout0_28ck1730 FIND v(dout0_28) AT=870.025n

.meas tran vdout0_29ck1730 FIND v(dout0_29) AT=870.025n

.meas tran vdout0_30ck1730 FIND v(dout0_30) AT=870.025n

.meas tran vdout0_31ck1730 FIND v(dout0_31) AT=870.025n

.meas tran vdout0_0ck1760 FIND v(dout0_0) AT=885.025n

.meas tran vdout0_1ck1760 FIND v(dout0_1) AT=885.025n

.meas tran vdout0_2ck1760 FIND v(dout0_2) AT=885.025n

.meas tran vdout0_3ck1760 FIND v(dout0_3) AT=885.025n

.meas tran vdout0_4ck1760 FIND v(dout0_4) AT=885.025n

.meas tran vdout0_5ck1760 FIND v(dout0_5) AT=885.025n

.meas tran vdout0_6ck1760 FIND v(dout0_6) AT=885.025n

.meas tran vdout0_7ck1760 FIND v(dout0_7) AT=885.025n

.meas tran vdout0_8ck1760 FIND v(dout0_8) AT=885.025n

.meas tran vdout0_9ck1760 FIND v(dout0_9) AT=885.025n

.meas tran vdout0_10ck1760 FIND v(dout0_10) AT=885.025n

.meas tran vdout0_11ck1760 FIND v(dout0_11) AT=885.025n

.meas tran vdout0_12ck1760 FIND v(dout0_12) AT=885.025n

.meas tran vdout0_13ck1760 FIND v(dout0_13) AT=885.025n

.meas tran vdout0_14ck1760 FIND v(dout0_14) AT=885.025n

.meas tran vdout0_15ck1760 FIND v(dout0_15) AT=885.025n

.meas tran vdout0_16ck1760 FIND v(dout0_16) AT=885.025n

.meas tran vdout0_17ck1760 FIND v(dout0_17) AT=885.025n

.meas tran vdout0_18ck1760 FIND v(dout0_18) AT=885.025n

.meas tran vdout0_19ck1760 FIND v(dout0_19) AT=885.025n

.meas tran vdout0_20ck1760 FIND v(dout0_20) AT=885.025n

.meas tran vdout0_21ck1760 FIND v(dout0_21) AT=885.025n

.meas tran vdout0_22ck1760 FIND v(dout0_22) AT=885.025n

.meas tran vdout0_23ck1760 FIND v(dout0_23) AT=885.025n

.meas tran vdout0_24ck1760 FIND v(dout0_24) AT=885.025n

.meas tran vdout0_25ck1760 FIND v(dout0_25) AT=885.025n

.meas tran vdout0_26ck1760 FIND v(dout0_26) AT=885.025n

.meas tran vdout0_27ck1760 FIND v(dout0_27) AT=885.025n

.meas tran vdout0_28ck1760 FIND v(dout0_28) AT=885.025n

.meas tran vdout0_29ck1760 FIND v(dout0_29) AT=885.025n

.meas tran vdout0_30ck1760 FIND v(dout0_30) AT=885.025n

.meas tran vdout0_31ck1760 FIND v(dout0_31) AT=885.025n

.meas tran vdout0_0ck1770 FIND v(dout0_0) AT=890.025n

.meas tran vdout0_1ck1770 FIND v(dout0_1) AT=890.025n

.meas tran vdout0_2ck1770 FIND v(dout0_2) AT=890.025n

.meas tran vdout0_3ck1770 FIND v(dout0_3) AT=890.025n

.meas tran vdout0_4ck1770 FIND v(dout0_4) AT=890.025n

.meas tran vdout0_5ck1770 FIND v(dout0_5) AT=890.025n

.meas tran vdout0_6ck1770 FIND v(dout0_6) AT=890.025n

.meas tran vdout0_7ck1770 FIND v(dout0_7) AT=890.025n

.meas tran vdout0_8ck1770 FIND v(dout0_8) AT=890.025n

.meas tran vdout0_9ck1770 FIND v(dout0_9) AT=890.025n

.meas tran vdout0_10ck1770 FIND v(dout0_10) AT=890.025n

.meas tran vdout0_11ck1770 FIND v(dout0_11) AT=890.025n

.meas tran vdout0_12ck1770 FIND v(dout0_12) AT=890.025n

.meas tran vdout0_13ck1770 FIND v(dout0_13) AT=890.025n

.meas tran vdout0_14ck1770 FIND v(dout0_14) AT=890.025n

.meas tran vdout0_15ck1770 FIND v(dout0_15) AT=890.025n

.meas tran vdout0_16ck1770 FIND v(dout0_16) AT=890.025n

.meas tran vdout0_17ck1770 FIND v(dout0_17) AT=890.025n

.meas tran vdout0_18ck1770 FIND v(dout0_18) AT=890.025n

.meas tran vdout0_19ck1770 FIND v(dout0_19) AT=890.025n

.meas tran vdout0_20ck1770 FIND v(dout0_20) AT=890.025n

.meas tran vdout0_21ck1770 FIND v(dout0_21) AT=890.025n

.meas tran vdout0_22ck1770 FIND v(dout0_22) AT=890.025n

.meas tran vdout0_23ck1770 FIND v(dout0_23) AT=890.025n

.meas tran vdout0_24ck1770 FIND v(dout0_24) AT=890.025n

.meas tran vdout0_25ck1770 FIND v(dout0_25) AT=890.025n

.meas tran vdout0_26ck1770 FIND v(dout0_26) AT=890.025n

.meas tran vdout0_27ck1770 FIND v(dout0_27) AT=890.025n

.meas tran vdout0_28ck1770 FIND v(dout0_28) AT=890.025n

.meas tran vdout0_29ck1770 FIND v(dout0_29) AT=890.025n

.meas tran vdout0_30ck1770 FIND v(dout0_30) AT=890.025n

.meas tran vdout0_31ck1770 FIND v(dout0_31) AT=890.025n

.meas tran vdout0_0ck1780 FIND v(dout0_0) AT=895.025n

.meas tran vdout0_1ck1780 FIND v(dout0_1) AT=895.025n

.meas tran vdout0_2ck1780 FIND v(dout0_2) AT=895.025n

.meas tran vdout0_3ck1780 FIND v(dout0_3) AT=895.025n

.meas tran vdout0_4ck1780 FIND v(dout0_4) AT=895.025n

.meas tran vdout0_5ck1780 FIND v(dout0_5) AT=895.025n

.meas tran vdout0_6ck1780 FIND v(dout0_6) AT=895.025n

.meas tran vdout0_7ck1780 FIND v(dout0_7) AT=895.025n

.meas tran vdout0_8ck1780 FIND v(dout0_8) AT=895.025n

.meas tran vdout0_9ck1780 FIND v(dout0_9) AT=895.025n

.meas tran vdout0_10ck1780 FIND v(dout0_10) AT=895.025n

.meas tran vdout0_11ck1780 FIND v(dout0_11) AT=895.025n

.meas tran vdout0_12ck1780 FIND v(dout0_12) AT=895.025n

.meas tran vdout0_13ck1780 FIND v(dout0_13) AT=895.025n

.meas tran vdout0_14ck1780 FIND v(dout0_14) AT=895.025n

.meas tran vdout0_15ck1780 FIND v(dout0_15) AT=895.025n

.meas tran vdout0_16ck1780 FIND v(dout0_16) AT=895.025n

.meas tran vdout0_17ck1780 FIND v(dout0_17) AT=895.025n

.meas tran vdout0_18ck1780 FIND v(dout0_18) AT=895.025n

.meas tran vdout0_19ck1780 FIND v(dout0_19) AT=895.025n

.meas tran vdout0_20ck1780 FIND v(dout0_20) AT=895.025n

.meas tran vdout0_21ck1780 FIND v(dout0_21) AT=895.025n

.meas tran vdout0_22ck1780 FIND v(dout0_22) AT=895.025n

.meas tran vdout0_23ck1780 FIND v(dout0_23) AT=895.025n

.meas tran vdout0_24ck1780 FIND v(dout0_24) AT=895.025n

.meas tran vdout0_25ck1780 FIND v(dout0_25) AT=895.025n

.meas tran vdout0_26ck1780 FIND v(dout0_26) AT=895.025n

.meas tran vdout0_27ck1780 FIND v(dout0_27) AT=895.025n

.meas tran vdout0_28ck1780 FIND v(dout0_28) AT=895.025n

.meas tran vdout0_29ck1780 FIND v(dout0_29) AT=895.025n

.meas tran vdout0_30ck1780 FIND v(dout0_30) AT=895.025n

.meas tran vdout0_31ck1780 FIND v(dout0_31) AT=895.025n

.meas tran vdout0_0ck1790 FIND v(dout0_0) AT=900.025n

.meas tran vdout0_1ck1790 FIND v(dout0_1) AT=900.025n

.meas tran vdout0_2ck1790 FIND v(dout0_2) AT=900.025n

.meas tran vdout0_3ck1790 FIND v(dout0_3) AT=900.025n

.meas tran vdout0_4ck1790 FIND v(dout0_4) AT=900.025n

.meas tran vdout0_5ck1790 FIND v(dout0_5) AT=900.025n

.meas tran vdout0_6ck1790 FIND v(dout0_6) AT=900.025n

.meas tran vdout0_7ck1790 FIND v(dout0_7) AT=900.025n

.meas tran vdout0_8ck1790 FIND v(dout0_8) AT=900.025n

.meas tran vdout0_9ck1790 FIND v(dout0_9) AT=900.025n

.meas tran vdout0_10ck1790 FIND v(dout0_10) AT=900.025n

.meas tran vdout0_11ck1790 FIND v(dout0_11) AT=900.025n

.meas tran vdout0_12ck1790 FIND v(dout0_12) AT=900.025n

.meas tran vdout0_13ck1790 FIND v(dout0_13) AT=900.025n

.meas tran vdout0_14ck1790 FIND v(dout0_14) AT=900.025n

.meas tran vdout0_15ck1790 FIND v(dout0_15) AT=900.025n

.meas tran vdout0_16ck1790 FIND v(dout0_16) AT=900.025n

.meas tran vdout0_17ck1790 FIND v(dout0_17) AT=900.025n

.meas tran vdout0_18ck1790 FIND v(dout0_18) AT=900.025n

.meas tran vdout0_19ck1790 FIND v(dout0_19) AT=900.025n

.meas tran vdout0_20ck1790 FIND v(dout0_20) AT=900.025n

.meas tran vdout0_21ck1790 FIND v(dout0_21) AT=900.025n

.meas tran vdout0_22ck1790 FIND v(dout0_22) AT=900.025n

.meas tran vdout0_23ck1790 FIND v(dout0_23) AT=900.025n

.meas tran vdout0_24ck1790 FIND v(dout0_24) AT=900.025n

.meas tran vdout0_25ck1790 FIND v(dout0_25) AT=900.025n

.meas tran vdout0_26ck1790 FIND v(dout0_26) AT=900.025n

.meas tran vdout0_27ck1790 FIND v(dout0_27) AT=900.025n

.meas tran vdout0_28ck1790 FIND v(dout0_28) AT=900.025n

.meas tran vdout0_29ck1790 FIND v(dout0_29) AT=900.025n

.meas tran vdout0_30ck1790 FIND v(dout0_30) AT=900.025n

.meas tran vdout0_31ck1790 FIND v(dout0_31) AT=900.025n

.meas tran vdout0_0ck1820 FIND v(dout0_0) AT=915.025n

.meas tran vdout0_1ck1820 FIND v(dout0_1) AT=915.025n

.meas tran vdout0_2ck1820 FIND v(dout0_2) AT=915.025n

.meas tran vdout0_3ck1820 FIND v(dout0_3) AT=915.025n

.meas tran vdout0_4ck1820 FIND v(dout0_4) AT=915.025n

.meas tran vdout0_5ck1820 FIND v(dout0_5) AT=915.025n

.meas tran vdout0_6ck1820 FIND v(dout0_6) AT=915.025n

.meas tran vdout0_7ck1820 FIND v(dout0_7) AT=915.025n

.meas tran vdout0_8ck1820 FIND v(dout0_8) AT=915.025n

.meas tran vdout0_9ck1820 FIND v(dout0_9) AT=915.025n

.meas tran vdout0_10ck1820 FIND v(dout0_10) AT=915.025n

.meas tran vdout0_11ck1820 FIND v(dout0_11) AT=915.025n

.meas tran vdout0_12ck1820 FIND v(dout0_12) AT=915.025n

.meas tran vdout0_13ck1820 FIND v(dout0_13) AT=915.025n

.meas tran vdout0_14ck1820 FIND v(dout0_14) AT=915.025n

.meas tran vdout0_15ck1820 FIND v(dout0_15) AT=915.025n

.meas tran vdout0_16ck1820 FIND v(dout0_16) AT=915.025n

.meas tran vdout0_17ck1820 FIND v(dout0_17) AT=915.025n

.meas tran vdout0_18ck1820 FIND v(dout0_18) AT=915.025n

.meas tran vdout0_19ck1820 FIND v(dout0_19) AT=915.025n

.meas tran vdout0_20ck1820 FIND v(dout0_20) AT=915.025n

.meas tran vdout0_21ck1820 FIND v(dout0_21) AT=915.025n

.meas tran vdout0_22ck1820 FIND v(dout0_22) AT=915.025n

.meas tran vdout0_23ck1820 FIND v(dout0_23) AT=915.025n

.meas tran vdout0_24ck1820 FIND v(dout0_24) AT=915.025n

.meas tran vdout0_25ck1820 FIND v(dout0_25) AT=915.025n

.meas tran vdout0_26ck1820 FIND v(dout0_26) AT=915.025n

.meas tran vdout0_27ck1820 FIND v(dout0_27) AT=915.025n

.meas tran vdout0_28ck1820 FIND v(dout0_28) AT=915.025n

.meas tran vdout0_29ck1820 FIND v(dout0_29) AT=915.025n

.meas tran vdout0_30ck1820 FIND v(dout0_30) AT=915.025n

.meas tran vdout0_31ck1820 FIND v(dout0_31) AT=915.025n

.meas tran vdout0_0ck1840 FIND v(dout0_0) AT=925.025n

.meas tran vdout0_1ck1840 FIND v(dout0_1) AT=925.025n

.meas tran vdout0_2ck1840 FIND v(dout0_2) AT=925.025n

.meas tran vdout0_3ck1840 FIND v(dout0_3) AT=925.025n

.meas tran vdout0_4ck1840 FIND v(dout0_4) AT=925.025n

.meas tran vdout0_5ck1840 FIND v(dout0_5) AT=925.025n

.meas tran vdout0_6ck1840 FIND v(dout0_6) AT=925.025n

.meas tran vdout0_7ck1840 FIND v(dout0_7) AT=925.025n

.meas tran vdout0_8ck1840 FIND v(dout0_8) AT=925.025n

.meas tran vdout0_9ck1840 FIND v(dout0_9) AT=925.025n

.meas tran vdout0_10ck1840 FIND v(dout0_10) AT=925.025n

.meas tran vdout0_11ck1840 FIND v(dout0_11) AT=925.025n

.meas tran vdout0_12ck1840 FIND v(dout0_12) AT=925.025n

.meas tran vdout0_13ck1840 FIND v(dout0_13) AT=925.025n

.meas tran vdout0_14ck1840 FIND v(dout0_14) AT=925.025n

.meas tran vdout0_15ck1840 FIND v(dout0_15) AT=925.025n

.meas tran vdout0_16ck1840 FIND v(dout0_16) AT=925.025n

.meas tran vdout0_17ck1840 FIND v(dout0_17) AT=925.025n

.meas tran vdout0_18ck1840 FIND v(dout0_18) AT=925.025n

.meas tran vdout0_19ck1840 FIND v(dout0_19) AT=925.025n

.meas tran vdout0_20ck1840 FIND v(dout0_20) AT=925.025n

.meas tran vdout0_21ck1840 FIND v(dout0_21) AT=925.025n

.meas tran vdout0_22ck1840 FIND v(dout0_22) AT=925.025n

.meas tran vdout0_23ck1840 FIND v(dout0_23) AT=925.025n

.meas tran vdout0_24ck1840 FIND v(dout0_24) AT=925.025n

.meas tran vdout0_25ck1840 FIND v(dout0_25) AT=925.025n

.meas tran vdout0_26ck1840 FIND v(dout0_26) AT=925.025n

.meas tran vdout0_27ck1840 FIND v(dout0_27) AT=925.025n

.meas tran vdout0_28ck1840 FIND v(dout0_28) AT=925.025n

.meas tran vdout0_29ck1840 FIND v(dout0_29) AT=925.025n

.meas tran vdout0_30ck1840 FIND v(dout0_30) AT=925.025n

.meas tran vdout0_31ck1840 FIND v(dout0_31) AT=925.025n

.meas tran vdout0_0ck1850 FIND v(dout0_0) AT=930.025n

.meas tran vdout0_1ck1850 FIND v(dout0_1) AT=930.025n

.meas tran vdout0_2ck1850 FIND v(dout0_2) AT=930.025n

.meas tran vdout0_3ck1850 FIND v(dout0_3) AT=930.025n

.meas tran vdout0_4ck1850 FIND v(dout0_4) AT=930.025n

.meas tran vdout0_5ck1850 FIND v(dout0_5) AT=930.025n

.meas tran vdout0_6ck1850 FIND v(dout0_6) AT=930.025n

.meas tran vdout0_7ck1850 FIND v(dout0_7) AT=930.025n

.meas tran vdout0_8ck1850 FIND v(dout0_8) AT=930.025n

.meas tran vdout0_9ck1850 FIND v(dout0_9) AT=930.025n

.meas tran vdout0_10ck1850 FIND v(dout0_10) AT=930.025n

.meas tran vdout0_11ck1850 FIND v(dout0_11) AT=930.025n

.meas tran vdout0_12ck1850 FIND v(dout0_12) AT=930.025n

.meas tran vdout0_13ck1850 FIND v(dout0_13) AT=930.025n

.meas tran vdout0_14ck1850 FIND v(dout0_14) AT=930.025n

.meas tran vdout0_15ck1850 FIND v(dout0_15) AT=930.025n

.meas tran vdout0_16ck1850 FIND v(dout0_16) AT=930.025n

.meas tran vdout0_17ck1850 FIND v(dout0_17) AT=930.025n

.meas tran vdout0_18ck1850 FIND v(dout0_18) AT=930.025n

.meas tran vdout0_19ck1850 FIND v(dout0_19) AT=930.025n

.meas tran vdout0_20ck1850 FIND v(dout0_20) AT=930.025n

.meas tran vdout0_21ck1850 FIND v(dout0_21) AT=930.025n

.meas tran vdout0_22ck1850 FIND v(dout0_22) AT=930.025n

.meas tran vdout0_23ck1850 FIND v(dout0_23) AT=930.025n

.meas tran vdout0_24ck1850 FIND v(dout0_24) AT=930.025n

.meas tran vdout0_25ck1850 FIND v(dout0_25) AT=930.025n

.meas tran vdout0_26ck1850 FIND v(dout0_26) AT=930.025n

.meas tran vdout0_27ck1850 FIND v(dout0_27) AT=930.025n

.meas tran vdout0_28ck1850 FIND v(dout0_28) AT=930.025n

.meas tran vdout0_29ck1850 FIND v(dout0_29) AT=930.025n

.meas tran vdout0_30ck1850 FIND v(dout0_30) AT=930.025n

.meas tran vdout0_31ck1850 FIND v(dout0_31) AT=930.025n

.meas tran vdout0_0ck1860 FIND v(dout0_0) AT=935.025n

.meas tran vdout0_1ck1860 FIND v(dout0_1) AT=935.025n

.meas tran vdout0_2ck1860 FIND v(dout0_2) AT=935.025n

.meas tran vdout0_3ck1860 FIND v(dout0_3) AT=935.025n

.meas tran vdout0_4ck1860 FIND v(dout0_4) AT=935.025n

.meas tran vdout0_5ck1860 FIND v(dout0_5) AT=935.025n

.meas tran vdout0_6ck1860 FIND v(dout0_6) AT=935.025n

.meas tran vdout0_7ck1860 FIND v(dout0_7) AT=935.025n

.meas tran vdout0_8ck1860 FIND v(dout0_8) AT=935.025n

.meas tran vdout0_9ck1860 FIND v(dout0_9) AT=935.025n

.meas tran vdout0_10ck1860 FIND v(dout0_10) AT=935.025n

.meas tran vdout0_11ck1860 FIND v(dout0_11) AT=935.025n

.meas tran vdout0_12ck1860 FIND v(dout0_12) AT=935.025n

.meas tran vdout0_13ck1860 FIND v(dout0_13) AT=935.025n

.meas tran vdout0_14ck1860 FIND v(dout0_14) AT=935.025n

.meas tran vdout0_15ck1860 FIND v(dout0_15) AT=935.025n

.meas tran vdout0_16ck1860 FIND v(dout0_16) AT=935.025n

.meas tran vdout0_17ck1860 FIND v(dout0_17) AT=935.025n

.meas tran vdout0_18ck1860 FIND v(dout0_18) AT=935.025n

.meas tran vdout0_19ck1860 FIND v(dout0_19) AT=935.025n

.meas tran vdout0_20ck1860 FIND v(dout0_20) AT=935.025n

.meas tran vdout0_21ck1860 FIND v(dout0_21) AT=935.025n

.meas tran vdout0_22ck1860 FIND v(dout0_22) AT=935.025n

.meas tran vdout0_23ck1860 FIND v(dout0_23) AT=935.025n

.meas tran vdout0_24ck1860 FIND v(dout0_24) AT=935.025n

.meas tran vdout0_25ck1860 FIND v(dout0_25) AT=935.025n

.meas tran vdout0_26ck1860 FIND v(dout0_26) AT=935.025n

.meas tran vdout0_27ck1860 FIND v(dout0_27) AT=935.025n

.meas tran vdout0_28ck1860 FIND v(dout0_28) AT=935.025n

.meas tran vdout0_29ck1860 FIND v(dout0_29) AT=935.025n

.meas tran vdout0_30ck1860 FIND v(dout0_30) AT=935.025n

.meas tran vdout0_31ck1860 FIND v(dout0_31) AT=935.025n

.meas tran vdout0_0ck1890 FIND v(dout0_0) AT=950.025n

.meas tran vdout0_1ck1890 FIND v(dout0_1) AT=950.025n

.meas tran vdout0_2ck1890 FIND v(dout0_2) AT=950.025n

.meas tran vdout0_3ck1890 FIND v(dout0_3) AT=950.025n

.meas tran vdout0_4ck1890 FIND v(dout0_4) AT=950.025n

.meas tran vdout0_5ck1890 FIND v(dout0_5) AT=950.025n

.meas tran vdout0_6ck1890 FIND v(dout0_6) AT=950.025n

.meas tran vdout0_7ck1890 FIND v(dout0_7) AT=950.025n

.meas tran vdout0_8ck1890 FIND v(dout0_8) AT=950.025n

.meas tran vdout0_9ck1890 FIND v(dout0_9) AT=950.025n

.meas tran vdout0_10ck1890 FIND v(dout0_10) AT=950.025n

.meas tran vdout0_11ck1890 FIND v(dout0_11) AT=950.025n

.meas tran vdout0_12ck1890 FIND v(dout0_12) AT=950.025n

.meas tran vdout0_13ck1890 FIND v(dout0_13) AT=950.025n

.meas tran vdout0_14ck1890 FIND v(dout0_14) AT=950.025n

.meas tran vdout0_15ck1890 FIND v(dout0_15) AT=950.025n

.meas tran vdout0_16ck1890 FIND v(dout0_16) AT=950.025n

.meas tran vdout0_17ck1890 FIND v(dout0_17) AT=950.025n

.meas tran vdout0_18ck1890 FIND v(dout0_18) AT=950.025n

.meas tran vdout0_19ck1890 FIND v(dout0_19) AT=950.025n

.meas tran vdout0_20ck1890 FIND v(dout0_20) AT=950.025n

.meas tran vdout0_21ck1890 FIND v(dout0_21) AT=950.025n

.meas tran vdout0_22ck1890 FIND v(dout0_22) AT=950.025n

.meas tran vdout0_23ck1890 FIND v(dout0_23) AT=950.025n

.meas tran vdout0_24ck1890 FIND v(dout0_24) AT=950.025n

.meas tran vdout0_25ck1890 FIND v(dout0_25) AT=950.025n

.meas tran vdout0_26ck1890 FIND v(dout0_26) AT=950.025n

.meas tran vdout0_27ck1890 FIND v(dout0_27) AT=950.025n

.meas tran vdout0_28ck1890 FIND v(dout0_28) AT=950.025n

.meas tran vdout0_29ck1890 FIND v(dout0_29) AT=950.025n

.meas tran vdout0_30ck1890 FIND v(dout0_30) AT=950.025n

.meas tran vdout0_31ck1890 FIND v(dout0_31) AT=950.025n

.meas tran vdout0_0ck1900 FIND v(dout0_0) AT=955.025n

.meas tran vdout0_1ck1900 FIND v(dout0_1) AT=955.025n

.meas tran vdout0_2ck1900 FIND v(dout0_2) AT=955.025n

.meas tran vdout0_3ck1900 FIND v(dout0_3) AT=955.025n

.meas tran vdout0_4ck1900 FIND v(dout0_4) AT=955.025n

.meas tran vdout0_5ck1900 FIND v(dout0_5) AT=955.025n

.meas tran vdout0_6ck1900 FIND v(dout0_6) AT=955.025n

.meas tran vdout0_7ck1900 FIND v(dout0_7) AT=955.025n

.meas tran vdout0_8ck1900 FIND v(dout0_8) AT=955.025n

.meas tran vdout0_9ck1900 FIND v(dout0_9) AT=955.025n

.meas tran vdout0_10ck1900 FIND v(dout0_10) AT=955.025n

.meas tran vdout0_11ck1900 FIND v(dout0_11) AT=955.025n

.meas tran vdout0_12ck1900 FIND v(dout0_12) AT=955.025n

.meas tran vdout0_13ck1900 FIND v(dout0_13) AT=955.025n

.meas tran vdout0_14ck1900 FIND v(dout0_14) AT=955.025n

.meas tran vdout0_15ck1900 FIND v(dout0_15) AT=955.025n

.meas tran vdout0_16ck1900 FIND v(dout0_16) AT=955.025n

.meas tran vdout0_17ck1900 FIND v(dout0_17) AT=955.025n

.meas tran vdout0_18ck1900 FIND v(dout0_18) AT=955.025n

.meas tran vdout0_19ck1900 FIND v(dout0_19) AT=955.025n

.meas tran vdout0_20ck1900 FIND v(dout0_20) AT=955.025n

.meas tran vdout0_21ck1900 FIND v(dout0_21) AT=955.025n

.meas tran vdout0_22ck1900 FIND v(dout0_22) AT=955.025n

.meas tran vdout0_23ck1900 FIND v(dout0_23) AT=955.025n

.meas tran vdout0_24ck1900 FIND v(dout0_24) AT=955.025n

.meas tran vdout0_25ck1900 FIND v(dout0_25) AT=955.025n

.meas tran vdout0_26ck1900 FIND v(dout0_26) AT=955.025n

.meas tran vdout0_27ck1900 FIND v(dout0_27) AT=955.025n

.meas tran vdout0_28ck1900 FIND v(dout0_28) AT=955.025n

.meas tran vdout0_29ck1900 FIND v(dout0_29) AT=955.025n

.meas tran vdout0_30ck1900 FIND v(dout0_30) AT=955.025n

.meas tran vdout0_31ck1900 FIND v(dout0_31) AT=955.025n

.meas tran vdout0_0ck1920 FIND v(dout0_0) AT=965.025n

.meas tran vdout0_1ck1920 FIND v(dout0_1) AT=965.025n

.meas tran vdout0_2ck1920 FIND v(dout0_2) AT=965.025n

.meas tran vdout0_3ck1920 FIND v(dout0_3) AT=965.025n

.meas tran vdout0_4ck1920 FIND v(dout0_4) AT=965.025n

.meas tran vdout0_5ck1920 FIND v(dout0_5) AT=965.025n

.meas tran vdout0_6ck1920 FIND v(dout0_6) AT=965.025n

.meas tran vdout0_7ck1920 FIND v(dout0_7) AT=965.025n

.meas tran vdout0_8ck1920 FIND v(dout0_8) AT=965.025n

.meas tran vdout0_9ck1920 FIND v(dout0_9) AT=965.025n

.meas tran vdout0_10ck1920 FIND v(dout0_10) AT=965.025n

.meas tran vdout0_11ck1920 FIND v(dout0_11) AT=965.025n

.meas tran vdout0_12ck1920 FIND v(dout0_12) AT=965.025n

.meas tran vdout0_13ck1920 FIND v(dout0_13) AT=965.025n

.meas tran vdout0_14ck1920 FIND v(dout0_14) AT=965.025n

.meas tran vdout0_15ck1920 FIND v(dout0_15) AT=965.025n

.meas tran vdout0_16ck1920 FIND v(dout0_16) AT=965.025n

.meas tran vdout0_17ck1920 FIND v(dout0_17) AT=965.025n

.meas tran vdout0_18ck1920 FIND v(dout0_18) AT=965.025n

.meas tran vdout0_19ck1920 FIND v(dout0_19) AT=965.025n

.meas tran vdout0_20ck1920 FIND v(dout0_20) AT=965.025n

.meas tran vdout0_21ck1920 FIND v(dout0_21) AT=965.025n

.meas tran vdout0_22ck1920 FIND v(dout0_22) AT=965.025n

.meas tran vdout0_23ck1920 FIND v(dout0_23) AT=965.025n

.meas tran vdout0_24ck1920 FIND v(dout0_24) AT=965.025n

.meas tran vdout0_25ck1920 FIND v(dout0_25) AT=965.025n

.meas tran vdout0_26ck1920 FIND v(dout0_26) AT=965.025n

.meas tran vdout0_27ck1920 FIND v(dout0_27) AT=965.025n

.meas tran vdout0_28ck1920 FIND v(dout0_28) AT=965.025n

.meas tran vdout0_29ck1920 FIND v(dout0_29) AT=965.025n

.meas tran vdout0_30ck1920 FIND v(dout0_30) AT=965.025n

.meas tran vdout0_31ck1920 FIND v(dout0_31) AT=965.025n

.meas tran vdout0_0ck1930 FIND v(dout0_0) AT=970.025n

.meas tran vdout0_1ck1930 FIND v(dout0_1) AT=970.025n

.meas tran vdout0_2ck1930 FIND v(dout0_2) AT=970.025n

.meas tran vdout0_3ck1930 FIND v(dout0_3) AT=970.025n

.meas tran vdout0_4ck1930 FIND v(dout0_4) AT=970.025n

.meas tran vdout0_5ck1930 FIND v(dout0_5) AT=970.025n

.meas tran vdout0_6ck1930 FIND v(dout0_6) AT=970.025n

.meas tran vdout0_7ck1930 FIND v(dout0_7) AT=970.025n

.meas tran vdout0_8ck1930 FIND v(dout0_8) AT=970.025n

.meas tran vdout0_9ck1930 FIND v(dout0_9) AT=970.025n

.meas tran vdout0_10ck1930 FIND v(dout0_10) AT=970.025n

.meas tran vdout0_11ck1930 FIND v(dout0_11) AT=970.025n

.meas tran vdout0_12ck1930 FIND v(dout0_12) AT=970.025n

.meas tran vdout0_13ck1930 FIND v(dout0_13) AT=970.025n

.meas tran vdout0_14ck1930 FIND v(dout0_14) AT=970.025n

.meas tran vdout0_15ck1930 FIND v(dout0_15) AT=970.025n

.meas tran vdout0_16ck1930 FIND v(dout0_16) AT=970.025n

.meas tran vdout0_17ck1930 FIND v(dout0_17) AT=970.025n

.meas tran vdout0_18ck1930 FIND v(dout0_18) AT=970.025n

.meas tran vdout0_19ck1930 FIND v(dout0_19) AT=970.025n

.meas tran vdout0_20ck1930 FIND v(dout0_20) AT=970.025n

.meas tran vdout0_21ck1930 FIND v(dout0_21) AT=970.025n

.meas tran vdout0_22ck1930 FIND v(dout0_22) AT=970.025n

.meas tran vdout0_23ck1930 FIND v(dout0_23) AT=970.025n

.meas tran vdout0_24ck1930 FIND v(dout0_24) AT=970.025n

.meas tran vdout0_25ck1930 FIND v(dout0_25) AT=970.025n

.meas tran vdout0_26ck1930 FIND v(dout0_26) AT=970.025n

.meas tran vdout0_27ck1930 FIND v(dout0_27) AT=970.025n

.meas tran vdout0_28ck1930 FIND v(dout0_28) AT=970.025n

.meas tran vdout0_29ck1930 FIND v(dout0_29) AT=970.025n

.meas tran vdout0_30ck1930 FIND v(dout0_30) AT=970.025n

.meas tran vdout0_31ck1930 FIND v(dout0_31) AT=970.025n

.meas tran vdout0_0ck1950 FIND v(dout0_0) AT=980.025n

.meas tran vdout0_1ck1950 FIND v(dout0_1) AT=980.025n

.meas tran vdout0_2ck1950 FIND v(dout0_2) AT=980.025n

.meas tran vdout0_3ck1950 FIND v(dout0_3) AT=980.025n

.meas tran vdout0_4ck1950 FIND v(dout0_4) AT=980.025n

.meas tran vdout0_5ck1950 FIND v(dout0_5) AT=980.025n

.meas tran vdout0_6ck1950 FIND v(dout0_6) AT=980.025n

.meas tran vdout0_7ck1950 FIND v(dout0_7) AT=980.025n

.meas tran vdout0_8ck1950 FIND v(dout0_8) AT=980.025n

.meas tran vdout0_9ck1950 FIND v(dout0_9) AT=980.025n

.meas tran vdout0_10ck1950 FIND v(dout0_10) AT=980.025n

.meas tran vdout0_11ck1950 FIND v(dout0_11) AT=980.025n

.meas tran vdout0_12ck1950 FIND v(dout0_12) AT=980.025n

.meas tran vdout0_13ck1950 FIND v(dout0_13) AT=980.025n

.meas tran vdout0_14ck1950 FIND v(dout0_14) AT=980.025n

.meas tran vdout0_15ck1950 FIND v(dout0_15) AT=980.025n

.meas tran vdout0_16ck1950 FIND v(dout0_16) AT=980.025n

.meas tran vdout0_17ck1950 FIND v(dout0_17) AT=980.025n

.meas tran vdout0_18ck1950 FIND v(dout0_18) AT=980.025n

.meas tran vdout0_19ck1950 FIND v(dout0_19) AT=980.025n

.meas tran vdout0_20ck1950 FIND v(dout0_20) AT=980.025n

.meas tran vdout0_21ck1950 FIND v(dout0_21) AT=980.025n

.meas tran vdout0_22ck1950 FIND v(dout0_22) AT=980.025n

.meas tran vdout0_23ck1950 FIND v(dout0_23) AT=980.025n

.meas tran vdout0_24ck1950 FIND v(dout0_24) AT=980.025n

.meas tran vdout0_25ck1950 FIND v(dout0_25) AT=980.025n

.meas tran vdout0_26ck1950 FIND v(dout0_26) AT=980.025n

.meas tran vdout0_27ck1950 FIND v(dout0_27) AT=980.025n

.meas tran vdout0_28ck1950 FIND v(dout0_28) AT=980.025n

.meas tran vdout0_29ck1950 FIND v(dout0_29) AT=980.025n

.meas tran vdout0_30ck1950 FIND v(dout0_30) AT=980.025n

.meas tran vdout0_31ck1950 FIND v(dout0_31) AT=980.025n

.meas tran vdout0_0ck1960 FIND v(dout0_0) AT=985.025n

.meas tran vdout0_1ck1960 FIND v(dout0_1) AT=985.025n

.meas tran vdout0_2ck1960 FIND v(dout0_2) AT=985.025n

.meas tran vdout0_3ck1960 FIND v(dout0_3) AT=985.025n

.meas tran vdout0_4ck1960 FIND v(dout0_4) AT=985.025n

.meas tran vdout0_5ck1960 FIND v(dout0_5) AT=985.025n

.meas tran vdout0_6ck1960 FIND v(dout0_6) AT=985.025n

.meas tran vdout0_7ck1960 FIND v(dout0_7) AT=985.025n

.meas tran vdout0_8ck1960 FIND v(dout0_8) AT=985.025n

.meas tran vdout0_9ck1960 FIND v(dout0_9) AT=985.025n

.meas tran vdout0_10ck1960 FIND v(dout0_10) AT=985.025n

.meas tran vdout0_11ck1960 FIND v(dout0_11) AT=985.025n

.meas tran vdout0_12ck1960 FIND v(dout0_12) AT=985.025n

.meas tran vdout0_13ck1960 FIND v(dout0_13) AT=985.025n

.meas tran vdout0_14ck1960 FIND v(dout0_14) AT=985.025n

.meas tran vdout0_15ck1960 FIND v(dout0_15) AT=985.025n

.meas tran vdout0_16ck1960 FIND v(dout0_16) AT=985.025n

.meas tran vdout0_17ck1960 FIND v(dout0_17) AT=985.025n

.meas tran vdout0_18ck1960 FIND v(dout0_18) AT=985.025n

.meas tran vdout0_19ck1960 FIND v(dout0_19) AT=985.025n

.meas tran vdout0_20ck1960 FIND v(dout0_20) AT=985.025n

.meas tran vdout0_21ck1960 FIND v(dout0_21) AT=985.025n

.meas tran vdout0_22ck1960 FIND v(dout0_22) AT=985.025n

.meas tran vdout0_23ck1960 FIND v(dout0_23) AT=985.025n

.meas tran vdout0_24ck1960 FIND v(dout0_24) AT=985.025n

.meas tran vdout0_25ck1960 FIND v(dout0_25) AT=985.025n

.meas tran vdout0_26ck1960 FIND v(dout0_26) AT=985.025n

.meas tran vdout0_27ck1960 FIND v(dout0_27) AT=985.025n

.meas tran vdout0_28ck1960 FIND v(dout0_28) AT=985.025n

.meas tran vdout0_29ck1960 FIND v(dout0_29) AT=985.025n

.meas tran vdout0_30ck1960 FIND v(dout0_30) AT=985.025n

.meas tran vdout0_31ck1960 FIND v(dout0_31) AT=985.025n

.meas tran vdout0_0ck1970 FIND v(dout0_0) AT=990.025n

.meas tran vdout0_1ck1970 FIND v(dout0_1) AT=990.025n

.meas tran vdout0_2ck1970 FIND v(dout0_2) AT=990.025n

.meas tran vdout0_3ck1970 FIND v(dout0_3) AT=990.025n

.meas tran vdout0_4ck1970 FIND v(dout0_4) AT=990.025n

.meas tran vdout0_5ck1970 FIND v(dout0_5) AT=990.025n

.meas tran vdout0_6ck1970 FIND v(dout0_6) AT=990.025n

.meas tran vdout0_7ck1970 FIND v(dout0_7) AT=990.025n

.meas tran vdout0_8ck1970 FIND v(dout0_8) AT=990.025n

.meas tran vdout0_9ck1970 FIND v(dout0_9) AT=990.025n

.meas tran vdout0_10ck1970 FIND v(dout0_10) AT=990.025n

.meas tran vdout0_11ck1970 FIND v(dout0_11) AT=990.025n

.meas tran vdout0_12ck1970 FIND v(dout0_12) AT=990.025n

.meas tran vdout0_13ck1970 FIND v(dout0_13) AT=990.025n

.meas tran vdout0_14ck1970 FIND v(dout0_14) AT=990.025n

.meas tran vdout0_15ck1970 FIND v(dout0_15) AT=990.025n

.meas tran vdout0_16ck1970 FIND v(dout0_16) AT=990.025n

.meas tran vdout0_17ck1970 FIND v(dout0_17) AT=990.025n

.meas tran vdout0_18ck1970 FIND v(dout0_18) AT=990.025n

.meas tran vdout0_19ck1970 FIND v(dout0_19) AT=990.025n

.meas tran vdout0_20ck1970 FIND v(dout0_20) AT=990.025n

.meas tran vdout0_21ck1970 FIND v(dout0_21) AT=990.025n

.meas tran vdout0_22ck1970 FIND v(dout0_22) AT=990.025n

.meas tran vdout0_23ck1970 FIND v(dout0_23) AT=990.025n

.meas tran vdout0_24ck1970 FIND v(dout0_24) AT=990.025n

.meas tran vdout0_25ck1970 FIND v(dout0_25) AT=990.025n

.meas tran vdout0_26ck1970 FIND v(dout0_26) AT=990.025n

.meas tran vdout0_27ck1970 FIND v(dout0_27) AT=990.025n

.meas tran vdout0_28ck1970 FIND v(dout0_28) AT=990.025n

.meas tran vdout0_29ck1970 FIND v(dout0_29) AT=990.025n

.meas tran vdout0_30ck1970 FIND v(dout0_30) AT=990.025n

.meas tran vdout0_31ck1970 FIND v(dout0_31) AT=990.025n

.meas tran vdout0_0ck1980 FIND v(dout0_0) AT=995.025n

.meas tran vdout0_1ck1980 FIND v(dout0_1) AT=995.025n

.meas tran vdout0_2ck1980 FIND v(dout0_2) AT=995.025n

.meas tran vdout0_3ck1980 FIND v(dout0_3) AT=995.025n

.meas tran vdout0_4ck1980 FIND v(dout0_4) AT=995.025n

.meas tran vdout0_5ck1980 FIND v(dout0_5) AT=995.025n

.meas tran vdout0_6ck1980 FIND v(dout0_6) AT=995.025n

.meas tran vdout0_7ck1980 FIND v(dout0_7) AT=995.025n

.meas tran vdout0_8ck1980 FIND v(dout0_8) AT=995.025n

.meas tran vdout0_9ck1980 FIND v(dout0_9) AT=995.025n

.meas tran vdout0_10ck1980 FIND v(dout0_10) AT=995.025n

.meas tran vdout0_11ck1980 FIND v(dout0_11) AT=995.025n

.meas tran vdout0_12ck1980 FIND v(dout0_12) AT=995.025n

.meas tran vdout0_13ck1980 FIND v(dout0_13) AT=995.025n

.meas tran vdout0_14ck1980 FIND v(dout0_14) AT=995.025n

.meas tran vdout0_15ck1980 FIND v(dout0_15) AT=995.025n

.meas tran vdout0_16ck1980 FIND v(dout0_16) AT=995.025n

.meas tran vdout0_17ck1980 FIND v(dout0_17) AT=995.025n

.meas tran vdout0_18ck1980 FIND v(dout0_18) AT=995.025n

.meas tran vdout0_19ck1980 FIND v(dout0_19) AT=995.025n

.meas tran vdout0_20ck1980 FIND v(dout0_20) AT=995.025n

.meas tran vdout0_21ck1980 FIND v(dout0_21) AT=995.025n

.meas tran vdout0_22ck1980 FIND v(dout0_22) AT=995.025n

.meas tran vdout0_23ck1980 FIND v(dout0_23) AT=995.025n

.meas tran vdout0_24ck1980 FIND v(dout0_24) AT=995.025n

.meas tran vdout0_25ck1980 FIND v(dout0_25) AT=995.025n

.meas tran vdout0_26ck1980 FIND v(dout0_26) AT=995.025n

.meas tran vdout0_27ck1980 FIND v(dout0_27) AT=995.025n

.meas tran vdout0_28ck1980 FIND v(dout0_28) AT=995.025n

.meas tran vdout0_29ck1980 FIND v(dout0_29) AT=995.025n

.meas tran vdout0_30ck1980 FIND v(dout0_30) AT=995.025n

.meas tran vdout0_31ck1980 FIND v(dout0_31) AT=995.025n

.meas tran vdout0_0ck1990 FIND v(dout0_0) AT=1000.025n

.meas tran vdout0_1ck1990 FIND v(dout0_1) AT=1000.025n

.meas tran vdout0_2ck1990 FIND v(dout0_2) AT=1000.025n

.meas tran vdout0_3ck1990 FIND v(dout0_3) AT=1000.025n

.meas tran vdout0_4ck1990 FIND v(dout0_4) AT=1000.025n

.meas tran vdout0_5ck1990 FIND v(dout0_5) AT=1000.025n

.meas tran vdout0_6ck1990 FIND v(dout0_6) AT=1000.025n

.meas tran vdout0_7ck1990 FIND v(dout0_7) AT=1000.025n

.meas tran vdout0_8ck1990 FIND v(dout0_8) AT=1000.025n

.meas tran vdout0_9ck1990 FIND v(dout0_9) AT=1000.025n

.meas tran vdout0_10ck1990 FIND v(dout0_10) AT=1000.025n

.meas tran vdout0_11ck1990 FIND v(dout0_11) AT=1000.025n

.meas tran vdout0_12ck1990 FIND v(dout0_12) AT=1000.025n

.meas tran vdout0_13ck1990 FIND v(dout0_13) AT=1000.025n

.meas tran vdout0_14ck1990 FIND v(dout0_14) AT=1000.025n

.meas tran vdout0_15ck1990 FIND v(dout0_15) AT=1000.025n

.meas tran vdout0_16ck1990 FIND v(dout0_16) AT=1000.025n

.meas tran vdout0_17ck1990 FIND v(dout0_17) AT=1000.025n

.meas tran vdout0_18ck1990 FIND v(dout0_18) AT=1000.025n

.meas tran vdout0_19ck1990 FIND v(dout0_19) AT=1000.025n

.meas tran vdout0_20ck1990 FIND v(dout0_20) AT=1000.025n

.meas tran vdout0_21ck1990 FIND v(dout0_21) AT=1000.025n

.meas tran vdout0_22ck1990 FIND v(dout0_22) AT=1000.025n

.meas tran vdout0_23ck1990 FIND v(dout0_23) AT=1000.025n

.meas tran vdout0_24ck1990 FIND v(dout0_24) AT=1000.025n

.meas tran vdout0_25ck1990 FIND v(dout0_25) AT=1000.025n

.meas tran vdout0_26ck1990 FIND v(dout0_26) AT=1000.025n

.meas tran vdout0_27ck1990 FIND v(dout0_27) AT=1000.025n

.meas tran vdout0_28ck1990 FIND v(dout0_28) AT=1000.025n

.meas tran vdout0_29ck1990 FIND v(dout0_29) AT=1000.025n

.meas tran vdout0_30ck1990 FIND v(dout0_30) AT=1000.025n

.meas tran vdout0_31ck1990 FIND v(dout0_31) AT=1000.025n

.meas tran vdout0_0ck2030 FIND v(dout0_0) AT=1020.025n

.meas tran vdout0_1ck2030 FIND v(dout0_1) AT=1020.025n

.meas tran vdout0_2ck2030 FIND v(dout0_2) AT=1020.025n

.meas tran vdout0_3ck2030 FIND v(dout0_3) AT=1020.025n

.meas tran vdout0_4ck2030 FIND v(dout0_4) AT=1020.025n

.meas tran vdout0_5ck2030 FIND v(dout0_5) AT=1020.025n

.meas tran vdout0_6ck2030 FIND v(dout0_6) AT=1020.025n

.meas tran vdout0_7ck2030 FIND v(dout0_7) AT=1020.025n

.meas tran vdout0_8ck2030 FIND v(dout0_8) AT=1020.025n

.meas tran vdout0_9ck2030 FIND v(dout0_9) AT=1020.025n

.meas tran vdout0_10ck2030 FIND v(dout0_10) AT=1020.025n

.meas tran vdout0_11ck2030 FIND v(dout0_11) AT=1020.025n

.meas tran vdout0_12ck2030 FIND v(dout0_12) AT=1020.025n

.meas tran vdout0_13ck2030 FIND v(dout0_13) AT=1020.025n

.meas tran vdout0_14ck2030 FIND v(dout0_14) AT=1020.025n

.meas tran vdout0_15ck2030 FIND v(dout0_15) AT=1020.025n

.meas tran vdout0_16ck2030 FIND v(dout0_16) AT=1020.025n

.meas tran vdout0_17ck2030 FIND v(dout0_17) AT=1020.025n

.meas tran vdout0_18ck2030 FIND v(dout0_18) AT=1020.025n

.meas tran vdout0_19ck2030 FIND v(dout0_19) AT=1020.025n

.meas tran vdout0_20ck2030 FIND v(dout0_20) AT=1020.025n

.meas tran vdout0_21ck2030 FIND v(dout0_21) AT=1020.025n

.meas tran vdout0_22ck2030 FIND v(dout0_22) AT=1020.025n

.meas tran vdout0_23ck2030 FIND v(dout0_23) AT=1020.025n

.meas tran vdout0_24ck2030 FIND v(dout0_24) AT=1020.025n

.meas tran vdout0_25ck2030 FIND v(dout0_25) AT=1020.025n

.meas tran vdout0_26ck2030 FIND v(dout0_26) AT=1020.025n

.meas tran vdout0_27ck2030 FIND v(dout0_27) AT=1020.025n

.meas tran vdout0_28ck2030 FIND v(dout0_28) AT=1020.025n

.meas tran vdout0_29ck2030 FIND v(dout0_29) AT=1020.025n

.meas tran vdout0_30ck2030 FIND v(dout0_30) AT=1020.025n

.meas tran vdout0_31ck2030 FIND v(dout0_31) AT=1020.025n

.meas tran vdout0_0ck2040 FIND v(dout0_0) AT=1025.025n

.meas tran vdout0_1ck2040 FIND v(dout0_1) AT=1025.025n

.meas tran vdout0_2ck2040 FIND v(dout0_2) AT=1025.025n

.meas tran vdout0_3ck2040 FIND v(dout0_3) AT=1025.025n

.meas tran vdout0_4ck2040 FIND v(dout0_4) AT=1025.025n

.meas tran vdout0_5ck2040 FIND v(dout0_5) AT=1025.025n

.meas tran vdout0_6ck2040 FIND v(dout0_6) AT=1025.025n

.meas tran vdout0_7ck2040 FIND v(dout0_7) AT=1025.025n

.meas tran vdout0_8ck2040 FIND v(dout0_8) AT=1025.025n

.meas tran vdout0_9ck2040 FIND v(dout0_9) AT=1025.025n

.meas tran vdout0_10ck2040 FIND v(dout0_10) AT=1025.025n

.meas tran vdout0_11ck2040 FIND v(dout0_11) AT=1025.025n

.meas tran vdout0_12ck2040 FIND v(dout0_12) AT=1025.025n

.meas tran vdout0_13ck2040 FIND v(dout0_13) AT=1025.025n

.meas tran vdout0_14ck2040 FIND v(dout0_14) AT=1025.025n

.meas tran vdout0_15ck2040 FIND v(dout0_15) AT=1025.025n

.meas tran vdout0_16ck2040 FIND v(dout0_16) AT=1025.025n

.meas tran vdout0_17ck2040 FIND v(dout0_17) AT=1025.025n

.meas tran vdout0_18ck2040 FIND v(dout0_18) AT=1025.025n

.meas tran vdout0_19ck2040 FIND v(dout0_19) AT=1025.025n

.meas tran vdout0_20ck2040 FIND v(dout0_20) AT=1025.025n

.meas tran vdout0_21ck2040 FIND v(dout0_21) AT=1025.025n

.meas tran vdout0_22ck2040 FIND v(dout0_22) AT=1025.025n

.meas tran vdout0_23ck2040 FIND v(dout0_23) AT=1025.025n

.meas tran vdout0_24ck2040 FIND v(dout0_24) AT=1025.025n

.meas tran vdout0_25ck2040 FIND v(dout0_25) AT=1025.025n

.meas tran vdout0_26ck2040 FIND v(dout0_26) AT=1025.025n

.meas tran vdout0_27ck2040 FIND v(dout0_27) AT=1025.025n

.meas tran vdout0_28ck2040 FIND v(dout0_28) AT=1025.025n

.meas tran vdout0_29ck2040 FIND v(dout0_29) AT=1025.025n

.meas tran vdout0_30ck2040 FIND v(dout0_30) AT=1025.025n

.meas tran vdout0_31ck2040 FIND v(dout0_31) AT=1025.025n
