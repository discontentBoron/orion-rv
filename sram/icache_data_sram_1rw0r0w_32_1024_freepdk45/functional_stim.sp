* Functional test stimulus file for 5ns period

* SS process corner
.include "/home/Nischal/Projects/OpenRAM/technology/freepdk45/models/tran_models/models_ss/PMOS_VTG.inc"
.include "/home/Nischal/Projects/OpenRAM/technology/freepdk45/models/tran_models/models_ss/NMOS_VTG.inc"
.include "/tmp/openram_Nischal_2290_temp/sram.sp"

* Global Power Supplies
Vvdd vdd 0 0.95

*Nodes gnd and 0 are the same global ground node in ngspice/hspice/xa. Otherwise, this source may be needed.
Vgnd gnd 0 0.0

* Instantiation of the SRAM
Xicache_data_sram_1rw0r0w_32_1024_freepdk45 din0_0 din0_1 din0_2 din0_3 din0_4 din0_5 din0_6 din0_7 din0_8 din0_9 din0_10 din0_11 din0_12 din0_13 din0_14 din0_15 din0_16 din0_17 din0_18 din0_19 din0_20 din0_21 din0_22 din0_23 din0_24 din0_25 din0_26 din0_27 din0_28 din0_29 din0_30 din0_31 a0_0 a0_1 a0_2 a0_3 a0_4 a0_5 a0_6 a0_7 a0_8 a0_9 CSB0 WEB0 clk0 dout0_0 dout0_1 dout0_2 dout0_3 dout0_4 dout0_5 dout0_6 dout0_7 dout0_8 dout0_9 dout0_10 dout0_11 dout0_12 dout0_13 dout0_14 dout0_15 dout0_16 dout0_17 dout0_18 dout0_19 dout0_20 dout0_21 dout0_22 dout0_23 dout0_24 dout0_25 dout0_26 dout0_27 dout0_28 dout0_29 dout0_30 dout0_31 vdd gnd icache_data_sram_1rw0r0w_32_1024_freepdk45

* SRAM output loads
CD00 dout0_0  0 0.8364f
CD01 dout0_1  0 0.8364f
CD02 dout0_2  0 0.8364f
CD03 dout0_3  0 0.8364f
CD04 dout0_4  0 0.8364f
CD05 dout0_5  0 0.8364f
CD06 dout0_6  0 0.8364f
CD07 dout0_7  0 0.8364f
CD08 dout0_8  0 0.8364f
CD09 dout0_9  0 0.8364f
CD010 dout0_10  0 0.8364f
CD011 dout0_11  0 0.8364f
CD012 dout0_12  0 0.8364f
CD013 dout0_13  0 0.8364f
CD014 dout0_14  0 0.8364f
CD015 dout0_15  0 0.8364f
CD016 dout0_16  0 0.8364f
CD017 dout0_17  0 0.8364f
CD018 dout0_18  0 0.8364f
CD019 dout0_19  0 0.8364f
CD020 dout0_20  0 0.8364f
CD021 dout0_21  0 0.8364f
CD022 dout0_22  0 0.8364f
CD023 dout0_23  0 0.8364f
CD024 dout0_24  0 0.8364f
CD025 dout0_25  0 0.8364f
CD026 dout0_26  0 0.8364f
CD027 dout0_27  0 0.8364f
CD028 dout0_28  0 0.8364f
CD029 dout0_29  0 0.8364f
CD030 dout0_30  0 0.8364f
CD031 dout0_31  0 0.8364f

* Important signals for debug
* bl:	xsram:xbank0:bl_0_0
* br:	xsram:xbank0:br_0_0
* s_en:	xsram:s_en
* q:	xsram:xbank0:xbitcell_array:xbitcell_array:xbit_r0_c0:Q
* qbar:	xsram:xbank0:xbitcell_array:xbitcell_array:xbit_r0_c0:Q_bar

* Sequence of operations
*	Idle during cycle 0 (0ns - 5ns)
*	Writing 00000101001010000101011101000011  to  address 1111111101 (from port 0) during cycle 1 (5ns - 10ns)
*	Writing 11010000010000001100001011010010  to  address 1111111101 (from port 0) during cycle 2 (10ns - 15ns)
*	Writing 00100001100001010111000011000011  to  address 1111111100 (from port 0) during cycle 3 (15ns - 20ns)
*	Reading 11010000010000001100001011010010 from address 1111111101 (from port 0) during cycle 4 (20ns - 25ns)
*	Reading 00100001100001010111000011000011 from address 1111111100 (from port 0) during cycle 5 (25ns - 30ns)
*	Reading 00100001100001010111000011000011 from address 1111111100 (from port 0) during cycle 7 (35ns - 40ns)
*	Reading 00100001100001010111000011000011 from address 1111111100 (from port 0) during cycle 8 (40ns - 45ns)
*	Writing 10110111001111111101001010110011  to  address 0000000011 (from port 0) during cycle 10 (50ns - 55ns)
*	Reading 10110111001111111101001010110011 from address 0000000011 (from port 0) during cycle 11 (55ns - 60ns)
*	Reading 00100001100001010111000011000011 from address 1111111100 (from port 0) during cycle 12 (60ns - 65ns)
*	Writing 10101110000000110011110101101110  to  address 0000000011 (from port 0) during cycle 15 (75ns - 80ns)
*	Reading 11010000010000001100001011010010 from address 1111111101 (from port 0) during cycle 16 (80ns - 85ns)
*	Reading 00100001100001010111000011000011 from address 1111111100 (from port 0) during cycle 17 (85ns - 90ns)
*	Writing 11000110101101111100010000011011  to  address 1111111011 (from port 0) during cycle 19 (95ns - 100ns)
*	Reading 11000110101101111100010000011011 from address 1111111011 (from port 0) during cycle 20 (100ns - 105ns)
*	Reading 11000110101101111100010000011011 from address 1111111011 (from port 0) during cycle 21 (105ns - 110ns)
*	Writing 10011001110010001101000100100000  to  address 1111111101 (from port 0) during cycle 23 (115ns - 120ns)
*	Reading 10101110000000110011110101101110 from address 0000000011 (from port 0) during cycle 24 (120ns - 125ns)
*	Reading 10011001110010001101000100100000 from address 1111111101 (from port 0) during cycle 26 (130ns - 135ns)
*	Writing 11110110000110101000111001100000  to  address 0000000110 (from port 0) during cycle 30 (150ns - 155ns)
*	Reading 00100001100001010111000011000011 from address 1111111100 (from port 0) during cycle 31 (155ns - 160ns)
*	Writing 00111111111111100000001110110100  to  address 1111110111 (from port 0) during cycle 32 (160ns - 165ns)
*	Writing 10011001101100000110100001001001  to  address 1111111110 (from port 0) during cycle 33 (165ns - 170ns)
*	Reading 00100001100001010111000011000011 from address 1111111100 (from port 0) during cycle 34 (170ns - 175ns)
*	Reading 11000110101101111100010000011011 from address 1111111011 (from port 0) during cycle 36 (180ns - 185ns)
*	Reading 10011001110010001101000100100000 from address 1111111101 (from port 0) during cycle 37 (185ns - 190ns)
*	Writing 11101011001000011001110101001010  to  address 1111111101 (from port 0) during cycle 38 (190ns - 195ns)
*	Reading 00111111111111100000001110110100 from address 1111110111 (from port 0) during cycle 40 (200ns - 205ns)
*	Reading 11101011001000011001110101001010 from address 1111111101 (from port 0) during cycle 41 (205ns - 210ns)
*	Reading 10011001101100000110100001001001 from address 1111111110 (from port 0) during cycle 42 (210ns - 215ns)
*	Reading 11110110000110101000111001100000 from address 0000000110 (from port 0) during cycle 44 (220ns - 225ns)
*	Reading 11110110000110101000111001100000 from address 0000000110 (from port 0) during cycle 45 (225ns - 230ns)
*	Reading 11101011001000011001110101001010 from address 1111111101 (from port 0) during cycle 46 (230ns - 235ns)
*	Reading 10011001101100000110100001001001 from address 1111111110 (from port 0) during cycle 47 (235ns - 240ns)
*	Writing 10111010111110000100110100111011  to  address 0000000000 (from port 0) during cycle 48 (240ns - 245ns)
*	Reading 10011001101100000110100001001001 from address 1111111110 (from port 0) during cycle 49 (245ns - 250ns)
*	Writing 01101011001010010001001001111000  to  address 1111111101 (from port 0) during cycle 53 (265ns - 270ns)
*	Reading 00111111111111100000001110110100 from address 1111110111 (from port 0) during cycle 54 (270ns - 275ns)
*	Reading 00100001100001010111000011000011 from address 1111111100 (from port 0) during cycle 55 (275ns - 280ns)
*	Reading 10011001101100000110100001001001 from address 1111111110 (from port 0) during cycle 56 (280ns - 285ns)
*	Writing 00001110101100011000000101110101  to  address 1111111011 (from port 0) during cycle 58 (290ns - 295ns)
*	Reading 10011001101100000110100001001001 from address 1111111110 (from port 0) during cycle 59 (295ns - 300ns)
*	Reading 01101011001010010001001001111000 from address 1111111101 (from port 0) during cycle 60 (300ns - 305ns)
*	Reading 00100001100001010111000011000011 from address 1111111100 (from port 0) during cycle 61 (305ns - 310ns)
*	Reading 00100001100001010111000011000011 from address 1111111100 (from port 0) during cycle 62 (310ns - 315ns)
*	Writing 10001111100101101110000110101011  to  address 1111111010 (from port 0) during cycle 64 (320ns - 325ns)
*	Writing 10111001000011001110010001110101  to  address 1111111110 (from port 0) during cycle 65 (325ns - 330ns)
*	Writing 00100011000010100011000111100110  to  address 0000000101 (from port 0) during cycle 66 (330ns - 335ns)
*	Reading 10001111100101101110000110101011 from address 1111111010 (from port 0) during cycle 69 (345ns - 350ns)
*	Reading 10001111100101101110000110101011 from address 1111111010 (from port 0) during cycle 71 (355ns - 360ns)
*	Reading 00111111111111100000001110110100 from address 1111110111 (from port 0) during cycle 72 (360ns - 365ns)
*	Reading 11110110000110101000111001100000 from address 0000000110 (from port 0) during cycle 73 (365ns - 370ns)
*	Reading 11110110000110101000111001100000 from address 0000000110 (from port 0) during cycle 74 (370ns - 375ns)
*	Reading 00001110101100011000000101110101 from address 1111111011 (from port 0) during cycle 75 (375ns - 380ns)
*	Reading 00100001100001010111000011000011 from address 1111111100 (from port 0) during cycle 77 (385ns - 390ns)
*	Reading 10101110000000110011110101101110 from address 0000000011 (from port 0) during cycle 79 (395ns - 400ns)
*	Reading 10001111100101101110000110101011 from address 1111111010 (from port 0) during cycle 80 (400ns - 405ns)
*	Writing 10011110111000000010110111111101  to  address 0000000010 (from port 0) during cycle 82 (410ns - 415ns)
*	Reading 10001111100101101110000110101011 from address 1111111010 (from port 0) during cycle 83 (415ns - 420ns)
*	Reading 00100011000010100011000111100110 from address 0000000101 (from port 0) during cycle 84 (420ns - 425ns)
*	Writing 00111001011101101000010101110010  to  address 0000000001 (from port 0) during cycle 85 (425ns - 430ns)
*	Reading 10111010111110000100110100111011 from address 0000000000 (from port 0) during cycle 87 (435ns - 440ns)
*	Reading 11110110000110101000111001100000 from address 0000000110 (from port 0) during cycle 90 (450ns - 455ns)
*	Reading 10101110000000110011110101101110 from address 0000000011 (from port 0) during cycle 92 (460ns - 465ns)
*	Reading 10111010111110000100110100111011 from address 0000000000 (from port 0) during cycle 93 (465ns - 470ns)
*	Reading 11110110000110101000111001100000 from address 0000000110 (from port 0) during cycle 94 (470ns - 475ns)
*	Reading 01101011001010010001001001111000 from address 1111111101 (from port 0) during cycle 95 (475ns - 480ns)
*	Reading 10111001000011001110010001110101 from address 1111111110 (from port 0) during cycle 96 (480ns - 485ns)
*	Reading 10101110000000110011110101101110 from address 0000000011 (from port 0) during cycle 97 (485ns - 490ns)
*	Reading 00001110101100011000000101110101 from address 1111111011 (from port 0) during cycle 98 (490ns - 495ns)
*	Reading 00001110101100011000000101110101 from address 1111111011 (from port 0) during cycle 99 (495ns - 500ns)
*	Reading 00001110101100011000000101110101 from address 1111111011 (from port 0) during cycle 101 (505ns - 510ns)
*	Writing 10101001110000011101011000101000  to  address 0000000010 (from port 0) during cycle 102 (510ns - 515ns)
*	Reading 00100001100001010111000011000011 from address 1111111100 (from port 0) during cycle 104 (520ns - 525ns)
*	Writing 00001110111011110011111011101110  to  address 1111111010 (from port 0) during cycle 105 (525ns - 530ns)
*	Writing 00011101111110011001000111110101  to  address 1111111110 (from port 0) during cycle 106 (530ns - 535ns)
*	Reading 00100011000010100011000111100110 from address 0000000101 (from port 0) during cycle 107 (535ns - 540ns)
*	Reading 11110110000110101000111001100000 from address 0000000110 (from port 0) during cycle 109 (545ns - 550ns)
*	Writing 11000010001000010110011110100010  to  address 0000000110 (from port 0) during cycle 110 (550ns - 555ns)
*	Reading 10101001110000011101011000101000 from address 0000000010 (from port 0) during cycle 112 (560ns - 565ns)
*	Reading 00111001011101101000010101110010 from address 0000000001 (from port 0) during cycle 113 (565ns - 570ns)
*	Writing 11110011001000100011110010111010  to  address 1111110111 (from port 0) during cycle 114 (570ns - 575ns)
*	Reading 00011101111110011001000111110101 from address 1111111110 (from port 0) during cycle 116 (580ns - 585ns)
*	Reading 10101001110000011101011000101000 from address 0000000010 (from port 0) during cycle 117 (585ns - 590ns)
*	Writing 11010011111100000110010000101100  to  address 1111111001 (from port 0) during cycle 118 (590ns - 595ns)
*	Reading 01101011001010010001001001111000 from address 1111111101 (from port 0) during cycle 119 (595ns - 600ns)
*	Writing 10110111111001000111101000111000  to  address 0000000100 (from port 0) during cycle 120 (600ns - 605ns)
*	Reading 10101110000000110011110101101110 from address 0000000011 (from port 0) during cycle 121 (605ns - 610ns)
*	Reading 00001110101100011000000101110101 from address 1111111011 (from port 0) during cycle 122 (610ns - 615ns)
*	Writing 00101000001101100110011111000010  to  address 1111110111 (from port 0) during cycle 123 (615ns - 620ns)
*	Reading 00111001011101101000010101110010 from address 0000000001 (from port 0) during cycle 125 (625ns - 630ns)
*	Reading 00101000001101100110011111000010 from address 1111110111 (from port 0) during cycle 126 (630ns - 635ns)
*	Reading 00101000001101100110011111000010 from address 1111110111 (from port 0) during cycle 127 (635ns - 640ns)
*	Reading 00111001011101101000010101110010 from address 0000000001 (from port 0) during cycle 128 (640ns - 645ns)
*	Reading 00001110101100011000000101110101 from address 1111111011 (from port 0) during cycle 129 (645ns - 650ns)
*	Writing 11011010001000111001011100100101  to  address 0000000010 (from port 0) during cycle 131 (655ns - 660ns)
*	Reading 11011010001000111001011100100101 from address 0000000010 (from port 0) during cycle 132 (660ns - 665ns)
*	Reading 10110111111001000111101000111000 from address 0000000100 (from port 0) during cycle 133 (665ns - 670ns)
*	Reading 01101011001010010001001001111000 from address 1111111101 (from port 0) during cycle 134 (670ns - 675ns)
*	Reading 00111001011101101000010101110010 from address 0000000001 (from port 0) during cycle 135 (675ns - 680ns)
*	Reading 00111001011101101000010101110010 from address 0000000001 (from port 0) during cycle 136 (680ns - 685ns)
*	Writing 11111100001001010000011001001111  to  address 0000000001 (from port 0) during cycle 137 (685ns - 690ns)
*	Reading 00100001100001010111000011000011 from address 1111111100 (from port 0) during cycle 139 (695ns - 700ns)
*	Reading 00011101111110011001000111110101 from address 1111111110 (from port 0) during cycle 140 (700ns - 705ns)
*	Reading 00100011000010100011000111100110 from address 0000000101 (from port 0) during cycle 142 (710ns - 715ns)
*	Writing 11101111111000000111000000111010  to  address 1111111101 (from port 0) during cycle 144 (720ns - 725ns)
*	Reading 11011010001000111001011100100101 from address 0000000010 (from port 0) during cycle 145 (725ns - 730ns)
*	Reading 00100011000010100011000111100110 from address 0000000101 (from port 0) during cycle 147 (735ns - 740ns)
*	Reading 00101000001101100110011111000010 from address 1111110111 (from port 0) during cycle 148 (740ns - 745ns)
*	Reading 10110111111001000111101000111000 from address 0000000100 (from port 0) during cycle 150 (750ns - 755ns)
*	Reading 11111100001001010000011001001111 from address 0000000001 (from port 0) during cycle 152 (760ns - 765ns)
*	Reading 00101000001101100110011111000010 from address 1111110111 (from port 0) during cycle 153 (765ns - 770ns)
*	Writing 10101111101011011001000001011011  to  address 1111111001 (from port 0) during cycle 154 (770ns - 775ns)
*	Reading 10111010111110000100110100111011 from address 0000000000 (from port 0) during cycle 155 (775ns - 780ns)
*	Reading 11000010001000010110011110100010 from address 0000000110 (from port 0) during cycle 156 (780ns - 785ns)
*	Reading 00001110111011110011111011101110 from address 1111111010 (from port 0) during cycle 157 (785ns - 790ns)
*	Writing 11100000101000100011011010001110  to  address 1111111100 (from port 0) during cycle 158 (790ns - 795ns)
*	Reading 00101000001101100110011111000010 from address 1111110111 (from port 0) during cycle 159 (795ns - 800ns)
*	Reading 00011101111110011001000111110101 from address 1111111110 (from port 0) during cycle 160 (800ns - 805ns)
*	Reading 11100000101000100011011010001110 from address 1111111100 (from port 0) during cycle 162 (810ns - 815ns)
*	Reading 00001110101100011000000101110101 from address 1111111011 (from port 0) during cycle 163 (815ns - 820ns)
*	Writing 00001110001111101101000110001011  to  address 1111111101 (from port 0) during cycle 164 (820ns - 825ns)
*	Reading 00001110101100011000000101110101 from address 1111111011 (from port 0) during cycle 165 (825ns - 830ns)
*	Writing 11001111000001110111101111101100  to  address 0000000011 (from port 0) during cycle 166 (830ns - 835ns)
*	Reading 11100000101000100011011010001110 from address 1111111100 (from port 0) during cycle 167 (835ns - 840ns)
*	Reading 11000010001000010110011110100010 from address 0000000110 (from port 0) during cycle 168 (840ns - 845ns)
*	Writing 00011001011111110110011101110111  to  address 1111111000 (from port 0) during cycle 169 (845ns - 850ns)
*	Reading 10111010111110000100110100111011 from address 0000000000 (from port 0) during cycle 170 (850ns - 855ns)
*	Writing 11101110000100101000101100000011  to  address 1111111001 (from port 0) during cycle 172 (860ns - 865ns)
*	Reading 11011010001000111001011100100101 from address 0000000010 (from port 0) during cycle 173 (865ns - 870ns)
*	Writing 10000111010011010111110001110110  to  address 1111111000 (from port 0) during cycle 175 (875ns - 880ns)
*	Reading 00101000001101100110011111000010 from address 1111110111 (from port 0) during cycle 176 (880ns - 885ns)
*	Reading 11100000101000100011011010001110 from address 1111111100 (from port 0) during cycle 177 (885ns - 890ns)
*	Reading 11000010001000010110011110100010 from address 0000000110 (from port 0) during cycle 178 (890ns - 895ns)
*	Reading 11011010001000111001011100100101 from address 0000000010 (from port 0) during cycle 179 (895ns - 900ns)
*	Writing 10111000011101110111100111111100  to  address 1111111100 (from port 0) during cycle 180 (900ns - 905ns)
*	Writing 10100010101001111101110110011100  to  address 1111111001 (from port 0) during cycle 181 (905ns - 910ns)
*	Reading 10111010111110000100110100111011 from address 0000000000 (from port 0) during cycle 182 (910ns - 915ns)
*	Reading 00100011000010100011000111100110 from address 0000000101 (from port 0) during cycle 184 (920ns - 925ns)
*	Reading 00001110111011110011111011101110 from address 1111111010 (from port 0) during cycle 185 (925ns - 930ns)
*	Reading 11111100001001010000011001001111 from address 0000000001 (from port 0) during cycle 186 (930ns - 935ns)
*	Writing 00000001111010010001111101001000  to  address 0000000110 (from port 0) during cycle 187 (935ns - 940ns)
*	Writing 10001001000001111111010001011110  to  address 1111111000 (from port 0) during cycle 188 (940ns - 945ns)
*	Reading 10110111111001000111101000111000 from address 0000000100 (from port 0) during cycle 189 (945ns - 950ns)
*	Reading 10001001000001111111010001011110 from address 1111111000 (from port 0) during cycle 190 (950ns - 955ns)
*	Reading 10100010101001111101110110011100 from address 1111111001 (from port 0) during cycle 192 (960ns - 965ns)
*	Reading 00100011000010100011000111100110 from address 0000000101 (from port 0) during cycle 193 (965ns - 970ns)
*	Writing 01000110110001011011000110101101  to  address 0000000101 (from port 0) during cycle 194 (970ns - 975ns)
*	Reading 00001110101100011000000101110101 from address 1111111011 (from port 0) during cycle 195 (975ns - 980ns)
*	Reading 00000001111010010001111101001000 from address 0000000110 (from port 0) during cycle 196 (980ns - 985ns)
*	Reading 01000110110001011011000110101101 from address 0000000101 (from port 0) during cycle 197 (985ns - 990ns)
*	Reading 01000110110001011011000110101101 from address 0000000101 (from port 0) during cycle 198 (990ns - 995ns)
*	Reading 10001001000001111111010001011110 from address 1111111000 (from port 0) during cycle 199 (995ns - 1000ns)
*	Writing 00101011100010000101000110010000  to  address 1111111001 (from port 0) during cycle 200 (1000ns - 1005ns)
*	Reading 00101011100010000101000110010000 from address 1111111001 (from port 0) during cycle 203 (1015ns - 1020ns)
*	Reading 00011101111110011001000111110101 from address 1111111110 (from port 0) during cycle 204 (1020ns - 1025ns)
*	Idle during cycle 205 (1025ns - 1030ns)

* Generation of data and address signals
* (time, data): [(0, 0), (5, 1), (10, 0), (15, 1), (20, 1), (25, 1), (30, 1), (35, 1), (40, 1), (45, 1), (50, 1), (55, 1), (60, 1), (65, 1), (70, 1), (75, 0), (80, 0), (85, 0), (90, 0), (95, 1), (100, 1), (105, 1), (110, 1), (115, 0), (120, 0), (125, 0), (130, 0), (135, 0), (140, 0), (145, 0), (150, 0), (155, 0), (160, 0), (165, 1), (170, 1), (175, 1), (180, 1), (185, 1), (190, 0), (195, 0), (200, 0), (205, 0), (210, 0), (215, 0), (220, 0), (225, 0), (230, 0), (235, 0), (240, 1), (245, 1), (250, 1), (255, 1), (260, 1), (265, 0), (270, 0), (275, 0), (280, 0), (285, 0), (290, 1), (295, 1), (300, 1), (305, 1), (310, 1), (315, 1), (320, 1), (325, 1), (330, 0), (335, 0), (340, 0), (345, 0), (350, 0), (355, 0), (360, 0), (365, 0), (370, 0), (375, 0), (380, 0), (385, 0), (390, 0), (395, 0), (400, 0), (405, 0), (410, 1), (415, 1), (420, 1), (425, 0), (430, 0), (435, 0), (440, 0), (445, 0), (450, 0), (455, 0), (460, 0), (465, 0), (470, 0), (475, 0), (480, 0), (485, 0), (490, 0), (495, 0), (500, 0), (505, 0), (510, 0), (515, 0), (520, 0), (525, 0), (530, 1), (535, 1), (540, 1), (545, 1), (550, 0), (555, 0), (560, 0), (565, 0), (570, 0), (575, 0), (580, 0), (585, 0), (590, 0), (595, 0), (600, 0), (605, 0), (610, 0), (615, 0), (620, 0), (625, 0), (630, 0), (635, 0), (640, 0), (645, 0), (650, 0), (655, 1), (660, 1), (665, 1), (670, 1), (675, 1), (680, 1), (685, 1), (690, 1), (695, 1), (700, 1), (705, 1), (710, 1), (715, 1), (720, 0), (725, 0), (730, 0), (735, 0), (740, 0), (745, 0), (750, 0), (755, 0), (760, 0), (765, 0), (770, 1), (775, 1), (780, 1), (785, 1), (790, 0), (795, 0), (800, 0), (805, 0), (810, 0), (815, 0), (820, 1), (825, 1), (830, 0), (835, 0), (840, 0), (845, 1), (850, 1), (855, 1), (860, 1), (865, 1), (870, 1), (875, 0), (880, 0), (885, 0), (890, 0), (895, 0), (900, 0), (905, 0), (910, 0), (915, 0), (920, 0), (925, 0), (930, 0), (935, 0), (940, 0), (945, 0), (950, 0), (955, 0), (960, 0), (965, 0), (970, 1), (975, 1), (980, 1), (985, 1), (990, 1), (995, 1), (1000, 0), (1005, 0), (1010, 0), (1015, 0), (1020, 0), (1025, 0)]
Vdin0_0  din0_0  0 PWL (0n 0.0v 4.745n 0.0v 4.755n 0.95v 9.745n 0.95v 9.755n 0.0v 14.745n 0.0v 14.755n 0.95v 19.745n 0.95v 19.755n 0.95v 24.745n 0.95v 24.755n 0.95v 29.745n 0.95v 29.755n 0.95v 34.745n 0.95v 34.755n 0.95v 39.745n 0.95v 39.755n 0.95v 44.745n 0.95v 44.755n 0.95v 49.745n 0.95v 49.755n 0.95v 54.745n 0.95v 54.755n 0.95v 59.745n 0.95v 59.755n 0.95v 64.745n 0.95v 64.755n 0.95v 69.745n 0.95v 69.755n 0.95v 74.745n 0.95v 74.755n 0.0v 79.745n 0.0v 79.755n 0.0v 84.745n 0.0v 84.755n 0.0v 89.745n 0.0v 89.755n 0.0v 94.745n 0.0v 94.755n 0.95v 99.745n 0.95v 99.755n 0.95v 104.745n 0.95v 104.755n 0.95v 109.745n 0.95v 109.755n 0.95v 114.745n 0.95v 114.755n 0.0v 119.745n 0.0v 119.755n 0.0v 124.745n 0.0v 124.755n 0.0v 129.745n 0.0v 129.755n 0.0v 134.745n 0.0v 134.755n 0.0v 139.745n 0.0v 139.755n 0.0v 144.745n 0.0v 144.755n 0.0v 149.745n 0.0v 149.755n 0.0v 154.745n 0.0v 154.755n 0.0v 159.745n 0.0v 159.755n 0.0v 164.745n 0.0v 164.755n 0.95v 169.745n 0.95v 169.755n 0.95v 174.745n 0.95v 174.755n 0.95v 179.745n 0.95v 179.755n 0.95v 184.745n 0.95v 184.755n 0.95v 189.745n 0.95v 189.755n 0.0v 194.745n 0.0v 194.755n 0.0v 199.745n 0.0v 199.755n 0.0v 204.745n 0.0v 204.755n 0.0v 209.745n 0.0v 209.755n 0.0v 214.745n 0.0v 214.755n 0.0v 219.745n 0.0v 219.755n 0.0v 224.745n 0.0v 224.755n 0.0v 229.745n 0.0v 229.755n 0.0v 234.745n 0.0v 234.755n 0.0v 239.745n 0.0v 239.755n 0.95v 244.745n 0.95v 244.755n 0.95v 249.745n 0.95v 249.755n 0.95v 254.745n 0.95v 254.755n 0.95v 259.745n 0.95v 259.755n 0.95v 264.745n 0.95v 264.755n 0.0v 269.745n 0.0v 269.755n 0.0v 274.745n 0.0v 274.755n 0.0v 279.745n 0.0v 279.755n 0.0v 284.745n 0.0v 284.755n 0.0v 289.745n 0.0v 289.755n 0.95v 294.745n 0.95v 294.755n 0.95v 299.745n 0.95v 299.755n 0.95v 304.745n 0.95v 304.755n 0.95v 309.745n 0.95v 309.755n 0.95v 314.745n 0.95v 314.755n 0.95v 319.745n 0.95v 319.755n 0.95v 324.745n 0.95v 324.755n 0.95v 329.745n 0.95v 329.755n 0.0v 334.745n 0.0v 334.755n 0.0v 339.745n 0.0v 339.755n 0.0v 344.745n 0.0v 344.755n 0.0v 349.745n 0.0v 349.755n 0.0v 354.745n 0.0v 354.755n 0.0v 359.745n 0.0v 359.755n 0.0v 364.745n 0.0v 364.755n 0.0v 369.745n 0.0v 369.755n 0.0v 374.745n 0.0v 374.755n 0.0v 379.745n 0.0v 379.755n 0.0v 384.745n 0.0v 384.755n 0.0v 389.745n 0.0v 389.755n 0.0v 394.745n 0.0v 394.755n 0.0v 399.745n 0.0v 399.755n 0.0v 404.745n 0.0v 404.755n 0.0v 409.745n 0.0v 409.755n 0.95v 414.745n 0.95v 414.755n 0.95v 419.745n 0.95v 419.755n 0.95v 424.745n 0.95v 424.755n 0.0v 429.745n 0.0v 429.755n 0.0v 434.745n 0.0v 434.755n 0.0v 439.745n 0.0v 439.755n 0.0v 444.745n 0.0v 444.755n 0.0v 449.745n 0.0v 449.755n 0.0v 454.745n 0.0v 454.755n 0.0v 459.745n 0.0v 459.755n 0.0v 464.745n 0.0v 464.755n 0.0v 469.745n 0.0v 469.755n 0.0v 474.745n 0.0v 474.755n 0.0v 479.745n 0.0v 479.755n 0.0v 484.745n 0.0v 484.755n 0.0v 489.745n 0.0v 489.755n 0.0v 494.745n 0.0v 494.755n 0.0v 499.745n 0.0v 499.755n 0.0v 504.745n 0.0v 504.755n 0.0v 509.745n 0.0v 509.755n 0.0v 514.745n 0.0v 514.755n 0.0v 519.745n 0.0v 519.755n 0.0v 524.745n 0.0v 524.755n 0.0v 529.745n 0.0v 529.755n 0.95v 534.745n 0.95v 534.755n 0.95v 539.745n 0.95v 539.755n 0.95v 544.745n 0.95v 544.755n 0.95v 549.745n 0.95v 549.755n 0.0v 554.745n 0.0v 554.755n 0.0v 559.745n 0.0v 559.755n 0.0v 564.745n 0.0v 564.755n 0.0v 569.745n 0.0v 569.755n 0.0v 574.745n 0.0v 574.755n 0.0v 579.745n 0.0v 579.755n 0.0v 584.745n 0.0v 584.755n 0.0v 589.745n 0.0v 589.755n 0.0v 594.745n 0.0v 594.755n 0.0v 599.745n 0.0v 599.755n 0.0v 604.745n 0.0v 604.755n 0.0v 609.745n 0.0v 609.755n 0.0v 614.745n 0.0v 614.755n 0.0v 619.745n 0.0v 619.755n 0.0v 624.745n 0.0v 624.755n 0.0v 629.745n 0.0v 629.755n 0.0v 634.745n 0.0v 634.755n 0.0v 639.745n 0.0v 639.755n 0.0v 644.745n 0.0v 644.755n 0.0v 649.745n 0.0v 649.755n 0.0v 654.745n 0.0v 654.755n 0.95v 659.745n 0.95v 659.755n 0.95v 664.745n 0.95v 664.755n 0.95v 669.745n 0.95v 669.755n 0.95v 674.745n 0.95v 674.755n 0.95v 679.745n 0.95v 679.755n 0.95v 684.745n 0.95v 684.755n 0.95v 689.745n 0.95v 689.755n 0.95v 694.745n 0.95v 694.755n 0.95v 699.745n 0.95v 699.755n 0.95v 704.745n 0.95v 704.755n 0.95v 709.745n 0.95v 709.755n 0.95v 714.745n 0.95v 714.755n 0.95v 719.745n 0.95v 719.755n 0.0v 724.745n 0.0v 724.755n 0.0v 729.745n 0.0v 729.755n 0.0v 734.745n 0.0v 734.755n 0.0v 739.745n 0.0v 739.755n 0.0v 744.745n 0.0v 744.755n 0.0v 749.745n 0.0v 749.755n 0.0v 754.745n 0.0v 754.755n 0.0v 759.745n 0.0v 759.755n 0.0v 764.745n 0.0v 764.755n 0.0v 769.745n 0.0v 769.755n 0.95v 774.745n 0.95v 774.755n 0.95v 779.745n 0.95v 779.755n 0.95v 784.745n 0.95v 784.755n 0.95v 789.745n 0.95v 789.755n 0.0v 794.745n 0.0v 794.755n 0.0v 799.745n 0.0v 799.755n 0.0v 804.745n 0.0v 804.755n 0.0v 809.745n 0.0v 809.755n 0.0v 814.745n 0.0v 814.755n 0.0v 819.745n 0.0v 819.755n 0.95v 824.745n 0.95v 824.755n 0.95v 829.745n 0.95v 829.755n 0.0v 834.745n 0.0v 834.755n 0.0v 839.745n 0.0v 839.755n 0.0v 844.745n 0.0v 844.755n 0.95v 849.745n 0.95v 849.755n 0.95v 854.745n 0.95v 854.755n 0.95v 859.745n 0.95v 859.755n 0.95v 864.745n 0.95v 864.755n 0.95v 869.745n 0.95v 869.755n 0.95v 874.745n 0.95v 874.755n 0.0v 879.745n 0.0v 879.755n 0.0v 884.745n 0.0v 884.755n 0.0v 889.745n 0.0v 889.755n 0.0v 894.745n 0.0v 894.755n 0.0v 899.745n 0.0v 899.755n 0.0v 904.745n 0.0v 904.755n 0.0v 909.745n 0.0v 909.755n 0.0v 914.745n 0.0v 914.755n 0.0v 919.745n 0.0v 919.755n 0.0v 924.745n 0.0v 924.755n 0.0v 929.745n 0.0v 929.755n 0.0v 934.745n 0.0v 934.755n 0.0v 939.745n 0.0v 939.755n 0.0v 944.745n 0.0v 944.755n 0.0v 949.745n 0.0v 949.755n 0.0v 954.745n 0.0v 954.755n 0.0v 959.745n 0.0v 959.755n 0.0v 964.745n 0.0v 964.755n 0.0v 969.745n 0.0v 969.755n 0.95v 974.745n 0.95v 974.755n 0.95v 979.745n 0.95v 979.755n 0.95v 984.745n 0.95v 984.755n 0.95v 989.745n 0.95v 989.755n 0.95v 994.745n 0.95v 994.755n 0.95v 999.745n 0.95v 999.755n 0.0v 1004.745n 0.0v 1004.755n 0.0v 1009.745n 0.0v 1009.755n 0.0v 1014.745n 0.0v 1014.755n 0.0v 1019.745n 0.0v 1019.755n 0.0v 1024.745n 0.0v 1024.755n 0.0v )
* (time, data): [(0, 0), (5, 1), (10, 1), (15, 1), (20, 1), (25, 1), (30, 1), (35, 1), (40, 1), (45, 1), (50, 1), (55, 1), (60, 1), (65, 1), (70, 1), (75, 1), (80, 1), (85, 1), (90, 1), (95, 1), (100, 1), (105, 1), (110, 1), (115, 0), (120, 0), (125, 0), (130, 0), (135, 0), (140, 0), (145, 0), (150, 0), (155, 0), (160, 0), (165, 0), (170, 0), (175, 0), (180, 0), (185, 0), (190, 1), (195, 1), (200, 1), (205, 1), (210, 1), (215, 1), (220, 1), (225, 1), (230, 1), (235, 1), (240, 1), (245, 1), (250, 1), (255, 1), (260, 1), (265, 0), (270, 0), (275, 0), (280, 0), (285, 0), (290, 0), (295, 0), (300, 0), (305, 0), (310, 0), (315, 0), (320, 1), (325, 0), (330, 1), (335, 1), (340, 1), (345, 1), (350, 1), (355, 1), (360, 1), (365, 1), (370, 1), (375, 1), (380, 1), (385, 1), (390, 1), (395, 1), (400, 1), (405, 1), (410, 0), (415, 0), (420, 0), (425, 1), (430, 1), (435, 1), (440, 1), (445, 1), (450, 1), (455, 1), (460, 1), (465, 1), (470, 1), (475, 1), (480, 1), (485, 1), (490, 1), (495, 1), (500, 1), (505, 1), (510, 0), (515, 0), (520, 0), (525, 1), (530, 0), (535, 0), (540, 0), (545, 0), (550, 1), (555, 1), (560, 1), (565, 1), (570, 1), (575, 1), (580, 1), (585, 1), (590, 0), (595, 0), (600, 0), (605, 0), (610, 0), (615, 1), (620, 1), (625, 1), (630, 1), (635, 1), (640, 1), (645, 1), (650, 1), (655, 0), (660, 0), (665, 0), (670, 0), (675, 0), (680, 0), (685, 1), (690, 1), (695, 1), (700, 1), (705, 1), (710, 1), (715, 1), (720, 1), (725, 1), (730, 1), (735, 1), (740, 1), (745, 1), (750, 1), (755, 1), (760, 1), (765, 1), (770, 1), (775, 1), (780, 1), (785, 1), (790, 1), (795, 1), (800, 1), (805, 1), (810, 1), (815, 1), (820, 1), (825, 1), (830, 0), (835, 0), (840, 0), (845, 1), (850, 1), (855, 1), (860, 1), (865, 1), (870, 1), (875, 1), (880, 1), (885, 1), (890, 1), (895, 1), (900, 0), (905, 0), (910, 0), (915, 0), (920, 0), (925, 0), (930, 0), (935, 0), (940, 1), (945, 1), (950, 1), (955, 1), (960, 1), (965, 1), (970, 0), (975, 0), (980, 0), (985, 0), (990, 0), (995, 0), (1000, 0), (1005, 0), (1010, 0), (1015, 0), (1020, 0), (1025, 0)]
Vdin0_1  din0_1  0 PWL (0n 0.0v 4.745n 0.0v 4.755n 0.95v 9.745n 0.95v 9.755n 0.95v 14.745n 0.95v 14.755n 0.95v 19.745n 0.95v 19.755n 0.95v 24.745n 0.95v 24.755n 0.95v 29.745n 0.95v 29.755n 0.95v 34.745n 0.95v 34.755n 0.95v 39.745n 0.95v 39.755n 0.95v 44.745n 0.95v 44.755n 0.95v 49.745n 0.95v 49.755n 0.95v 54.745n 0.95v 54.755n 0.95v 59.745n 0.95v 59.755n 0.95v 64.745n 0.95v 64.755n 0.95v 69.745n 0.95v 69.755n 0.95v 74.745n 0.95v 74.755n 0.95v 79.745n 0.95v 79.755n 0.95v 84.745n 0.95v 84.755n 0.95v 89.745n 0.95v 89.755n 0.95v 94.745n 0.95v 94.755n 0.95v 99.745n 0.95v 99.755n 0.95v 104.745n 0.95v 104.755n 0.95v 109.745n 0.95v 109.755n 0.95v 114.745n 0.95v 114.755n 0.0v 119.745n 0.0v 119.755n 0.0v 124.745n 0.0v 124.755n 0.0v 129.745n 0.0v 129.755n 0.0v 134.745n 0.0v 134.755n 0.0v 139.745n 0.0v 139.755n 0.0v 144.745n 0.0v 144.755n 0.0v 149.745n 0.0v 149.755n 0.0v 154.745n 0.0v 154.755n 0.0v 159.745n 0.0v 159.755n 0.0v 164.745n 0.0v 164.755n 0.0v 169.745n 0.0v 169.755n 0.0v 174.745n 0.0v 174.755n 0.0v 179.745n 0.0v 179.755n 0.0v 184.745n 0.0v 184.755n 0.0v 189.745n 0.0v 189.755n 0.95v 194.745n 0.95v 194.755n 0.95v 199.745n 0.95v 199.755n 0.95v 204.745n 0.95v 204.755n 0.95v 209.745n 0.95v 209.755n 0.95v 214.745n 0.95v 214.755n 0.95v 219.745n 0.95v 219.755n 0.95v 224.745n 0.95v 224.755n 0.95v 229.745n 0.95v 229.755n 0.95v 234.745n 0.95v 234.755n 0.95v 239.745n 0.95v 239.755n 0.95v 244.745n 0.95v 244.755n 0.95v 249.745n 0.95v 249.755n 0.95v 254.745n 0.95v 254.755n 0.95v 259.745n 0.95v 259.755n 0.95v 264.745n 0.95v 264.755n 0.0v 269.745n 0.0v 269.755n 0.0v 274.745n 0.0v 274.755n 0.0v 279.745n 0.0v 279.755n 0.0v 284.745n 0.0v 284.755n 0.0v 289.745n 0.0v 289.755n 0.0v 294.745n 0.0v 294.755n 0.0v 299.745n 0.0v 299.755n 0.0v 304.745n 0.0v 304.755n 0.0v 309.745n 0.0v 309.755n 0.0v 314.745n 0.0v 314.755n 0.0v 319.745n 0.0v 319.755n 0.95v 324.745n 0.95v 324.755n 0.0v 329.745n 0.0v 329.755n 0.95v 334.745n 0.95v 334.755n 0.95v 339.745n 0.95v 339.755n 0.95v 344.745n 0.95v 344.755n 0.95v 349.745n 0.95v 349.755n 0.95v 354.745n 0.95v 354.755n 0.95v 359.745n 0.95v 359.755n 0.95v 364.745n 0.95v 364.755n 0.95v 369.745n 0.95v 369.755n 0.95v 374.745n 0.95v 374.755n 0.95v 379.745n 0.95v 379.755n 0.95v 384.745n 0.95v 384.755n 0.95v 389.745n 0.95v 389.755n 0.95v 394.745n 0.95v 394.755n 0.95v 399.745n 0.95v 399.755n 0.95v 404.745n 0.95v 404.755n 0.95v 409.745n 0.95v 409.755n 0.0v 414.745n 0.0v 414.755n 0.0v 419.745n 0.0v 419.755n 0.0v 424.745n 0.0v 424.755n 0.95v 429.745n 0.95v 429.755n 0.95v 434.745n 0.95v 434.755n 0.95v 439.745n 0.95v 439.755n 0.95v 444.745n 0.95v 444.755n 0.95v 449.745n 0.95v 449.755n 0.95v 454.745n 0.95v 454.755n 0.95v 459.745n 0.95v 459.755n 0.95v 464.745n 0.95v 464.755n 0.95v 469.745n 0.95v 469.755n 0.95v 474.745n 0.95v 474.755n 0.95v 479.745n 0.95v 479.755n 0.95v 484.745n 0.95v 484.755n 0.95v 489.745n 0.95v 489.755n 0.95v 494.745n 0.95v 494.755n 0.95v 499.745n 0.95v 499.755n 0.95v 504.745n 0.95v 504.755n 0.95v 509.745n 0.95v 509.755n 0.0v 514.745n 0.0v 514.755n 0.0v 519.745n 0.0v 519.755n 0.0v 524.745n 0.0v 524.755n 0.95v 529.745n 0.95v 529.755n 0.0v 534.745n 0.0v 534.755n 0.0v 539.745n 0.0v 539.755n 0.0v 544.745n 0.0v 544.755n 0.0v 549.745n 0.0v 549.755n 0.95v 554.745n 0.95v 554.755n 0.95v 559.745n 0.95v 559.755n 0.95v 564.745n 0.95v 564.755n 0.95v 569.745n 0.95v 569.755n 0.95v 574.745n 0.95v 574.755n 0.95v 579.745n 0.95v 579.755n 0.95v 584.745n 0.95v 584.755n 0.95v 589.745n 0.95v 589.755n 0.0v 594.745n 0.0v 594.755n 0.0v 599.745n 0.0v 599.755n 0.0v 604.745n 0.0v 604.755n 0.0v 609.745n 0.0v 609.755n 0.0v 614.745n 0.0v 614.755n 0.95v 619.745n 0.95v 619.755n 0.95v 624.745n 0.95v 624.755n 0.95v 629.745n 0.95v 629.755n 0.95v 634.745n 0.95v 634.755n 0.95v 639.745n 0.95v 639.755n 0.95v 644.745n 0.95v 644.755n 0.95v 649.745n 0.95v 649.755n 0.95v 654.745n 0.95v 654.755n 0.0v 659.745n 0.0v 659.755n 0.0v 664.745n 0.0v 664.755n 0.0v 669.745n 0.0v 669.755n 0.0v 674.745n 0.0v 674.755n 0.0v 679.745n 0.0v 679.755n 0.0v 684.745n 0.0v 684.755n 0.95v 689.745n 0.95v 689.755n 0.95v 694.745n 0.95v 694.755n 0.95v 699.745n 0.95v 699.755n 0.95v 704.745n 0.95v 704.755n 0.95v 709.745n 0.95v 709.755n 0.95v 714.745n 0.95v 714.755n 0.95v 719.745n 0.95v 719.755n 0.95v 724.745n 0.95v 724.755n 0.95v 729.745n 0.95v 729.755n 0.95v 734.745n 0.95v 734.755n 0.95v 739.745n 0.95v 739.755n 0.95v 744.745n 0.95v 744.755n 0.95v 749.745n 0.95v 749.755n 0.95v 754.745n 0.95v 754.755n 0.95v 759.745n 0.95v 759.755n 0.95v 764.745n 0.95v 764.755n 0.95v 769.745n 0.95v 769.755n 0.95v 774.745n 0.95v 774.755n 0.95v 779.745n 0.95v 779.755n 0.95v 784.745n 0.95v 784.755n 0.95v 789.745n 0.95v 789.755n 0.95v 794.745n 0.95v 794.755n 0.95v 799.745n 0.95v 799.755n 0.95v 804.745n 0.95v 804.755n 0.95v 809.745n 0.95v 809.755n 0.95v 814.745n 0.95v 814.755n 0.95v 819.745n 0.95v 819.755n 0.95v 824.745n 0.95v 824.755n 0.95v 829.745n 0.95v 829.755n 0.0v 834.745n 0.0v 834.755n 0.0v 839.745n 0.0v 839.755n 0.0v 844.745n 0.0v 844.755n 0.95v 849.745n 0.95v 849.755n 0.95v 854.745n 0.95v 854.755n 0.95v 859.745n 0.95v 859.755n 0.95v 864.745n 0.95v 864.755n 0.95v 869.745n 0.95v 869.755n 0.95v 874.745n 0.95v 874.755n 0.95v 879.745n 0.95v 879.755n 0.95v 884.745n 0.95v 884.755n 0.95v 889.745n 0.95v 889.755n 0.95v 894.745n 0.95v 894.755n 0.95v 899.745n 0.95v 899.755n 0.0v 904.745n 0.0v 904.755n 0.0v 909.745n 0.0v 909.755n 0.0v 914.745n 0.0v 914.755n 0.0v 919.745n 0.0v 919.755n 0.0v 924.745n 0.0v 924.755n 0.0v 929.745n 0.0v 929.755n 0.0v 934.745n 0.0v 934.755n 0.0v 939.745n 0.0v 939.755n 0.95v 944.745n 0.95v 944.755n 0.95v 949.745n 0.95v 949.755n 0.95v 954.745n 0.95v 954.755n 0.95v 959.745n 0.95v 959.755n 0.95v 964.745n 0.95v 964.755n 0.95v 969.745n 0.95v 969.755n 0.0v 974.745n 0.0v 974.755n 0.0v 979.745n 0.0v 979.755n 0.0v 984.745n 0.0v 984.755n 0.0v 989.745n 0.0v 989.755n 0.0v 994.745n 0.0v 994.755n 0.0v 999.745n 0.0v 999.755n 0.0v 1004.745n 0.0v 1004.755n 0.0v 1009.745n 0.0v 1009.755n 0.0v 1014.745n 0.0v 1014.755n 0.0v 1019.745n 0.0v 1019.755n 0.0v 1024.745n 0.0v 1024.755n 0.0v )
* (time, data): [(0, 0), (5, 0), (10, 0), (15, 0), (20, 0), (25, 0), (30, 0), (35, 0), (40, 0), (45, 0), (50, 0), (55, 0), (60, 0), (65, 0), (70, 0), (75, 1), (80, 1), (85, 1), (90, 1), (95, 0), (100, 0), (105, 0), (110, 0), (115, 0), (120, 0), (125, 0), (130, 0), (135, 0), (140, 0), (145, 0), (150, 0), (155, 0), (160, 1), (165, 0), (170, 0), (175, 0), (180, 0), (185, 0), (190, 0), (195, 0), (200, 0), (205, 0), (210, 0), (215, 0), (220, 0), (225, 0), (230, 0), (235, 0), (240, 0), (245, 0), (250, 0), (255, 0), (260, 0), (265, 0), (270, 0), (275, 0), (280, 0), (285, 0), (290, 1), (295, 1), (300, 1), (305, 1), (310, 1), (315, 1), (320, 0), (325, 1), (330, 1), (335, 1), (340, 1), (345, 1), (350, 1), (355, 1), (360, 1), (365, 1), (370, 1), (375, 1), (380, 1), (385, 1), (390, 1), (395, 1), (400, 1), (405, 1), (410, 1), (415, 1), (420, 1), (425, 0), (430, 0), (435, 0), (440, 0), (445, 0), (450, 0), (455, 0), (460, 0), (465, 0), (470, 0), (475, 0), (480, 0), (485, 0), (490, 0), (495, 0), (500, 0), (505, 0), (510, 0), (515, 0), (520, 0), (525, 1), (530, 1), (535, 1), (540, 1), (545, 1), (550, 0), (555, 0), (560, 0), (565, 0), (570, 0), (575, 0), (580, 0), (585, 0), (590, 1), (595, 1), (600, 0), (605, 0), (610, 0), (615, 0), (620, 0), (625, 0), (630, 0), (635, 0), (640, 0), (645, 0), (650, 0), (655, 1), (660, 1), (665, 1), (670, 1), (675, 1), (680, 1), (685, 1), (690, 1), (695, 1), (700, 1), (705, 1), (710, 1), (715, 1), (720, 0), (725, 0), (730, 0), (735, 0), (740, 0), (745, 0), (750, 0), (755, 0), (760, 0), (765, 0), (770, 0), (775, 0), (780, 0), (785, 0), (790, 1), (795, 1), (800, 1), (805, 1), (810, 1), (815, 1), (820, 0), (825, 0), (830, 1), (835, 1), (840, 1), (845, 1), (850, 1), (855, 1), (860, 0), (865, 0), (870, 0), (875, 1), (880, 1), (885, 1), (890, 1), (895, 1), (900, 1), (905, 1), (910, 1), (915, 1), (920, 1), (925, 1), (930, 1), (935, 0), (940, 1), (945, 1), (950, 1), (955, 1), (960, 1), (965, 1), (970, 1), (975, 1), (980, 1), (985, 1), (990, 1), (995, 1), (1000, 0), (1005, 0), (1010, 0), (1015, 0), (1020, 0), (1025, 0)]
Vdin0_2  din0_2  0 PWL (0n 0.0v 4.745n 0.0v 4.755n 0.0v 9.745n 0.0v 9.755n 0.0v 14.745n 0.0v 14.755n 0.0v 19.745n 0.0v 19.755n 0.0v 24.745n 0.0v 24.755n 0.0v 29.745n 0.0v 29.755n 0.0v 34.745n 0.0v 34.755n 0.0v 39.745n 0.0v 39.755n 0.0v 44.745n 0.0v 44.755n 0.0v 49.745n 0.0v 49.755n 0.0v 54.745n 0.0v 54.755n 0.0v 59.745n 0.0v 59.755n 0.0v 64.745n 0.0v 64.755n 0.0v 69.745n 0.0v 69.755n 0.0v 74.745n 0.0v 74.755n 0.95v 79.745n 0.95v 79.755n 0.95v 84.745n 0.95v 84.755n 0.95v 89.745n 0.95v 89.755n 0.95v 94.745n 0.95v 94.755n 0.0v 99.745n 0.0v 99.755n 0.0v 104.745n 0.0v 104.755n 0.0v 109.745n 0.0v 109.755n 0.0v 114.745n 0.0v 114.755n 0.0v 119.745n 0.0v 119.755n 0.0v 124.745n 0.0v 124.755n 0.0v 129.745n 0.0v 129.755n 0.0v 134.745n 0.0v 134.755n 0.0v 139.745n 0.0v 139.755n 0.0v 144.745n 0.0v 144.755n 0.0v 149.745n 0.0v 149.755n 0.0v 154.745n 0.0v 154.755n 0.0v 159.745n 0.0v 159.755n 0.95v 164.745n 0.95v 164.755n 0.0v 169.745n 0.0v 169.755n 0.0v 174.745n 0.0v 174.755n 0.0v 179.745n 0.0v 179.755n 0.0v 184.745n 0.0v 184.755n 0.0v 189.745n 0.0v 189.755n 0.0v 194.745n 0.0v 194.755n 0.0v 199.745n 0.0v 199.755n 0.0v 204.745n 0.0v 204.755n 0.0v 209.745n 0.0v 209.755n 0.0v 214.745n 0.0v 214.755n 0.0v 219.745n 0.0v 219.755n 0.0v 224.745n 0.0v 224.755n 0.0v 229.745n 0.0v 229.755n 0.0v 234.745n 0.0v 234.755n 0.0v 239.745n 0.0v 239.755n 0.0v 244.745n 0.0v 244.755n 0.0v 249.745n 0.0v 249.755n 0.0v 254.745n 0.0v 254.755n 0.0v 259.745n 0.0v 259.755n 0.0v 264.745n 0.0v 264.755n 0.0v 269.745n 0.0v 269.755n 0.0v 274.745n 0.0v 274.755n 0.0v 279.745n 0.0v 279.755n 0.0v 284.745n 0.0v 284.755n 0.0v 289.745n 0.0v 289.755n 0.95v 294.745n 0.95v 294.755n 0.95v 299.745n 0.95v 299.755n 0.95v 304.745n 0.95v 304.755n 0.95v 309.745n 0.95v 309.755n 0.95v 314.745n 0.95v 314.755n 0.95v 319.745n 0.95v 319.755n 0.0v 324.745n 0.0v 324.755n 0.95v 329.745n 0.95v 329.755n 0.95v 334.745n 0.95v 334.755n 0.95v 339.745n 0.95v 339.755n 0.95v 344.745n 0.95v 344.755n 0.95v 349.745n 0.95v 349.755n 0.95v 354.745n 0.95v 354.755n 0.95v 359.745n 0.95v 359.755n 0.95v 364.745n 0.95v 364.755n 0.95v 369.745n 0.95v 369.755n 0.95v 374.745n 0.95v 374.755n 0.95v 379.745n 0.95v 379.755n 0.95v 384.745n 0.95v 384.755n 0.95v 389.745n 0.95v 389.755n 0.95v 394.745n 0.95v 394.755n 0.95v 399.745n 0.95v 399.755n 0.95v 404.745n 0.95v 404.755n 0.95v 409.745n 0.95v 409.755n 0.95v 414.745n 0.95v 414.755n 0.95v 419.745n 0.95v 419.755n 0.95v 424.745n 0.95v 424.755n 0.0v 429.745n 0.0v 429.755n 0.0v 434.745n 0.0v 434.755n 0.0v 439.745n 0.0v 439.755n 0.0v 444.745n 0.0v 444.755n 0.0v 449.745n 0.0v 449.755n 0.0v 454.745n 0.0v 454.755n 0.0v 459.745n 0.0v 459.755n 0.0v 464.745n 0.0v 464.755n 0.0v 469.745n 0.0v 469.755n 0.0v 474.745n 0.0v 474.755n 0.0v 479.745n 0.0v 479.755n 0.0v 484.745n 0.0v 484.755n 0.0v 489.745n 0.0v 489.755n 0.0v 494.745n 0.0v 494.755n 0.0v 499.745n 0.0v 499.755n 0.0v 504.745n 0.0v 504.755n 0.0v 509.745n 0.0v 509.755n 0.0v 514.745n 0.0v 514.755n 0.0v 519.745n 0.0v 519.755n 0.0v 524.745n 0.0v 524.755n 0.95v 529.745n 0.95v 529.755n 0.95v 534.745n 0.95v 534.755n 0.95v 539.745n 0.95v 539.755n 0.95v 544.745n 0.95v 544.755n 0.95v 549.745n 0.95v 549.755n 0.0v 554.745n 0.0v 554.755n 0.0v 559.745n 0.0v 559.755n 0.0v 564.745n 0.0v 564.755n 0.0v 569.745n 0.0v 569.755n 0.0v 574.745n 0.0v 574.755n 0.0v 579.745n 0.0v 579.755n 0.0v 584.745n 0.0v 584.755n 0.0v 589.745n 0.0v 589.755n 0.95v 594.745n 0.95v 594.755n 0.95v 599.745n 0.95v 599.755n 0.0v 604.745n 0.0v 604.755n 0.0v 609.745n 0.0v 609.755n 0.0v 614.745n 0.0v 614.755n 0.0v 619.745n 0.0v 619.755n 0.0v 624.745n 0.0v 624.755n 0.0v 629.745n 0.0v 629.755n 0.0v 634.745n 0.0v 634.755n 0.0v 639.745n 0.0v 639.755n 0.0v 644.745n 0.0v 644.755n 0.0v 649.745n 0.0v 649.755n 0.0v 654.745n 0.0v 654.755n 0.95v 659.745n 0.95v 659.755n 0.95v 664.745n 0.95v 664.755n 0.95v 669.745n 0.95v 669.755n 0.95v 674.745n 0.95v 674.755n 0.95v 679.745n 0.95v 679.755n 0.95v 684.745n 0.95v 684.755n 0.95v 689.745n 0.95v 689.755n 0.95v 694.745n 0.95v 694.755n 0.95v 699.745n 0.95v 699.755n 0.95v 704.745n 0.95v 704.755n 0.95v 709.745n 0.95v 709.755n 0.95v 714.745n 0.95v 714.755n 0.95v 719.745n 0.95v 719.755n 0.0v 724.745n 0.0v 724.755n 0.0v 729.745n 0.0v 729.755n 0.0v 734.745n 0.0v 734.755n 0.0v 739.745n 0.0v 739.755n 0.0v 744.745n 0.0v 744.755n 0.0v 749.745n 0.0v 749.755n 0.0v 754.745n 0.0v 754.755n 0.0v 759.745n 0.0v 759.755n 0.0v 764.745n 0.0v 764.755n 0.0v 769.745n 0.0v 769.755n 0.0v 774.745n 0.0v 774.755n 0.0v 779.745n 0.0v 779.755n 0.0v 784.745n 0.0v 784.755n 0.0v 789.745n 0.0v 789.755n 0.95v 794.745n 0.95v 794.755n 0.95v 799.745n 0.95v 799.755n 0.95v 804.745n 0.95v 804.755n 0.95v 809.745n 0.95v 809.755n 0.95v 814.745n 0.95v 814.755n 0.95v 819.745n 0.95v 819.755n 0.0v 824.745n 0.0v 824.755n 0.0v 829.745n 0.0v 829.755n 0.95v 834.745n 0.95v 834.755n 0.95v 839.745n 0.95v 839.755n 0.95v 844.745n 0.95v 844.755n 0.95v 849.745n 0.95v 849.755n 0.95v 854.745n 0.95v 854.755n 0.95v 859.745n 0.95v 859.755n 0.0v 864.745n 0.0v 864.755n 0.0v 869.745n 0.0v 869.755n 0.0v 874.745n 0.0v 874.755n 0.95v 879.745n 0.95v 879.755n 0.95v 884.745n 0.95v 884.755n 0.95v 889.745n 0.95v 889.755n 0.95v 894.745n 0.95v 894.755n 0.95v 899.745n 0.95v 899.755n 0.95v 904.745n 0.95v 904.755n 0.95v 909.745n 0.95v 909.755n 0.95v 914.745n 0.95v 914.755n 0.95v 919.745n 0.95v 919.755n 0.95v 924.745n 0.95v 924.755n 0.95v 929.745n 0.95v 929.755n 0.95v 934.745n 0.95v 934.755n 0.0v 939.745n 0.0v 939.755n 0.95v 944.745n 0.95v 944.755n 0.95v 949.745n 0.95v 949.755n 0.95v 954.745n 0.95v 954.755n 0.95v 959.745n 0.95v 959.755n 0.95v 964.745n 0.95v 964.755n 0.95v 969.745n 0.95v 969.755n 0.95v 974.745n 0.95v 974.755n 0.95v 979.745n 0.95v 979.755n 0.95v 984.745n 0.95v 984.755n 0.95v 989.745n 0.95v 989.755n 0.95v 994.745n 0.95v 994.755n 0.95v 999.745n 0.95v 999.755n 0.0v 1004.745n 0.0v 1004.755n 0.0v 1009.745n 0.0v 1009.755n 0.0v 1014.745n 0.0v 1014.755n 0.0v 1019.745n 0.0v 1019.755n 0.0v 1024.745n 0.0v 1024.755n 0.0v )
* (time, data): [(0, 0), (5, 0), (10, 0), (15, 0), (20, 0), (25, 0), (30, 0), (35, 0), (40, 0), (45, 0), (50, 0), (55, 0), (60, 0), (65, 0), (70, 0), (75, 1), (80, 1), (85, 1), (90, 1), (95, 1), (100, 1), (105, 1), (110, 1), (115, 0), (120, 0), (125, 0), (130, 0), (135, 0), (140, 0), (145, 0), (150, 0), (155, 0), (160, 0), (165, 1), (170, 1), (175, 1), (180, 1), (185, 1), (190, 1), (195, 1), (200, 1), (205, 1), (210, 1), (215, 1), (220, 1), (225, 1), (230, 1), (235, 1), (240, 1), (245, 1), (250, 1), (255, 1), (260, 1), (265, 1), (270, 1), (275, 1), (280, 1), (285, 1), (290, 0), (295, 0), (300, 0), (305, 0), (310, 0), (315, 0), (320, 1), (325, 0), (330, 0), (335, 0), (340, 0), (345, 0), (350, 0), (355, 0), (360, 0), (365, 0), (370, 0), (375, 0), (380, 0), (385, 0), (390, 0), (395, 0), (400, 0), (405, 0), (410, 1), (415, 1), (420, 1), (425, 0), (430, 0), (435, 0), (440, 0), (445, 0), (450, 0), (455, 0), (460, 0), (465, 0), (470, 0), (475, 0), (480, 0), (485, 0), (490, 0), (495, 0), (500, 0), (505, 0), (510, 1), (515, 1), (520, 1), (525, 1), (530, 0), (535, 0), (540, 0), (545, 0), (550, 0), (555, 0), (560, 0), (565, 0), (570, 1), (575, 1), (580, 1), (585, 1), (590, 1), (595, 1), (600, 1), (605, 1), (610, 1), (615, 0), (620, 0), (625, 0), (630, 0), (635, 0), (640, 0), (645, 0), (650, 0), (655, 0), (660, 0), (665, 0), (670, 0), (675, 0), (680, 0), (685, 1), (690, 1), (695, 1), (700, 1), (705, 1), (710, 1), (715, 1), (720, 1), (725, 1), (730, 1), (735, 1), (740, 1), (745, 1), (750, 1), (755, 1), (760, 1), (765, 1), (770, 1), (775, 1), (780, 1), (785, 1), (790, 1), (795, 1), (800, 1), (805, 1), (810, 1), (815, 1), (820, 1), (825, 1), (830, 1), (835, 1), (840, 1), (845, 0), (850, 0), (855, 0), (860, 0), (865, 0), (870, 0), (875, 0), (880, 0), (885, 0), (890, 0), (895, 0), (900, 1), (905, 1), (910, 1), (915, 1), (920, 1), (925, 1), (930, 1), (935, 1), (940, 1), (945, 1), (950, 1), (955, 1), (960, 1), (965, 1), (970, 1), (975, 1), (980, 1), (985, 1), (990, 1), (995, 1), (1000, 0), (1005, 0), (1010, 0), (1015, 0), (1020, 0), (1025, 0)]
Vdin0_3  din0_3  0 PWL (0n 0.0v 4.745n 0.0v 4.755n 0.0v 9.745n 0.0v 9.755n 0.0v 14.745n 0.0v 14.755n 0.0v 19.745n 0.0v 19.755n 0.0v 24.745n 0.0v 24.755n 0.0v 29.745n 0.0v 29.755n 0.0v 34.745n 0.0v 34.755n 0.0v 39.745n 0.0v 39.755n 0.0v 44.745n 0.0v 44.755n 0.0v 49.745n 0.0v 49.755n 0.0v 54.745n 0.0v 54.755n 0.0v 59.745n 0.0v 59.755n 0.0v 64.745n 0.0v 64.755n 0.0v 69.745n 0.0v 69.755n 0.0v 74.745n 0.0v 74.755n 0.95v 79.745n 0.95v 79.755n 0.95v 84.745n 0.95v 84.755n 0.95v 89.745n 0.95v 89.755n 0.95v 94.745n 0.95v 94.755n 0.95v 99.745n 0.95v 99.755n 0.95v 104.745n 0.95v 104.755n 0.95v 109.745n 0.95v 109.755n 0.95v 114.745n 0.95v 114.755n 0.0v 119.745n 0.0v 119.755n 0.0v 124.745n 0.0v 124.755n 0.0v 129.745n 0.0v 129.755n 0.0v 134.745n 0.0v 134.755n 0.0v 139.745n 0.0v 139.755n 0.0v 144.745n 0.0v 144.755n 0.0v 149.745n 0.0v 149.755n 0.0v 154.745n 0.0v 154.755n 0.0v 159.745n 0.0v 159.755n 0.0v 164.745n 0.0v 164.755n 0.95v 169.745n 0.95v 169.755n 0.95v 174.745n 0.95v 174.755n 0.95v 179.745n 0.95v 179.755n 0.95v 184.745n 0.95v 184.755n 0.95v 189.745n 0.95v 189.755n 0.95v 194.745n 0.95v 194.755n 0.95v 199.745n 0.95v 199.755n 0.95v 204.745n 0.95v 204.755n 0.95v 209.745n 0.95v 209.755n 0.95v 214.745n 0.95v 214.755n 0.95v 219.745n 0.95v 219.755n 0.95v 224.745n 0.95v 224.755n 0.95v 229.745n 0.95v 229.755n 0.95v 234.745n 0.95v 234.755n 0.95v 239.745n 0.95v 239.755n 0.95v 244.745n 0.95v 244.755n 0.95v 249.745n 0.95v 249.755n 0.95v 254.745n 0.95v 254.755n 0.95v 259.745n 0.95v 259.755n 0.95v 264.745n 0.95v 264.755n 0.95v 269.745n 0.95v 269.755n 0.95v 274.745n 0.95v 274.755n 0.95v 279.745n 0.95v 279.755n 0.95v 284.745n 0.95v 284.755n 0.95v 289.745n 0.95v 289.755n 0.0v 294.745n 0.0v 294.755n 0.0v 299.745n 0.0v 299.755n 0.0v 304.745n 0.0v 304.755n 0.0v 309.745n 0.0v 309.755n 0.0v 314.745n 0.0v 314.755n 0.0v 319.745n 0.0v 319.755n 0.95v 324.745n 0.95v 324.755n 0.0v 329.745n 0.0v 329.755n 0.0v 334.745n 0.0v 334.755n 0.0v 339.745n 0.0v 339.755n 0.0v 344.745n 0.0v 344.755n 0.0v 349.745n 0.0v 349.755n 0.0v 354.745n 0.0v 354.755n 0.0v 359.745n 0.0v 359.755n 0.0v 364.745n 0.0v 364.755n 0.0v 369.745n 0.0v 369.755n 0.0v 374.745n 0.0v 374.755n 0.0v 379.745n 0.0v 379.755n 0.0v 384.745n 0.0v 384.755n 0.0v 389.745n 0.0v 389.755n 0.0v 394.745n 0.0v 394.755n 0.0v 399.745n 0.0v 399.755n 0.0v 404.745n 0.0v 404.755n 0.0v 409.745n 0.0v 409.755n 0.95v 414.745n 0.95v 414.755n 0.95v 419.745n 0.95v 419.755n 0.95v 424.745n 0.95v 424.755n 0.0v 429.745n 0.0v 429.755n 0.0v 434.745n 0.0v 434.755n 0.0v 439.745n 0.0v 439.755n 0.0v 444.745n 0.0v 444.755n 0.0v 449.745n 0.0v 449.755n 0.0v 454.745n 0.0v 454.755n 0.0v 459.745n 0.0v 459.755n 0.0v 464.745n 0.0v 464.755n 0.0v 469.745n 0.0v 469.755n 0.0v 474.745n 0.0v 474.755n 0.0v 479.745n 0.0v 479.755n 0.0v 484.745n 0.0v 484.755n 0.0v 489.745n 0.0v 489.755n 0.0v 494.745n 0.0v 494.755n 0.0v 499.745n 0.0v 499.755n 0.0v 504.745n 0.0v 504.755n 0.0v 509.745n 0.0v 509.755n 0.95v 514.745n 0.95v 514.755n 0.95v 519.745n 0.95v 519.755n 0.95v 524.745n 0.95v 524.755n 0.95v 529.745n 0.95v 529.755n 0.0v 534.745n 0.0v 534.755n 0.0v 539.745n 0.0v 539.755n 0.0v 544.745n 0.0v 544.755n 0.0v 549.745n 0.0v 549.755n 0.0v 554.745n 0.0v 554.755n 0.0v 559.745n 0.0v 559.755n 0.0v 564.745n 0.0v 564.755n 0.0v 569.745n 0.0v 569.755n 0.95v 574.745n 0.95v 574.755n 0.95v 579.745n 0.95v 579.755n 0.95v 584.745n 0.95v 584.755n 0.95v 589.745n 0.95v 589.755n 0.95v 594.745n 0.95v 594.755n 0.95v 599.745n 0.95v 599.755n 0.95v 604.745n 0.95v 604.755n 0.95v 609.745n 0.95v 609.755n 0.95v 614.745n 0.95v 614.755n 0.0v 619.745n 0.0v 619.755n 0.0v 624.745n 0.0v 624.755n 0.0v 629.745n 0.0v 629.755n 0.0v 634.745n 0.0v 634.755n 0.0v 639.745n 0.0v 639.755n 0.0v 644.745n 0.0v 644.755n 0.0v 649.745n 0.0v 649.755n 0.0v 654.745n 0.0v 654.755n 0.0v 659.745n 0.0v 659.755n 0.0v 664.745n 0.0v 664.755n 0.0v 669.745n 0.0v 669.755n 0.0v 674.745n 0.0v 674.755n 0.0v 679.745n 0.0v 679.755n 0.0v 684.745n 0.0v 684.755n 0.95v 689.745n 0.95v 689.755n 0.95v 694.745n 0.95v 694.755n 0.95v 699.745n 0.95v 699.755n 0.95v 704.745n 0.95v 704.755n 0.95v 709.745n 0.95v 709.755n 0.95v 714.745n 0.95v 714.755n 0.95v 719.745n 0.95v 719.755n 0.95v 724.745n 0.95v 724.755n 0.95v 729.745n 0.95v 729.755n 0.95v 734.745n 0.95v 734.755n 0.95v 739.745n 0.95v 739.755n 0.95v 744.745n 0.95v 744.755n 0.95v 749.745n 0.95v 749.755n 0.95v 754.745n 0.95v 754.755n 0.95v 759.745n 0.95v 759.755n 0.95v 764.745n 0.95v 764.755n 0.95v 769.745n 0.95v 769.755n 0.95v 774.745n 0.95v 774.755n 0.95v 779.745n 0.95v 779.755n 0.95v 784.745n 0.95v 784.755n 0.95v 789.745n 0.95v 789.755n 0.95v 794.745n 0.95v 794.755n 0.95v 799.745n 0.95v 799.755n 0.95v 804.745n 0.95v 804.755n 0.95v 809.745n 0.95v 809.755n 0.95v 814.745n 0.95v 814.755n 0.95v 819.745n 0.95v 819.755n 0.95v 824.745n 0.95v 824.755n 0.95v 829.745n 0.95v 829.755n 0.95v 834.745n 0.95v 834.755n 0.95v 839.745n 0.95v 839.755n 0.95v 844.745n 0.95v 844.755n 0.0v 849.745n 0.0v 849.755n 0.0v 854.745n 0.0v 854.755n 0.0v 859.745n 0.0v 859.755n 0.0v 864.745n 0.0v 864.755n 0.0v 869.745n 0.0v 869.755n 0.0v 874.745n 0.0v 874.755n 0.0v 879.745n 0.0v 879.755n 0.0v 884.745n 0.0v 884.755n 0.0v 889.745n 0.0v 889.755n 0.0v 894.745n 0.0v 894.755n 0.0v 899.745n 0.0v 899.755n 0.95v 904.745n 0.95v 904.755n 0.95v 909.745n 0.95v 909.755n 0.95v 914.745n 0.95v 914.755n 0.95v 919.745n 0.95v 919.755n 0.95v 924.745n 0.95v 924.755n 0.95v 929.745n 0.95v 929.755n 0.95v 934.745n 0.95v 934.755n 0.95v 939.745n 0.95v 939.755n 0.95v 944.745n 0.95v 944.755n 0.95v 949.745n 0.95v 949.755n 0.95v 954.745n 0.95v 954.755n 0.95v 959.745n 0.95v 959.755n 0.95v 964.745n 0.95v 964.755n 0.95v 969.745n 0.95v 969.755n 0.95v 974.745n 0.95v 974.755n 0.95v 979.745n 0.95v 979.755n 0.95v 984.745n 0.95v 984.755n 0.95v 989.745n 0.95v 989.755n 0.95v 994.745n 0.95v 994.755n 0.95v 999.745n 0.95v 999.755n 0.0v 1004.745n 0.0v 1004.755n 0.0v 1009.745n 0.0v 1009.755n 0.0v 1014.745n 0.0v 1014.755n 0.0v 1019.745n 0.0v 1019.755n 0.0v 1024.745n 0.0v 1024.755n 0.0v )
* (time, data): [(0, 0), (5, 0), (10, 1), (15, 0), (20, 0), (25, 0), (30, 0), (35, 0), (40, 0), (45, 0), (50, 1), (55, 1), (60, 1), (65, 1), (70, 1), (75, 0), (80, 0), (85, 0), (90, 0), (95, 1), (100, 1), (105, 1), (110, 1), (115, 0), (120, 0), (125, 0), (130, 0), (135, 0), (140, 0), (145, 0), (150, 0), (155, 0), (160, 1), (165, 0), (170, 0), (175, 0), (180, 0), (185, 0), (190, 0), (195, 0), (200, 0), (205, 0), (210, 0), (215, 0), (220, 0), (225, 0), (230, 0), (235, 0), (240, 1), (245, 1), (250, 1), (255, 1), (260, 1), (265, 1), (270, 1), (275, 1), (280, 1), (285, 1), (290, 1), (295, 1), (300, 1), (305, 1), (310, 1), (315, 1), (320, 0), (325, 1), (330, 0), (335, 0), (340, 0), (345, 0), (350, 0), (355, 0), (360, 0), (365, 0), (370, 0), (375, 0), (380, 0), (385, 0), (390, 0), (395, 0), (400, 0), (405, 0), (410, 1), (415, 1), (420, 1), (425, 1), (430, 1), (435, 1), (440, 1), (445, 1), (450, 1), (455, 1), (460, 1), (465, 1), (470, 1), (475, 1), (480, 1), (485, 1), (490, 1), (495, 1), (500, 1), (505, 1), (510, 0), (515, 0), (520, 0), (525, 0), (530, 1), (535, 1), (540, 1), (545, 1), (550, 0), (555, 0), (560, 0), (565, 0), (570, 1), (575, 1), (580, 1), (585, 1), (590, 0), (595, 0), (600, 1), (605, 1), (610, 1), (615, 0), (620, 0), (625, 0), (630, 0), (635, 0), (640, 0), (645, 0), (650, 0), (655, 0), (660, 0), (665, 0), (670, 0), (675, 0), (680, 0), (685, 0), (690, 0), (695, 0), (700, 0), (705, 0), (710, 0), (715, 0), (720, 1), (725, 1), (730, 1), (735, 1), (740, 1), (745, 1), (750, 1), (755, 1), (760, 1), (765, 1), (770, 1), (775, 1), (780, 1), (785, 1), (790, 0), (795, 0), (800, 0), (805, 0), (810, 0), (815, 0), (820, 0), (825, 0), (830, 0), (835, 0), (840, 0), (845, 1), (850, 1), (855, 1), (860, 0), (865, 0), (870, 0), (875, 1), (880, 1), (885, 1), (890, 1), (895, 1), (900, 1), (905, 1), (910, 1), (915, 1), (920, 1), (925, 1), (930, 1), (935, 0), (940, 1), (945, 1), (950, 1), (955, 1), (960, 1), (965, 1), (970, 0), (975, 0), (980, 0), (985, 0), (990, 0), (995, 0), (1000, 1), (1005, 1), (1010, 1), (1015, 1), (1020, 1), (1025, 1)]
Vdin0_4  din0_4  0 PWL (0n 0.0v 4.745n 0.0v 4.755n 0.0v 9.745n 0.0v 9.755n 0.95v 14.745n 0.95v 14.755n 0.0v 19.745n 0.0v 19.755n 0.0v 24.745n 0.0v 24.755n 0.0v 29.745n 0.0v 29.755n 0.0v 34.745n 0.0v 34.755n 0.0v 39.745n 0.0v 39.755n 0.0v 44.745n 0.0v 44.755n 0.0v 49.745n 0.0v 49.755n 0.95v 54.745n 0.95v 54.755n 0.95v 59.745n 0.95v 59.755n 0.95v 64.745n 0.95v 64.755n 0.95v 69.745n 0.95v 69.755n 0.95v 74.745n 0.95v 74.755n 0.0v 79.745n 0.0v 79.755n 0.0v 84.745n 0.0v 84.755n 0.0v 89.745n 0.0v 89.755n 0.0v 94.745n 0.0v 94.755n 0.95v 99.745n 0.95v 99.755n 0.95v 104.745n 0.95v 104.755n 0.95v 109.745n 0.95v 109.755n 0.95v 114.745n 0.95v 114.755n 0.0v 119.745n 0.0v 119.755n 0.0v 124.745n 0.0v 124.755n 0.0v 129.745n 0.0v 129.755n 0.0v 134.745n 0.0v 134.755n 0.0v 139.745n 0.0v 139.755n 0.0v 144.745n 0.0v 144.755n 0.0v 149.745n 0.0v 149.755n 0.0v 154.745n 0.0v 154.755n 0.0v 159.745n 0.0v 159.755n 0.95v 164.745n 0.95v 164.755n 0.0v 169.745n 0.0v 169.755n 0.0v 174.745n 0.0v 174.755n 0.0v 179.745n 0.0v 179.755n 0.0v 184.745n 0.0v 184.755n 0.0v 189.745n 0.0v 189.755n 0.0v 194.745n 0.0v 194.755n 0.0v 199.745n 0.0v 199.755n 0.0v 204.745n 0.0v 204.755n 0.0v 209.745n 0.0v 209.755n 0.0v 214.745n 0.0v 214.755n 0.0v 219.745n 0.0v 219.755n 0.0v 224.745n 0.0v 224.755n 0.0v 229.745n 0.0v 229.755n 0.0v 234.745n 0.0v 234.755n 0.0v 239.745n 0.0v 239.755n 0.95v 244.745n 0.95v 244.755n 0.95v 249.745n 0.95v 249.755n 0.95v 254.745n 0.95v 254.755n 0.95v 259.745n 0.95v 259.755n 0.95v 264.745n 0.95v 264.755n 0.95v 269.745n 0.95v 269.755n 0.95v 274.745n 0.95v 274.755n 0.95v 279.745n 0.95v 279.755n 0.95v 284.745n 0.95v 284.755n 0.95v 289.745n 0.95v 289.755n 0.95v 294.745n 0.95v 294.755n 0.95v 299.745n 0.95v 299.755n 0.95v 304.745n 0.95v 304.755n 0.95v 309.745n 0.95v 309.755n 0.95v 314.745n 0.95v 314.755n 0.95v 319.745n 0.95v 319.755n 0.0v 324.745n 0.0v 324.755n 0.95v 329.745n 0.95v 329.755n 0.0v 334.745n 0.0v 334.755n 0.0v 339.745n 0.0v 339.755n 0.0v 344.745n 0.0v 344.755n 0.0v 349.745n 0.0v 349.755n 0.0v 354.745n 0.0v 354.755n 0.0v 359.745n 0.0v 359.755n 0.0v 364.745n 0.0v 364.755n 0.0v 369.745n 0.0v 369.755n 0.0v 374.745n 0.0v 374.755n 0.0v 379.745n 0.0v 379.755n 0.0v 384.745n 0.0v 384.755n 0.0v 389.745n 0.0v 389.755n 0.0v 394.745n 0.0v 394.755n 0.0v 399.745n 0.0v 399.755n 0.0v 404.745n 0.0v 404.755n 0.0v 409.745n 0.0v 409.755n 0.95v 414.745n 0.95v 414.755n 0.95v 419.745n 0.95v 419.755n 0.95v 424.745n 0.95v 424.755n 0.95v 429.745n 0.95v 429.755n 0.95v 434.745n 0.95v 434.755n 0.95v 439.745n 0.95v 439.755n 0.95v 444.745n 0.95v 444.755n 0.95v 449.745n 0.95v 449.755n 0.95v 454.745n 0.95v 454.755n 0.95v 459.745n 0.95v 459.755n 0.95v 464.745n 0.95v 464.755n 0.95v 469.745n 0.95v 469.755n 0.95v 474.745n 0.95v 474.755n 0.95v 479.745n 0.95v 479.755n 0.95v 484.745n 0.95v 484.755n 0.95v 489.745n 0.95v 489.755n 0.95v 494.745n 0.95v 494.755n 0.95v 499.745n 0.95v 499.755n 0.95v 504.745n 0.95v 504.755n 0.95v 509.745n 0.95v 509.755n 0.0v 514.745n 0.0v 514.755n 0.0v 519.745n 0.0v 519.755n 0.0v 524.745n 0.0v 524.755n 0.0v 529.745n 0.0v 529.755n 0.95v 534.745n 0.95v 534.755n 0.95v 539.745n 0.95v 539.755n 0.95v 544.745n 0.95v 544.755n 0.95v 549.745n 0.95v 549.755n 0.0v 554.745n 0.0v 554.755n 0.0v 559.745n 0.0v 559.755n 0.0v 564.745n 0.0v 564.755n 0.0v 569.745n 0.0v 569.755n 0.95v 574.745n 0.95v 574.755n 0.95v 579.745n 0.95v 579.755n 0.95v 584.745n 0.95v 584.755n 0.95v 589.745n 0.95v 589.755n 0.0v 594.745n 0.0v 594.755n 0.0v 599.745n 0.0v 599.755n 0.95v 604.745n 0.95v 604.755n 0.95v 609.745n 0.95v 609.755n 0.95v 614.745n 0.95v 614.755n 0.0v 619.745n 0.0v 619.755n 0.0v 624.745n 0.0v 624.755n 0.0v 629.745n 0.0v 629.755n 0.0v 634.745n 0.0v 634.755n 0.0v 639.745n 0.0v 639.755n 0.0v 644.745n 0.0v 644.755n 0.0v 649.745n 0.0v 649.755n 0.0v 654.745n 0.0v 654.755n 0.0v 659.745n 0.0v 659.755n 0.0v 664.745n 0.0v 664.755n 0.0v 669.745n 0.0v 669.755n 0.0v 674.745n 0.0v 674.755n 0.0v 679.745n 0.0v 679.755n 0.0v 684.745n 0.0v 684.755n 0.0v 689.745n 0.0v 689.755n 0.0v 694.745n 0.0v 694.755n 0.0v 699.745n 0.0v 699.755n 0.0v 704.745n 0.0v 704.755n 0.0v 709.745n 0.0v 709.755n 0.0v 714.745n 0.0v 714.755n 0.0v 719.745n 0.0v 719.755n 0.95v 724.745n 0.95v 724.755n 0.95v 729.745n 0.95v 729.755n 0.95v 734.745n 0.95v 734.755n 0.95v 739.745n 0.95v 739.755n 0.95v 744.745n 0.95v 744.755n 0.95v 749.745n 0.95v 749.755n 0.95v 754.745n 0.95v 754.755n 0.95v 759.745n 0.95v 759.755n 0.95v 764.745n 0.95v 764.755n 0.95v 769.745n 0.95v 769.755n 0.95v 774.745n 0.95v 774.755n 0.95v 779.745n 0.95v 779.755n 0.95v 784.745n 0.95v 784.755n 0.95v 789.745n 0.95v 789.755n 0.0v 794.745n 0.0v 794.755n 0.0v 799.745n 0.0v 799.755n 0.0v 804.745n 0.0v 804.755n 0.0v 809.745n 0.0v 809.755n 0.0v 814.745n 0.0v 814.755n 0.0v 819.745n 0.0v 819.755n 0.0v 824.745n 0.0v 824.755n 0.0v 829.745n 0.0v 829.755n 0.0v 834.745n 0.0v 834.755n 0.0v 839.745n 0.0v 839.755n 0.0v 844.745n 0.0v 844.755n 0.95v 849.745n 0.95v 849.755n 0.95v 854.745n 0.95v 854.755n 0.95v 859.745n 0.95v 859.755n 0.0v 864.745n 0.0v 864.755n 0.0v 869.745n 0.0v 869.755n 0.0v 874.745n 0.0v 874.755n 0.95v 879.745n 0.95v 879.755n 0.95v 884.745n 0.95v 884.755n 0.95v 889.745n 0.95v 889.755n 0.95v 894.745n 0.95v 894.755n 0.95v 899.745n 0.95v 899.755n 0.95v 904.745n 0.95v 904.755n 0.95v 909.745n 0.95v 909.755n 0.95v 914.745n 0.95v 914.755n 0.95v 919.745n 0.95v 919.755n 0.95v 924.745n 0.95v 924.755n 0.95v 929.745n 0.95v 929.755n 0.95v 934.745n 0.95v 934.755n 0.0v 939.745n 0.0v 939.755n 0.95v 944.745n 0.95v 944.755n 0.95v 949.745n 0.95v 949.755n 0.95v 954.745n 0.95v 954.755n 0.95v 959.745n 0.95v 959.755n 0.95v 964.745n 0.95v 964.755n 0.95v 969.745n 0.95v 969.755n 0.0v 974.745n 0.0v 974.755n 0.0v 979.745n 0.0v 979.755n 0.0v 984.745n 0.0v 984.755n 0.0v 989.745n 0.0v 989.755n 0.0v 994.745n 0.0v 994.755n 0.0v 999.745n 0.0v 999.755n 0.95v 1004.745n 0.95v 1004.755n 0.95v 1009.745n 0.95v 1009.755n 0.95v 1014.745n 0.95v 1014.755n 0.95v 1019.745n 0.95v 1019.755n 0.95v 1024.745n 0.95v 1024.755n 0.95v )
* (time, data): [(0, 0), (5, 0), (10, 0), (15, 0), (20, 0), (25, 0), (30, 0), (35, 0), (40, 0), (45, 0), (50, 1), (55, 1), (60, 1), (65, 1), (70, 1), (75, 1), (80, 1), (85, 1), (90, 1), (95, 0), (100, 0), (105, 0), (110, 0), (115, 1), (120, 1), (125, 1), (130, 1), (135, 1), (140, 1), (145, 1), (150, 1), (155, 1), (160, 1), (165, 0), (170, 0), (175, 0), (180, 0), (185, 0), (190, 0), (195, 0), (200, 0), (205, 0), (210, 0), (215, 0), (220, 0), (225, 0), (230, 0), (235, 0), (240, 1), (245, 1), (250, 1), (255, 1), (260, 1), (265, 1), (270, 1), (275, 1), (280, 1), (285, 1), (290, 1), (295, 1), (300, 1), (305, 1), (310, 1), (315, 1), (320, 1), (325, 1), (330, 1), (335, 1), (340, 1), (345, 1), (350, 1), (355, 1), (360, 1), (365, 1), (370, 1), (375, 1), (380, 1), (385, 1), (390, 1), (395, 1), (400, 1), (405, 1), (410, 1), (415, 1), (420, 1), (425, 1), (430, 1), (435, 1), (440, 1), (445, 1), (450, 1), (455, 1), (460, 1), (465, 1), (470, 1), (475, 1), (480, 1), (485, 1), (490, 1), (495, 1), (500, 1), (505, 1), (510, 1), (515, 1), (520, 1), (525, 1), (530, 1), (535, 1), (540, 1), (545, 1), (550, 1), (555, 1), (560, 1), (565, 1), (570, 1), (575, 1), (580, 1), (585, 1), (590, 1), (595, 1), (600, 1), (605, 1), (610, 1), (615, 0), (620, 0), (625, 0), (630, 0), (635, 0), (640, 0), (645, 0), (650, 0), (655, 1), (660, 1), (665, 1), (670, 1), (675, 1), (680, 1), (685, 0), (690, 0), (695, 0), (700, 0), (705, 0), (710, 0), (715, 0), (720, 1), (725, 1), (730, 1), (735, 1), (740, 1), (745, 1), (750, 1), (755, 1), (760, 1), (765, 1), (770, 0), (775, 0), (780, 0), (785, 0), (790, 0), (795, 0), (800, 0), (805, 0), (810, 0), (815, 0), (820, 0), (825, 0), (830, 1), (835, 1), (840, 1), (845, 1), (850, 1), (855, 1), (860, 0), (865, 0), (870, 0), (875, 1), (880, 1), (885, 1), (890, 1), (895, 1), (900, 1), (905, 0), (910, 0), (915, 0), (920, 0), (925, 0), (930, 0), (935, 0), (940, 0), (945, 0), (950, 0), (955, 0), (960, 0), (965, 0), (970, 1), (975, 1), (980, 1), (985, 1), (990, 1), (995, 1), (1000, 0), (1005, 0), (1010, 0), (1015, 0), (1020, 0), (1025, 0)]
Vdin0_5  din0_5  0 PWL (0n 0.0v 4.745n 0.0v 4.755n 0.0v 9.745n 0.0v 9.755n 0.0v 14.745n 0.0v 14.755n 0.0v 19.745n 0.0v 19.755n 0.0v 24.745n 0.0v 24.755n 0.0v 29.745n 0.0v 29.755n 0.0v 34.745n 0.0v 34.755n 0.0v 39.745n 0.0v 39.755n 0.0v 44.745n 0.0v 44.755n 0.0v 49.745n 0.0v 49.755n 0.95v 54.745n 0.95v 54.755n 0.95v 59.745n 0.95v 59.755n 0.95v 64.745n 0.95v 64.755n 0.95v 69.745n 0.95v 69.755n 0.95v 74.745n 0.95v 74.755n 0.95v 79.745n 0.95v 79.755n 0.95v 84.745n 0.95v 84.755n 0.95v 89.745n 0.95v 89.755n 0.95v 94.745n 0.95v 94.755n 0.0v 99.745n 0.0v 99.755n 0.0v 104.745n 0.0v 104.755n 0.0v 109.745n 0.0v 109.755n 0.0v 114.745n 0.0v 114.755n 0.95v 119.745n 0.95v 119.755n 0.95v 124.745n 0.95v 124.755n 0.95v 129.745n 0.95v 129.755n 0.95v 134.745n 0.95v 134.755n 0.95v 139.745n 0.95v 139.755n 0.95v 144.745n 0.95v 144.755n 0.95v 149.745n 0.95v 149.755n 0.95v 154.745n 0.95v 154.755n 0.95v 159.745n 0.95v 159.755n 0.95v 164.745n 0.95v 164.755n 0.0v 169.745n 0.0v 169.755n 0.0v 174.745n 0.0v 174.755n 0.0v 179.745n 0.0v 179.755n 0.0v 184.745n 0.0v 184.755n 0.0v 189.745n 0.0v 189.755n 0.0v 194.745n 0.0v 194.755n 0.0v 199.745n 0.0v 199.755n 0.0v 204.745n 0.0v 204.755n 0.0v 209.745n 0.0v 209.755n 0.0v 214.745n 0.0v 214.755n 0.0v 219.745n 0.0v 219.755n 0.0v 224.745n 0.0v 224.755n 0.0v 229.745n 0.0v 229.755n 0.0v 234.745n 0.0v 234.755n 0.0v 239.745n 0.0v 239.755n 0.95v 244.745n 0.95v 244.755n 0.95v 249.745n 0.95v 249.755n 0.95v 254.745n 0.95v 254.755n 0.95v 259.745n 0.95v 259.755n 0.95v 264.745n 0.95v 264.755n 0.95v 269.745n 0.95v 269.755n 0.95v 274.745n 0.95v 274.755n 0.95v 279.745n 0.95v 279.755n 0.95v 284.745n 0.95v 284.755n 0.95v 289.745n 0.95v 289.755n 0.95v 294.745n 0.95v 294.755n 0.95v 299.745n 0.95v 299.755n 0.95v 304.745n 0.95v 304.755n 0.95v 309.745n 0.95v 309.755n 0.95v 314.745n 0.95v 314.755n 0.95v 319.745n 0.95v 319.755n 0.95v 324.745n 0.95v 324.755n 0.95v 329.745n 0.95v 329.755n 0.95v 334.745n 0.95v 334.755n 0.95v 339.745n 0.95v 339.755n 0.95v 344.745n 0.95v 344.755n 0.95v 349.745n 0.95v 349.755n 0.95v 354.745n 0.95v 354.755n 0.95v 359.745n 0.95v 359.755n 0.95v 364.745n 0.95v 364.755n 0.95v 369.745n 0.95v 369.755n 0.95v 374.745n 0.95v 374.755n 0.95v 379.745n 0.95v 379.755n 0.95v 384.745n 0.95v 384.755n 0.95v 389.745n 0.95v 389.755n 0.95v 394.745n 0.95v 394.755n 0.95v 399.745n 0.95v 399.755n 0.95v 404.745n 0.95v 404.755n 0.95v 409.745n 0.95v 409.755n 0.95v 414.745n 0.95v 414.755n 0.95v 419.745n 0.95v 419.755n 0.95v 424.745n 0.95v 424.755n 0.95v 429.745n 0.95v 429.755n 0.95v 434.745n 0.95v 434.755n 0.95v 439.745n 0.95v 439.755n 0.95v 444.745n 0.95v 444.755n 0.95v 449.745n 0.95v 449.755n 0.95v 454.745n 0.95v 454.755n 0.95v 459.745n 0.95v 459.755n 0.95v 464.745n 0.95v 464.755n 0.95v 469.745n 0.95v 469.755n 0.95v 474.745n 0.95v 474.755n 0.95v 479.745n 0.95v 479.755n 0.95v 484.745n 0.95v 484.755n 0.95v 489.745n 0.95v 489.755n 0.95v 494.745n 0.95v 494.755n 0.95v 499.745n 0.95v 499.755n 0.95v 504.745n 0.95v 504.755n 0.95v 509.745n 0.95v 509.755n 0.95v 514.745n 0.95v 514.755n 0.95v 519.745n 0.95v 519.755n 0.95v 524.745n 0.95v 524.755n 0.95v 529.745n 0.95v 529.755n 0.95v 534.745n 0.95v 534.755n 0.95v 539.745n 0.95v 539.755n 0.95v 544.745n 0.95v 544.755n 0.95v 549.745n 0.95v 549.755n 0.95v 554.745n 0.95v 554.755n 0.95v 559.745n 0.95v 559.755n 0.95v 564.745n 0.95v 564.755n 0.95v 569.745n 0.95v 569.755n 0.95v 574.745n 0.95v 574.755n 0.95v 579.745n 0.95v 579.755n 0.95v 584.745n 0.95v 584.755n 0.95v 589.745n 0.95v 589.755n 0.95v 594.745n 0.95v 594.755n 0.95v 599.745n 0.95v 599.755n 0.95v 604.745n 0.95v 604.755n 0.95v 609.745n 0.95v 609.755n 0.95v 614.745n 0.95v 614.755n 0.0v 619.745n 0.0v 619.755n 0.0v 624.745n 0.0v 624.755n 0.0v 629.745n 0.0v 629.755n 0.0v 634.745n 0.0v 634.755n 0.0v 639.745n 0.0v 639.755n 0.0v 644.745n 0.0v 644.755n 0.0v 649.745n 0.0v 649.755n 0.0v 654.745n 0.0v 654.755n 0.95v 659.745n 0.95v 659.755n 0.95v 664.745n 0.95v 664.755n 0.95v 669.745n 0.95v 669.755n 0.95v 674.745n 0.95v 674.755n 0.95v 679.745n 0.95v 679.755n 0.95v 684.745n 0.95v 684.755n 0.0v 689.745n 0.0v 689.755n 0.0v 694.745n 0.0v 694.755n 0.0v 699.745n 0.0v 699.755n 0.0v 704.745n 0.0v 704.755n 0.0v 709.745n 0.0v 709.755n 0.0v 714.745n 0.0v 714.755n 0.0v 719.745n 0.0v 719.755n 0.95v 724.745n 0.95v 724.755n 0.95v 729.745n 0.95v 729.755n 0.95v 734.745n 0.95v 734.755n 0.95v 739.745n 0.95v 739.755n 0.95v 744.745n 0.95v 744.755n 0.95v 749.745n 0.95v 749.755n 0.95v 754.745n 0.95v 754.755n 0.95v 759.745n 0.95v 759.755n 0.95v 764.745n 0.95v 764.755n 0.95v 769.745n 0.95v 769.755n 0.0v 774.745n 0.0v 774.755n 0.0v 779.745n 0.0v 779.755n 0.0v 784.745n 0.0v 784.755n 0.0v 789.745n 0.0v 789.755n 0.0v 794.745n 0.0v 794.755n 0.0v 799.745n 0.0v 799.755n 0.0v 804.745n 0.0v 804.755n 0.0v 809.745n 0.0v 809.755n 0.0v 814.745n 0.0v 814.755n 0.0v 819.745n 0.0v 819.755n 0.0v 824.745n 0.0v 824.755n 0.0v 829.745n 0.0v 829.755n 0.95v 834.745n 0.95v 834.755n 0.95v 839.745n 0.95v 839.755n 0.95v 844.745n 0.95v 844.755n 0.95v 849.745n 0.95v 849.755n 0.95v 854.745n 0.95v 854.755n 0.95v 859.745n 0.95v 859.755n 0.0v 864.745n 0.0v 864.755n 0.0v 869.745n 0.0v 869.755n 0.0v 874.745n 0.0v 874.755n 0.95v 879.745n 0.95v 879.755n 0.95v 884.745n 0.95v 884.755n 0.95v 889.745n 0.95v 889.755n 0.95v 894.745n 0.95v 894.755n 0.95v 899.745n 0.95v 899.755n 0.95v 904.745n 0.95v 904.755n 0.0v 909.745n 0.0v 909.755n 0.0v 914.745n 0.0v 914.755n 0.0v 919.745n 0.0v 919.755n 0.0v 924.745n 0.0v 924.755n 0.0v 929.745n 0.0v 929.755n 0.0v 934.745n 0.0v 934.755n 0.0v 939.745n 0.0v 939.755n 0.0v 944.745n 0.0v 944.755n 0.0v 949.745n 0.0v 949.755n 0.0v 954.745n 0.0v 954.755n 0.0v 959.745n 0.0v 959.755n 0.0v 964.745n 0.0v 964.755n 0.0v 969.745n 0.0v 969.755n 0.95v 974.745n 0.95v 974.755n 0.95v 979.745n 0.95v 979.755n 0.95v 984.745n 0.95v 984.755n 0.95v 989.745n 0.95v 989.755n 0.95v 994.745n 0.95v 994.755n 0.95v 999.745n 0.95v 999.755n 0.0v 1004.745n 0.0v 1004.755n 0.0v 1009.745n 0.0v 1009.755n 0.0v 1014.745n 0.0v 1014.755n 0.0v 1019.745n 0.0v 1019.755n 0.0v 1024.745n 0.0v 1024.755n 0.0v )
* (time, data): [(0, 0), (5, 1), (10, 1), (15, 1), (20, 1), (25, 1), (30, 1), (35, 1), (40, 1), (45, 1), (50, 0), (55, 0), (60, 0), (65, 0), (70, 0), (75, 1), (80, 1), (85, 1), (90, 1), (95, 0), (100, 0), (105, 0), (110, 0), (115, 0), (120, 0), (125, 0), (130, 0), (135, 0), (140, 0), (145, 0), (150, 1), (155, 1), (160, 0), (165, 1), (170, 1), (175, 1), (180, 1), (185, 1), (190, 1), (195, 1), (200, 1), (205, 1), (210, 1), (215, 1), (220, 1), (225, 1), (230, 1), (235, 1), (240, 0), (245, 0), (250, 0), (255, 0), (260, 0), (265, 1), (270, 1), (275, 1), (280, 1), (285, 1), (290, 1), (295, 1), (300, 1), (305, 1), (310, 1), (315, 1), (320, 0), (325, 1), (330, 1), (335, 1), (340, 1), (345, 1), (350, 1), (355, 1), (360, 1), (365, 1), (370, 1), (375, 1), (380, 1), (385, 1), (390, 1), (395, 1), (400, 1), (405, 1), (410, 1), (415, 1), (420, 1), (425, 1), (430, 1), (435, 1), (440, 1), (445, 1), (450, 1), (455, 1), (460, 1), (465, 1), (470, 1), (475, 1), (480, 1), (485, 1), (490, 1), (495, 1), (500, 1), (505, 1), (510, 0), (515, 0), (520, 0), (525, 1), (530, 1), (535, 1), (540, 1), (545, 1), (550, 0), (555, 0), (560, 0), (565, 0), (570, 0), (575, 0), (580, 0), (585, 0), (590, 0), (595, 0), (600, 0), (605, 0), (610, 0), (615, 1), (620, 1), (625, 1), (630, 1), (635, 1), (640, 1), (645, 1), (650, 1), (655, 0), (660, 0), (665, 0), (670, 0), (675, 0), (680, 0), (685, 1), (690, 1), (695, 1), (700, 1), (705, 1), (710, 1), (715, 1), (720, 0), (725, 0), (730, 0), (735, 0), (740, 0), (745, 0), (750, 0), (755, 0), (760, 0), (765, 0), (770, 1), (775, 1), (780, 1), (785, 1), (790, 0), (795, 0), (800, 0), (805, 0), (810, 0), (815, 0), (820, 0), (825, 0), (830, 1), (835, 1), (840, 1), (845, 1), (850, 1), (855, 1), (860, 0), (865, 0), (870, 0), (875, 1), (880, 1), (885, 1), (890, 1), (895, 1), (900, 1), (905, 0), (910, 0), (915, 0), (920, 0), (925, 0), (930, 0), (935, 1), (940, 1), (945, 1), (950, 1), (955, 1), (960, 1), (965, 1), (970, 0), (975, 0), (980, 0), (985, 0), (990, 0), (995, 0), (1000, 0), (1005, 0), (1010, 0), (1015, 0), (1020, 0), (1025, 0)]
Vdin0_6  din0_6  0 PWL (0n 0.0v 4.745n 0.0v 4.755n 0.95v 9.745n 0.95v 9.755n 0.95v 14.745n 0.95v 14.755n 0.95v 19.745n 0.95v 19.755n 0.95v 24.745n 0.95v 24.755n 0.95v 29.745n 0.95v 29.755n 0.95v 34.745n 0.95v 34.755n 0.95v 39.745n 0.95v 39.755n 0.95v 44.745n 0.95v 44.755n 0.95v 49.745n 0.95v 49.755n 0.0v 54.745n 0.0v 54.755n 0.0v 59.745n 0.0v 59.755n 0.0v 64.745n 0.0v 64.755n 0.0v 69.745n 0.0v 69.755n 0.0v 74.745n 0.0v 74.755n 0.95v 79.745n 0.95v 79.755n 0.95v 84.745n 0.95v 84.755n 0.95v 89.745n 0.95v 89.755n 0.95v 94.745n 0.95v 94.755n 0.0v 99.745n 0.0v 99.755n 0.0v 104.745n 0.0v 104.755n 0.0v 109.745n 0.0v 109.755n 0.0v 114.745n 0.0v 114.755n 0.0v 119.745n 0.0v 119.755n 0.0v 124.745n 0.0v 124.755n 0.0v 129.745n 0.0v 129.755n 0.0v 134.745n 0.0v 134.755n 0.0v 139.745n 0.0v 139.755n 0.0v 144.745n 0.0v 144.755n 0.0v 149.745n 0.0v 149.755n 0.95v 154.745n 0.95v 154.755n 0.95v 159.745n 0.95v 159.755n 0.0v 164.745n 0.0v 164.755n 0.95v 169.745n 0.95v 169.755n 0.95v 174.745n 0.95v 174.755n 0.95v 179.745n 0.95v 179.755n 0.95v 184.745n 0.95v 184.755n 0.95v 189.745n 0.95v 189.755n 0.95v 194.745n 0.95v 194.755n 0.95v 199.745n 0.95v 199.755n 0.95v 204.745n 0.95v 204.755n 0.95v 209.745n 0.95v 209.755n 0.95v 214.745n 0.95v 214.755n 0.95v 219.745n 0.95v 219.755n 0.95v 224.745n 0.95v 224.755n 0.95v 229.745n 0.95v 229.755n 0.95v 234.745n 0.95v 234.755n 0.95v 239.745n 0.95v 239.755n 0.0v 244.745n 0.0v 244.755n 0.0v 249.745n 0.0v 249.755n 0.0v 254.745n 0.0v 254.755n 0.0v 259.745n 0.0v 259.755n 0.0v 264.745n 0.0v 264.755n 0.95v 269.745n 0.95v 269.755n 0.95v 274.745n 0.95v 274.755n 0.95v 279.745n 0.95v 279.755n 0.95v 284.745n 0.95v 284.755n 0.95v 289.745n 0.95v 289.755n 0.95v 294.745n 0.95v 294.755n 0.95v 299.745n 0.95v 299.755n 0.95v 304.745n 0.95v 304.755n 0.95v 309.745n 0.95v 309.755n 0.95v 314.745n 0.95v 314.755n 0.95v 319.745n 0.95v 319.755n 0.0v 324.745n 0.0v 324.755n 0.95v 329.745n 0.95v 329.755n 0.95v 334.745n 0.95v 334.755n 0.95v 339.745n 0.95v 339.755n 0.95v 344.745n 0.95v 344.755n 0.95v 349.745n 0.95v 349.755n 0.95v 354.745n 0.95v 354.755n 0.95v 359.745n 0.95v 359.755n 0.95v 364.745n 0.95v 364.755n 0.95v 369.745n 0.95v 369.755n 0.95v 374.745n 0.95v 374.755n 0.95v 379.745n 0.95v 379.755n 0.95v 384.745n 0.95v 384.755n 0.95v 389.745n 0.95v 389.755n 0.95v 394.745n 0.95v 394.755n 0.95v 399.745n 0.95v 399.755n 0.95v 404.745n 0.95v 404.755n 0.95v 409.745n 0.95v 409.755n 0.95v 414.745n 0.95v 414.755n 0.95v 419.745n 0.95v 419.755n 0.95v 424.745n 0.95v 424.755n 0.95v 429.745n 0.95v 429.755n 0.95v 434.745n 0.95v 434.755n 0.95v 439.745n 0.95v 439.755n 0.95v 444.745n 0.95v 444.755n 0.95v 449.745n 0.95v 449.755n 0.95v 454.745n 0.95v 454.755n 0.95v 459.745n 0.95v 459.755n 0.95v 464.745n 0.95v 464.755n 0.95v 469.745n 0.95v 469.755n 0.95v 474.745n 0.95v 474.755n 0.95v 479.745n 0.95v 479.755n 0.95v 484.745n 0.95v 484.755n 0.95v 489.745n 0.95v 489.755n 0.95v 494.745n 0.95v 494.755n 0.95v 499.745n 0.95v 499.755n 0.95v 504.745n 0.95v 504.755n 0.95v 509.745n 0.95v 509.755n 0.0v 514.745n 0.0v 514.755n 0.0v 519.745n 0.0v 519.755n 0.0v 524.745n 0.0v 524.755n 0.95v 529.745n 0.95v 529.755n 0.95v 534.745n 0.95v 534.755n 0.95v 539.745n 0.95v 539.755n 0.95v 544.745n 0.95v 544.755n 0.95v 549.745n 0.95v 549.755n 0.0v 554.745n 0.0v 554.755n 0.0v 559.745n 0.0v 559.755n 0.0v 564.745n 0.0v 564.755n 0.0v 569.745n 0.0v 569.755n 0.0v 574.745n 0.0v 574.755n 0.0v 579.745n 0.0v 579.755n 0.0v 584.745n 0.0v 584.755n 0.0v 589.745n 0.0v 589.755n 0.0v 594.745n 0.0v 594.755n 0.0v 599.745n 0.0v 599.755n 0.0v 604.745n 0.0v 604.755n 0.0v 609.745n 0.0v 609.755n 0.0v 614.745n 0.0v 614.755n 0.95v 619.745n 0.95v 619.755n 0.95v 624.745n 0.95v 624.755n 0.95v 629.745n 0.95v 629.755n 0.95v 634.745n 0.95v 634.755n 0.95v 639.745n 0.95v 639.755n 0.95v 644.745n 0.95v 644.755n 0.95v 649.745n 0.95v 649.755n 0.95v 654.745n 0.95v 654.755n 0.0v 659.745n 0.0v 659.755n 0.0v 664.745n 0.0v 664.755n 0.0v 669.745n 0.0v 669.755n 0.0v 674.745n 0.0v 674.755n 0.0v 679.745n 0.0v 679.755n 0.0v 684.745n 0.0v 684.755n 0.95v 689.745n 0.95v 689.755n 0.95v 694.745n 0.95v 694.755n 0.95v 699.745n 0.95v 699.755n 0.95v 704.745n 0.95v 704.755n 0.95v 709.745n 0.95v 709.755n 0.95v 714.745n 0.95v 714.755n 0.95v 719.745n 0.95v 719.755n 0.0v 724.745n 0.0v 724.755n 0.0v 729.745n 0.0v 729.755n 0.0v 734.745n 0.0v 734.755n 0.0v 739.745n 0.0v 739.755n 0.0v 744.745n 0.0v 744.755n 0.0v 749.745n 0.0v 749.755n 0.0v 754.745n 0.0v 754.755n 0.0v 759.745n 0.0v 759.755n 0.0v 764.745n 0.0v 764.755n 0.0v 769.745n 0.0v 769.755n 0.95v 774.745n 0.95v 774.755n 0.95v 779.745n 0.95v 779.755n 0.95v 784.745n 0.95v 784.755n 0.95v 789.745n 0.95v 789.755n 0.0v 794.745n 0.0v 794.755n 0.0v 799.745n 0.0v 799.755n 0.0v 804.745n 0.0v 804.755n 0.0v 809.745n 0.0v 809.755n 0.0v 814.745n 0.0v 814.755n 0.0v 819.745n 0.0v 819.755n 0.0v 824.745n 0.0v 824.755n 0.0v 829.745n 0.0v 829.755n 0.95v 834.745n 0.95v 834.755n 0.95v 839.745n 0.95v 839.755n 0.95v 844.745n 0.95v 844.755n 0.95v 849.745n 0.95v 849.755n 0.95v 854.745n 0.95v 854.755n 0.95v 859.745n 0.95v 859.755n 0.0v 864.745n 0.0v 864.755n 0.0v 869.745n 0.0v 869.755n 0.0v 874.745n 0.0v 874.755n 0.95v 879.745n 0.95v 879.755n 0.95v 884.745n 0.95v 884.755n 0.95v 889.745n 0.95v 889.755n 0.95v 894.745n 0.95v 894.755n 0.95v 899.745n 0.95v 899.755n 0.95v 904.745n 0.95v 904.755n 0.0v 909.745n 0.0v 909.755n 0.0v 914.745n 0.0v 914.755n 0.0v 919.745n 0.0v 919.755n 0.0v 924.745n 0.0v 924.755n 0.0v 929.745n 0.0v 929.755n 0.0v 934.745n 0.0v 934.755n 0.95v 939.745n 0.95v 939.755n 0.95v 944.745n 0.95v 944.755n 0.95v 949.745n 0.95v 949.755n 0.95v 954.745n 0.95v 954.755n 0.95v 959.745n 0.95v 959.755n 0.95v 964.745n 0.95v 964.755n 0.95v 969.745n 0.95v 969.755n 0.0v 974.745n 0.0v 974.755n 0.0v 979.745n 0.0v 979.755n 0.0v 984.745n 0.0v 984.755n 0.0v 989.745n 0.0v 989.755n 0.0v 994.745n 0.0v 994.755n 0.0v 999.745n 0.0v 999.755n 0.0v 1004.745n 0.0v 1004.755n 0.0v 1009.745n 0.0v 1009.755n 0.0v 1014.745n 0.0v 1014.755n 0.0v 1019.745n 0.0v 1019.755n 0.0v 1024.745n 0.0v 1024.755n 0.0v )
* (time, data): [(0, 0), (5, 0), (10, 1), (15, 1), (20, 1), (25, 1), (30, 1), (35, 1), (40, 1), (45, 1), (50, 1), (55, 1), (60, 1), (65, 1), (70, 1), (75, 0), (80, 0), (85, 0), (90, 0), (95, 0), (100, 0), (105, 0), (110, 0), (115, 0), (120, 0), (125, 0), (130, 0), (135, 0), (140, 0), (145, 0), (150, 0), (155, 0), (160, 1), (165, 0), (170, 0), (175, 0), (180, 0), (185, 0), (190, 0), (195, 0), (200, 0), (205, 0), (210, 0), (215, 0), (220, 0), (225, 0), (230, 0), (235, 0), (240, 0), (245, 0), (250, 0), (255, 0), (260, 0), (265, 0), (270, 0), (275, 0), (280, 0), (285, 0), (290, 0), (295, 0), (300, 0), (305, 0), (310, 0), (315, 0), (320, 1), (325, 0), (330, 1), (335, 1), (340, 1), (345, 1), (350, 1), (355, 1), (360, 1), (365, 1), (370, 1), (375, 1), (380, 1), (385, 1), (390, 1), (395, 1), (400, 1), (405, 1), (410, 1), (415, 1), (420, 1), (425, 0), (430, 0), (435, 0), (440, 0), (445, 0), (450, 0), (455, 0), (460, 0), (465, 0), (470, 0), (475, 0), (480, 0), (485, 0), (490, 0), (495, 0), (500, 0), (505, 0), (510, 0), (515, 0), (520, 0), (525, 1), (530, 1), (535, 1), (540, 1), (545, 1), (550, 1), (555, 1), (560, 1), (565, 1), (570, 1), (575, 1), (580, 1), (585, 1), (590, 0), (595, 0), (600, 0), (605, 0), (610, 0), (615, 1), (620, 1), (625, 1), (630, 1), (635, 1), (640, 1), (645, 1), (650, 1), (655, 0), (660, 0), (665, 0), (670, 0), (675, 0), (680, 0), (685, 0), (690, 0), (695, 0), (700, 0), (705, 0), (710, 0), (715, 0), (720, 0), (725, 0), (730, 0), (735, 0), (740, 0), (745, 0), (750, 0), (755, 0), (760, 0), (765, 0), (770, 0), (775, 0), (780, 0), (785, 0), (790, 1), (795, 1), (800, 1), (805, 1), (810, 1), (815, 1), (820, 1), (825, 1), (830, 1), (835, 1), (840, 1), (845, 0), (850, 0), (855, 0), (860, 0), (865, 0), (870, 0), (875, 0), (880, 0), (885, 0), (890, 0), (895, 0), (900, 1), (905, 1), (910, 1), (915, 1), (920, 1), (925, 1), (930, 1), (935, 0), (940, 0), (945, 0), (950, 0), (955, 0), (960, 0), (965, 0), (970, 1), (975, 1), (980, 1), (985, 1), (990, 1), (995, 1), (1000, 1), (1005, 1), (1010, 1), (1015, 1), (1020, 1), (1025, 1)]
Vdin0_7  din0_7  0 PWL (0n 0.0v 4.745n 0.0v 4.755n 0.0v 9.745n 0.0v 9.755n 0.95v 14.745n 0.95v 14.755n 0.95v 19.745n 0.95v 19.755n 0.95v 24.745n 0.95v 24.755n 0.95v 29.745n 0.95v 29.755n 0.95v 34.745n 0.95v 34.755n 0.95v 39.745n 0.95v 39.755n 0.95v 44.745n 0.95v 44.755n 0.95v 49.745n 0.95v 49.755n 0.95v 54.745n 0.95v 54.755n 0.95v 59.745n 0.95v 59.755n 0.95v 64.745n 0.95v 64.755n 0.95v 69.745n 0.95v 69.755n 0.95v 74.745n 0.95v 74.755n 0.0v 79.745n 0.0v 79.755n 0.0v 84.745n 0.0v 84.755n 0.0v 89.745n 0.0v 89.755n 0.0v 94.745n 0.0v 94.755n 0.0v 99.745n 0.0v 99.755n 0.0v 104.745n 0.0v 104.755n 0.0v 109.745n 0.0v 109.755n 0.0v 114.745n 0.0v 114.755n 0.0v 119.745n 0.0v 119.755n 0.0v 124.745n 0.0v 124.755n 0.0v 129.745n 0.0v 129.755n 0.0v 134.745n 0.0v 134.755n 0.0v 139.745n 0.0v 139.755n 0.0v 144.745n 0.0v 144.755n 0.0v 149.745n 0.0v 149.755n 0.0v 154.745n 0.0v 154.755n 0.0v 159.745n 0.0v 159.755n 0.95v 164.745n 0.95v 164.755n 0.0v 169.745n 0.0v 169.755n 0.0v 174.745n 0.0v 174.755n 0.0v 179.745n 0.0v 179.755n 0.0v 184.745n 0.0v 184.755n 0.0v 189.745n 0.0v 189.755n 0.0v 194.745n 0.0v 194.755n 0.0v 199.745n 0.0v 199.755n 0.0v 204.745n 0.0v 204.755n 0.0v 209.745n 0.0v 209.755n 0.0v 214.745n 0.0v 214.755n 0.0v 219.745n 0.0v 219.755n 0.0v 224.745n 0.0v 224.755n 0.0v 229.745n 0.0v 229.755n 0.0v 234.745n 0.0v 234.755n 0.0v 239.745n 0.0v 239.755n 0.0v 244.745n 0.0v 244.755n 0.0v 249.745n 0.0v 249.755n 0.0v 254.745n 0.0v 254.755n 0.0v 259.745n 0.0v 259.755n 0.0v 264.745n 0.0v 264.755n 0.0v 269.745n 0.0v 269.755n 0.0v 274.745n 0.0v 274.755n 0.0v 279.745n 0.0v 279.755n 0.0v 284.745n 0.0v 284.755n 0.0v 289.745n 0.0v 289.755n 0.0v 294.745n 0.0v 294.755n 0.0v 299.745n 0.0v 299.755n 0.0v 304.745n 0.0v 304.755n 0.0v 309.745n 0.0v 309.755n 0.0v 314.745n 0.0v 314.755n 0.0v 319.745n 0.0v 319.755n 0.95v 324.745n 0.95v 324.755n 0.0v 329.745n 0.0v 329.755n 0.95v 334.745n 0.95v 334.755n 0.95v 339.745n 0.95v 339.755n 0.95v 344.745n 0.95v 344.755n 0.95v 349.745n 0.95v 349.755n 0.95v 354.745n 0.95v 354.755n 0.95v 359.745n 0.95v 359.755n 0.95v 364.745n 0.95v 364.755n 0.95v 369.745n 0.95v 369.755n 0.95v 374.745n 0.95v 374.755n 0.95v 379.745n 0.95v 379.755n 0.95v 384.745n 0.95v 384.755n 0.95v 389.745n 0.95v 389.755n 0.95v 394.745n 0.95v 394.755n 0.95v 399.745n 0.95v 399.755n 0.95v 404.745n 0.95v 404.755n 0.95v 409.745n 0.95v 409.755n 0.95v 414.745n 0.95v 414.755n 0.95v 419.745n 0.95v 419.755n 0.95v 424.745n 0.95v 424.755n 0.0v 429.745n 0.0v 429.755n 0.0v 434.745n 0.0v 434.755n 0.0v 439.745n 0.0v 439.755n 0.0v 444.745n 0.0v 444.755n 0.0v 449.745n 0.0v 449.755n 0.0v 454.745n 0.0v 454.755n 0.0v 459.745n 0.0v 459.755n 0.0v 464.745n 0.0v 464.755n 0.0v 469.745n 0.0v 469.755n 0.0v 474.745n 0.0v 474.755n 0.0v 479.745n 0.0v 479.755n 0.0v 484.745n 0.0v 484.755n 0.0v 489.745n 0.0v 489.755n 0.0v 494.745n 0.0v 494.755n 0.0v 499.745n 0.0v 499.755n 0.0v 504.745n 0.0v 504.755n 0.0v 509.745n 0.0v 509.755n 0.0v 514.745n 0.0v 514.755n 0.0v 519.745n 0.0v 519.755n 0.0v 524.745n 0.0v 524.755n 0.95v 529.745n 0.95v 529.755n 0.95v 534.745n 0.95v 534.755n 0.95v 539.745n 0.95v 539.755n 0.95v 544.745n 0.95v 544.755n 0.95v 549.745n 0.95v 549.755n 0.95v 554.745n 0.95v 554.755n 0.95v 559.745n 0.95v 559.755n 0.95v 564.745n 0.95v 564.755n 0.95v 569.745n 0.95v 569.755n 0.95v 574.745n 0.95v 574.755n 0.95v 579.745n 0.95v 579.755n 0.95v 584.745n 0.95v 584.755n 0.95v 589.745n 0.95v 589.755n 0.0v 594.745n 0.0v 594.755n 0.0v 599.745n 0.0v 599.755n 0.0v 604.745n 0.0v 604.755n 0.0v 609.745n 0.0v 609.755n 0.0v 614.745n 0.0v 614.755n 0.95v 619.745n 0.95v 619.755n 0.95v 624.745n 0.95v 624.755n 0.95v 629.745n 0.95v 629.755n 0.95v 634.745n 0.95v 634.755n 0.95v 639.745n 0.95v 639.755n 0.95v 644.745n 0.95v 644.755n 0.95v 649.745n 0.95v 649.755n 0.95v 654.745n 0.95v 654.755n 0.0v 659.745n 0.0v 659.755n 0.0v 664.745n 0.0v 664.755n 0.0v 669.745n 0.0v 669.755n 0.0v 674.745n 0.0v 674.755n 0.0v 679.745n 0.0v 679.755n 0.0v 684.745n 0.0v 684.755n 0.0v 689.745n 0.0v 689.755n 0.0v 694.745n 0.0v 694.755n 0.0v 699.745n 0.0v 699.755n 0.0v 704.745n 0.0v 704.755n 0.0v 709.745n 0.0v 709.755n 0.0v 714.745n 0.0v 714.755n 0.0v 719.745n 0.0v 719.755n 0.0v 724.745n 0.0v 724.755n 0.0v 729.745n 0.0v 729.755n 0.0v 734.745n 0.0v 734.755n 0.0v 739.745n 0.0v 739.755n 0.0v 744.745n 0.0v 744.755n 0.0v 749.745n 0.0v 749.755n 0.0v 754.745n 0.0v 754.755n 0.0v 759.745n 0.0v 759.755n 0.0v 764.745n 0.0v 764.755n 0.0v 769.745n 0.0v 769.755n 0.0v 774.745n 0.0v 774.755n 0.0v 779.745n 0.0v 779.755n 0.0v 784.745n 0.0v 784.755n 0.0v 789.745n 0.0v 789.755n 0.95v 794.745n 0.95v 794.755n 0.95v 799.745n 0.95v 799.755n 0.95v 804.745n 0.95v 804.755n 0.95v 809.745n 0.95v 809.755n 0.95v 814.745n 0.95v 814.755n 0.95v 819.745n 0.95v 819.755n 0.95v 824.745n 0.95v 824.755n 0.95v 829.745n 0.95v 829.755n 0.95v 834.745n 0.95v 834.755n 0.95v 839.745n 0.95v 839.755n 0.95v 844.745n 0.95v 844.755n 0.0v 849.745n 0.0v 849.755n 0.0v 854.745n 0.0v 854.755n 0.0v 859.745n 0.0v 859.755n 0.0v 864.745n 0.0v 864.755n 0.0v 869.745n 0.0v 869.755n 0.0v 874.745n 0.0v 874.755n 0.0v 879.745n 0.0v 879.755n 0.0v 884.745n 0.0v 884.755n 0.0v 889.745n 0.0v 889.755n 0.0v 894.745n 0.0v 894.755n 0.0v 899.745n 0.0v 899.755n 0.95v 904.745n 0.95v 904.755n 0.95v 909.745n 0.95v 909.755n 0.95v 914.745n 0.95v 914.755n 0.95v 919.745n 0.95v 919.755n 0.95v 924.745n 0.95v 924.755n 0.95v 929.745n 0.95v 929.755n 0.95v 934.745n 0.95v 934.755n 0.0v 939.745n 0.0v 939.755n 0.0v 944.745n 0.0v 944.755n 0.0v 949.745n 0.0v 949.755n 0.0v 954.745n 0.0v 954.755n 0.0v 959.745n 0.0v 959.755n 0.0v 964.745n 0.0v 964.755n 0.0v 969.745n 0.0v 969.755n 0.95v 974.745n 0.95v 974.755n 0.95v 979.745n 0.95v 979.755n 0.95v 984.745n 0.95v 984.755n 0.95v 989.745n 0.95v 989.755n 0.95v 994.745n 0.95v 994.755n 0.95v 999.745n 0.95v 999.755n 0.95v 1004.745n 0.95v 1004.755n 0.95v 1009.745n 0.95v 1009.755n 0.95v 1014.745n 0.95v 1014.755n 0.95v 1019.745n 0.95v 1019.755n 0.95v 1024.745n 0.95v 1024.755n 0.95v )
* (time, data): [(0, 0), (5, 1), (10, 0), (15, 0), (20, 0), (25, 0), (30, 0), (35, 0), (40, 0), (45, 0), (50, 0), (55, 0), (60, 0), (65, 0), (70, 0), (75, 1), (80, 1), (85, 1), (90, 1), (95, 0), (100, 0), (105, 0), (110, 0), (115, 1), (120, 1), (125, 1), (130, 1), (135, 1), (140, 1), (145, 1), (150, 0), (155, 0), (160, 1), (165, 0), (170, 0), (175, 0), (180, 0), (185, 0), (190, 1), (195, 1), (200, 1), (205, 1), (210, 1), (215, 1), (220, 1), (225, 1), (230, 1), (235, 1), (240, 1), (245, 1), (250, 1), (255, 1), (260, 1), (265, 0), (270, 0), (275, 0), (280, 0), (285, 0), (290, 1), (295, 1), (300, 1), (305, 1), (310, 1), (315, 1), (320, 1), (325, 0), (330, 1), (335, 1), (340, 1), (345, 1), (350, 1), (355, 1), (360, 1), (365, 1), (370, 1), (375, 1), (380, 1), (385, 1), (390, 1), (395, 1), (400, 1), (405, 1), (410, 1), (415, 1), (420, 1), (425, 1), (430, 1), (435, 1), (440, 1), (445, 1), (450, 1), (455, 1), (460, 1), (465, 1), (470, 1), (475, 1), (480, 1), (485, 1), (490, 1), (495, 1), (500, 1), (505, 1), (510, 0), (515, 0), (520, 0), (525, 0), (530, 1), (535, 1), (540, 1), (545, 1), (550, 1), (555, 1), (560, 1), (565, 1), (570, 0), (575, 0), (580, 0), (585, 0), (590, 0), (595, 0), (600, 0), (605, 0), (610, 0), (615, 1), (620, 1), (625, 1), (630, 1), (635, 1), (640, 1), (645, 1), (650, 1), (655, 1), (660, 1), (665, 1), (670, 1), (675, 1), (680, 1), (685, 0), (690, 0), (695, 0), (700, 0), (705, 0), (710, 0), (715, 0), (720, 0), (725, 0), (730, 0), (735, 0), (740, 0), (745, 0), (750, 0), (755, 0), (760, 0), (765, 0), (770, 0), (775, 0), (780, 0), (785, 0), (790, 0), (795, 0), (800, 0), (805, 0), (810, 0), (815, 0), (820, 1), (825, 1), (830, 1), (835, 1), (840, 1), (845, 1), (850, 1), (855, 1), (860, 1), (865, 1), (870, 1), (875, 0), (880, 0), (885, 0), (890, 0), (895, 0), (900, 1), (905, 1), (910, 1), (915, 1), (920, 1), (925, 1), (930, 1), (935, 1), (940, 0), (945, 0), (950, 0), (955, 0), (960, 0), (965, 0), (970, 1), (975, 1), (980, 1), (985, 1), (990, 1), (995, 1), (1000, 1), (1005, 1), (1010, 1), (1015, 1), (1020, 1), (1025, 1)]
Vdin0_8  din0_8  0 PWL (0n 0.0v 4.745n 0.0v 4.755n 0.95v 9.745n 0.95v 9.755n 0.0v 14.745n 0.0v 14.755n 0.0v 19.745n 0.0v 19.755n 0.0v 24.745n 0.0v 24.755n 0.0v 29.745n 0.0v 29.755n 0.0v 34.745n 0.0v 34.755n 0.0v 39.745n 0.0v 39.755n 0.0v 44.745n 0.0v 44.755n 0.0v 49.745n 0.0v 49.755n 0.0v 54.745n 0.0v 54.755n 0.0v 59.745n 0.0v 59.755n 0.0v 64.745n 0.0v 64.755n 0.0v 69.745n 0.0v 69.755n 0.0v 74.745n 0.0v 74.755n 0.95v 79.745n 0.95v 79.755n 0.95v 84.745n 0.95v 84.755n 0.95v 89.745n 0.95v 89.755n 0.95v 94.745n 0.95v 94.755n 0.0v 99.745n 0.0v 99.755n 0.0v 104.745n 0.0v 104.755n 0.0v 109.745n 0.0v 109.755n 0.0v 114.745n 0.0v 114.755n 0.95v 119.745n 0.95v 119.755n 0.95v 124.745n 0.95v 124.755n 0.95v 129.745n 0.95v 129.755n 0.95v 134.745n 0.95v 134.755n 0.95v 139.745n 0.95v 139.755n 0.95v 144.745n 0.95v 144.755n 0.95v 149.745n 0.95v 149.755n 0.0v 154.745n 0.0v 154.755n 0.0v 159.745n 0.0v 159.755n 0.95v 164.745n 0.95v 164.755n 0.0v 169.745n 0.0v 169.755n 0.0v 174.745n 0.0v 174.755n 0.0v 179.745n 0.0v 179.755n 0.0v 184.745n 0.0v 184.755n 0.0v 189.745n 0.0v 189.755n 0.95v 194.745n 0.95v 194.755n 0.95v 199.745n 0.95v 199.755n 0.95v 204.745n 0.95v 204.755n 0.95v 209.745n 0.95v 209.755n 0.95v 214.745n 0.95v 214.755n 0.95v 219.745n 0.95v 219.755n 0.95v 224.745n 0.95v 224.755n 0.95v 229.745n 0.95v 229.755n 0.95v 234.745n 0.95v 234.755n 0.95v 239.745n 0.95v 239.755n 0.95v 244.745n 0.95v 244.755n 0.95v 249.745n 0.95v 249.755n 0.95v 254.745n 0.95v 254.755n 0.95v 259.745n 0.95v 259.755n 0.95v 264.745n 0.95v 264.755n 0.0v 269.745n 0.0v 269.755n 0.0v 274.745n 0.0v 274.755n 0.0v 279.745n 0.0v 279.755n 0.0v 284.745n 0.0v 284.755n 0.0v 289.745n 0.0v 289.755n 0.95v 294.745n 0.95v 294.755n 0.95v 299.745n 0.95v 299.755n 0.95v 304.745n 0.95v 304.755n 0.95v 309.745n 0.95v 309.755n 0.95v 314.745n 0.95v 314.755n 0.95v 319.745n 0.95v 319.755n 0.95v 324.745n 0.95v 324.755n 0.0v 329.745n 0.0v 329.755n 0.95v 334.745n 0.95v 334.755n 0.95v 339.745n 0.95v 339.755n 0.95v 344.745n 0.95v 344.755n 0.95v 349.745n 0.95v 349.755n 0.95v 354.745n 0.95v 354.755n 0.95v 359.745n 0.95v 359.755n 0.95v 364.745n 0.95v 364.755n 0.95v 369.745n 0.95v 369.755n 0.95v 374.745n 0.95v 374.755n 0.95v 379.745n 0.95v 379.755n 0.95v 384.745n 0.95v 384.755n 0.95v 389.745n 0.95v 389.755n 0.95v 394.745n 0.95v 394.755n 0.95v 399.745n 0.95v 399.755n 0.95v 404.745n 0.95v 404.755n 0.95v 409.745n 0.95v 409.755n 0.95v 414.745n 0.95v 414.755n 0.95v 419.745n 0.95v 419.755n 0.95v 424.745n 0.95v 424.755n 0.95v 429.745n 0.95v 429.755n 0.95v 434.745n 0.95v 434.755n 0.95v 439.745n 0.95v 439.755n 0.95v 444.745n 0.95v 444.755n 0.95v 449.745n 0.95v 449.755n 0.95v 454.745n 0.95v 454.755n 0.95v 459.745n 0.95v 459.755n 0.95v 464.745n 0.95v 464.755n 0.95v 469.745n 0.95v 469.755n 0.95v 474.745n 0.95v 474.755n 0.95v 479.745n 0.95v 479.755n 0.95v 484.745n 0.95v 484.755n 0.95v 489.745n 0.95v 489.755n 0.95v 494.745n 0.95v 494.755n 0.95v 499.745n 0.95v 499.755n 0.95v 504.745n 0.95v 504.755n 0.95v 509.745n 0.95v 509.755n 0.0v 514.745n 0.0v 514.755n 0.0v 519.745n 0.0v 519.755n 0.0v 524.745n 0.0v 524.755n 0.0v 529.745n 0.0v 529.755n 0.95v 534.745n 0.95v 534.755n 0.95v 539.745n 0.95v 539.755n 0.95v 544.745n 0.95v 544.755n 0.95v 549.745n 0.95v 549.755n 0.95v 554.745n 0.95v 554.755n 0.95v 559.745n 0.95v 559.755n 0.95v 564.745n 0.95v 564.755n 0.95v 569.745n 0.95v 569.755n 0.0v 574.745n 0.0v 574.755n 0.0v 579.745n 0.0v 579.755n 0.0v 584.745n 0.0v 584.755n 0.0v 589.745n 0.0v 589.755n 0.0v 594.745n 0.0v 594.755n 0.0v 599.745n 0.0v 599.755n 0.0v 604.745n 0.0v 604.755n 0.0v 609.745n 0.0v 609.755n 0.0v 614.745n 0.0v 614.755n 0.95v 619.745n 0.95v 619.755n 0.95v 624.745n 0.95v 624.755n 0.95v 629.745n 0.95v 629.755n 0.95v 634.745n 0.95v 634.755n 0.95v 639.745n 0.95v 639.755n 0.95v 644.745n 0.95v 644.755n 0.95v 649.745n 0.95v 649.755n 0.95v 654.745n 0.95v 654.755n 0.95v 659.745n 0.95v 659.755n 0.95v 664.745n 0.95v 664.755n 0.95v 669.745n 0.95v 669.755n 0.95v 674.745n 0.95v 674.755n 0.95v 679.745n 0.95v 679.755n 0.95v 684.745n 0.95v 684.755n 0.0v 689.745n 0.0v 689.755n 0.0v 694.745n 0.0v 694.755n 0.0v 699.745n 0.0v 699.755n 0.0v 704.745n 0.0v 704.755n 0.0v 709.745n 0.0v 709.755n 0.0v 714.745n 0.0v 714.755n 0.0v 719.745n 0.0v 719.755n 0.0v 724.745n 0.0v 724.755n 0.0v 729.745n 0.0v 729.755n 0.0v 734.745n 0.0v 734.755n 0.0v 739.745n 0.0v 739.755n 0.0v 744.745n 0.0v 744.755n 0.0v 749.745n 0.0v 749.755n 0.0v 754.745n 0.0v 754.755n 0.0v 759.745n 0.0v 759.755n 0.0v 764.745n 0.0v 764.755n 0.0v 769.745n 0.0v 769.755n 0.0v 774.745n 0.0v 774.755n 0.0v 779.745n 0.0v 779.755n 0.0v 784.745n 0.0v 784.755n 0.0v 789.745n 0.0v 789.755n 0.0v 794.745n 0.0v 794.755n 0.0v 799.745n 0.0v 799.755n 0.0v 804.745n 0.0v 804.755n 0.0v 809.745n 0.0v 809.755n 0.0v 814.745n 0.0v 814.755n 0.0v 819.745n 0.0v 819.755n 0.95v 824.745n 0.95v 824.755n 0.95v 829.745n 0.95v 829.755n 0.95v 834.745n 0.95v 834.755n 0.95v 839.745n 0.95v 839.755n 0.95v 844.745n 0.95v 844.755n 0.95v 849.745n 0.95v 849.755n 0.95v 854.745n 0.95v 854.755n 0.95v 859.745n 0.95v 859.755n 0.95v 864.745n 0.95v 864.755n 0.95v 869.745n 0.95v 869.755n 0.95v 874.745n 0.95v 874.755n 0.0v 879.745n 0.0v 879.755n 0.0v 884.745n 0.0v 884.755n 0.0v 889.745n 0.0v 889.755n 0.0v 894.745n 0.0v 894.755n 0.0v 899.745n 0.0v 899.755n 0.95v 904.745n 0.95v 904.755n 0.95v 909.745n 0.95v 909.755n 0.95v 914.745n 0.95v 914.755n 0.95v 919.745n 0.95v 919.755n 0.95v 924.745n 0.95v 924.755n 0.95v 929.745n 0.95v 929.755n 0.95v 934.745n 0.95v 934.755n 0.95v 939.745n 0.95v 939.755n 0.0v 944.745n 0.0v 944.755n 0.0v 949.745n 0.0v 949.755n 0.0v 954.745n 0.0v 954.755n 0.0v 959.745n 0.0v 959.755n 0.0v 964.745n 0.0v 964.755n 0.0v 969.745n 0.0v 969.755n 0.95v 974.745n 0.95v 974.755n 0.95v 979.745n 0.95v 979.755n 0.95v 984.745n 0.95v 984.755n 0.95v 989.745n 0.95v 989.755n 0.95v 994.745n 0.95v 994.755n 0.95v 999.745n 0.95v 999.755n 0.95v 1004.745n 0.95v 1004.755n 0.95v 1009.745n 0.95v 1009.755n 0.95v 1014.745n 0.95v 1014.755n 0.95v 1019.745n 0.95v 1019.755n 0.95v 1024.745n 0.95v 1024.755n 0.95v )
* (time, data): [(0, 0), (5, 1), (10, 1), (15, 0), (20, 0), (25, 0), (30, 0), (35, 0), (40, 0), (45, 0), (50, 1), (55, 1), (60, 1), (65, 1), (70, 1), (75, 0), (80, 0), (85, 0), (90, 0), (95, 0), (100, 0), (105, 0), (110, 0), (115, 0), (120, 0), (125, 0), (130, 0), (135, 0), (140, 0), (145, 0), (150, 1), (155, 1), (160, 1), (165, 0), (170, 0), (175, 0), (180, 0), (185, 0), (190, 0), (195, 0), (200, 0), (205, 0), (210, 0), (215, 0), (220, 0), (225, 0), (230, 0), (235, 0), (240, 0), (245, 0), (250, 0), (255, 0), (260, 0), (265, 1), (270, 1), (275, 1), (280, 1), (285, 1), (290, 0), (295, 0), (300, 0), (305, 0), (310, 0), (315, 0), (320, 0), (325, 0), (330, 0), (335, 0), (340, 0), (345, 0), (350, 0), (355, 0), (360, 0), (365, 0), (370, 0), (375, 0), (380, 0), (385, 0), (390, 0), (395, 0), (400, 0), (405, 0), (410, 0), (415, 0), (420, 0), (425, 0), (430, 0), (435, 0), (440, 0), (445, 0), (450, 0), (455, 0), (460, 0), (465, 0), (470, 0), (475, 0), (480, 0), (485, 0), (490, 0), (495, 0), (500, 0), (505, 0), (510, 1), (515, 1), (520, 1), (525, 1), (530, 0), (535, 0), (540, 0), (545, 0), (550, 1), (555, 1), (560, 1), (565, 1), (570, 0), (575, 0), (580, 0), (585, 0), (590, 0), (595, 0), (600, 1), (605, 1), (610, 1), (615, 1), (620, 1), (625, 1), (630, 1), (635, 1), (640, 1), (645, 1), (650, 1), (655, 1), (660, 1), (665, 1), (670, 1), (675, 1), (680, 1), (685, 1), (690, 1), (695, 1), (700, 1), (705, 1), (710, 1), (715, 1), (720, 0), (725, 0), (730, 0), (735, 0), (740, 0), (745, 0), (750, 0), (755, 0), (760, 0), (765, 0), (770, 0), (775, 0), (780, 0), (785, 0), (790, 1), (795, 1), (800, 1), (805, 1), (810, 1), (815, 1), (820, 0), (825, 0), (830, 1), (835, 1), (840, 1), (845, 1), (850, 1), (855, 1), (860, 1), (865, 1), (870, 1), (875, 0), (880, 0), (885, 0), (890, 0), (895, 0), (900, 0), (905, 0), (910, 0), (915, 0), (920, 0), (925, 0), (930, 0), (935, 1), (940, 0), (945, 0), (950, 0), (955, 0), (960, 0), (965, 0), (970, 0), (975, 0), (980, 0), (985, 0), (990, 0), (995, 0), (1000, 0), (1005, 0), (1010, 0), (1015, 0), (1020, 0), (1025, 0)]
Vdin0_9  din0_9  0 PWL (0n 0.0v 4.745n 0.0v 4.755n 0.95v 9.745n 0.95v 9.755n 0.95v 14.745n 0.95v 14.755n 0.0v 19.745n 0.0v 19.755n 0.0v 24.745n 0.0v 24.755n 0.0v 29.745n 0.0v 29.755n 0.0v 34.745n 0.0v 34.755n 0.0v 39.745n 0.0v 39.755n 0.0v 44.745n 0.0v 44.755n 0.0v 49.745n 0.0v 49.755n 0.95v 54.745n 0.95v 54.755n 0.95v 59.745n 0.95v 59.755n 0.95v 64.745n 0.95v 64.755n 0.95v 69.745n 0.95v 69.755n 0.95v 74.745n 0.95v 74.755n 0.0v 79.745n 0.0v 79.755n 0.0v 84.745n 0.0v 84.755n 0.0v 89.745n 0.0v 89.755n 0.0v 94.745n 0.0v 94.755n 0.0v 99.745n 0.0v 99.755n 0.0v 104.745n 0.0v 104.755n 0.0v 109.745n 0.0v 109.755n 0.0v 114.745n 0.0v 114.755n 0.0v 119.745n 0.0v 119.755n 0.0v 124.745n 0.0v 124.755n 0.0v 129.745n 0.0v 129.755n 0.0v 134.745n 0.0v 134.755n 0.0v 139.745n 0.0v 139.755n 0.0v 144.745n 0.0v 144.755n 0.0v 149.745n 0.0v 149.755n 0.95v 154.745n 0.95v 154.755n 0.95v 159.745n 0.95v 159.755n 0.95v 164.745n 0.95v 164.755n 0.0v 169.745n 0.0v 169.755n 0.0v 174.745n 0.0v 174.755n 0.0v 179.745n 0.0v 179.755n 0.0v 184.745n 0.0v 184.755n 0.0v 189.745n 0.0v 189.755n 0.0v 194.745n 0.0v 194.755n 0.0v 199.745n 0.0v 199.755n 0.0v 204.745n 0.0v 204.755n 0.0v 209.745n 0.0v 209.755n 0.0v 214.745n 0.0v 214.755n 0.0v 219.745n 0.0v 219.755n 0.0v 224.745n 0.0v 224.755n 0.0v 229.745n 0.0v 229.755n 0.0v 234.745n 0.0v 234.755n 0.0v 239.745n 0.0v 239.755n 0.0v 244.745n 0.0v 244.755n 0.0v 249.745n 0.0v 249.755n 0.0v 254.745n 0.0v 254.755n 0.0v 259.745n 0.0v 259.755n 0.0v 264.745n 0.0v 264.755n 0.95v 269.745n 0.95v 269.755n 0.95v 274.745n 0.95v 274.755n 0.95v 279.745n 0.95v 279.755n 0.95v 284.745n 0.95v 284.755n 0.95v 289.745n 0.95v 289.755n 0.0v 294.745n 0.0v 294.755n 0.0v 299.745n 0.0v 299.755n 0.0v 304.745n 0.0v 304.755n 0.0v 309.745n 0.0v 309.755n 0.0v 314.745n 0.0v 314.755n 0.0v 319.745n 0.0v 319.755n 0.0v 324.745n 0.0v 324.755n 0.0v 329.745n 0.0v 329.755n 0.0v 334.745n 0.0v 334.755n 0.0v 339.745n 0.0v 339.755n 0.0v 344.745n 0.0v 344.755n 0.0v 349.745n 0.0v 349.755n 0.0v 354.745n 0.0v 354.755n 0.0v 359.745n 0.0v 359.755n 0.0v 364.745n 0.0v 364.755n 0.0v 369.745n 0.0v 369.755n 0.0v 374.745n 0.0v 374.755n 0.0v 379.745n 0.0v 379.755n 0.0v 384.745n 0.0v 384.755n 0.0v 389.745n 0.0v 389.755n 0.0v 394.745n 0.0v 394.755n 0.0v 399.745n 0.0v 399.755n 0.0v 404.745n 0.0v 404.755n 0.0v 409.745n 0.0v 409.755n 0.0v 414.745n 0.0v 414.755n 0.0v 419.745n 0.0v 419.755n 0.0v 424.745n 0.0v 424.755n 0.0v 429.745n 0.0v 429.755n 0.0v 434.745n 0.0v 434.755n 0.0v 439.745n 0.0v 439.755n 0.0v 444.745n 0.0v 444.755n 0.0v 449.745n 0.0v 449.755n 0.0v 454.745n 0.0v 454.755n 0.0v 459.745n 0.0v 459.755n 0.0v 464.745n 0.0v 464.755n 0.0v 469.745n 0.0v 469.755n 0.0v 474.745n 0.0v 474.755n 0.0v 479.745n 0.0v 479.755n 0.0v 484.745n 0.0v 484.755n 0.0v 489.745n 0.0v 489.755n 0.0v 494.745n 0.0v 494.755n 0.0v 499.745n 0.0v 499.755n 0.0v 504.745n 0.0v 504.755n 0.0v 509.745n 0.0v 509.755n 0.95v 514.745n 0.95v 514.755n 0.95v 519.745n 0.95v 519.755n 0.95v 524.745n 0.95v 524.755n 0.95v 529.745n 0.95v 529.755n 0.0v 534.745n 0.0v 534.755n 0.0v 539.745n 0.0v 539.755n 0.0v 544.745n 0.0v 544.755n 0.0v 549.745n 0.0v 549.755n 0.95v 554.745n 0.95v 554.755n 0.95v 559.745n 0.95v 559.755n 0.95v 564.745n 0.95v 564.755n 0.95v 569.745n 0.95v 569.755n 0.0v 574.745n 0.0v 574.755n 0.0v 579.745n 0.0v 579.755n 0.0v 584.745n 0.0v 584.755n 0.0v 589.745n 0.0v 589.755n 0.0v 594.745n 0.0v 594.755n 0.0v 599.745n 0.0v 599.755n 0.95v 604.745n 0.95v 604.755n 0.95v 609.745n 0.95v 609.755n 0.95v 614.745n 0.95v 614.755n 0.95v 619.745n 0.95v 619.755n 0.95v 624.745n 0.95v 624.755n 0.95v 629.745n 0.95v 629.755n 0.95v 634.745n 0.95v 634.755n 0.95v 639.745n 0.95v 639.755n 0.95v 644.745n 0.95v 644.755n 0.95v 649.745n 0.95v 649.755n 0.95v 654.745n 0.95v 654.755n 0.95v 659.745n 0.95v 659.755n 0.95v 664.745n 0.95v 664.755n 0.95v 669.745n 0.95v 669.755n 0.95v 674.745n 0.95v 674.755n 0.95v 679.745n 0.95v 679.755n 0.95v 684.745n 0.95v 684.755n 0.95v 689.745n 0.95v 689.755n 0.95v 694.745n 0.95v 694.755n 0.95v 699.745n 0.95v 699.755n 0.95v 704.745n 0.95v 704.755n 0.95v 709.745n 0.95v 709.755n 0.95v 714.745n 0.95v 714.755n 0.95v 719.745n 0.95v 719.755n 0.0v 724.745n 0.0v 724.755n 0.0v 729.745n 0.0v 729.755n 0.0v 734.745n 0.0v 734.755n 0.0v 739.745n 0.0v 739.755n 0.0v 744.745n 0.0v 744.755n 0.0v 749.745n 0.0v 749.755n 0.0v 754.745n 0.0v 754.755n 0.0v 759.745n 0.0v 759.755n 0.0v 764.745n 0.0v 764.755n 0.0v 769.745n 0.0v 769.755n 0.0v 774.745n 0.0v 774.755n 0.0v 779.745n 0.0v 779.755n 0.0v 784.745n 0.0v 784.755n 0.0v 789.745n 0.0v 789.755n 0.95v 794.745n 0.95v 794.755n 0.95v 799.745n 0.95v 799.755n 0.95v 804.745n 0.95v 804.755n 0.95v 809.745n 0.95v 809.755n 0.95v 814.745n 0.95v 814.755n 0.95v 819.745n 0.95v 819.755n 0.0v 824.745n 0.0v 824.755n 0.0v 829.745n 0.0v 829.755n 0.95v 834.745n 0.95v 834.755n 0.95v 839.745n 0.95v 839.755n 0.95v 844.745n 0.95v 844.755n 0.95v 849.745n 0.95v 849.755n 0.95v 854.745n 0.95v 854.755n 0.95v 859.745n 0.95v 859.755n 0.95v 864.745n 0.95v 864.755n 0.95v 869.745n 0.95v 869.755n 0.95v 874.745n 0.95v 874.755n 0.0v 879.745n 0.0v 879.755n 0.0v 884.745n 0.0v 884.755n 0.0v 889.745n 0.0v 889.755n 0.0v 894.745n 0.0v 894.755n 0.0v 899.745n 0.0v 899.755n 0.0v 904.745n 0.0v 904.755n 0.0v 909.745n 0.0v 909.755n 0.0v 914.745n 0.0v 914.755n 0.0v 919.745n 0.0v 919.755n 0.0v 924.745n 0.0v 924.755n 0.0v 929.745n 0.0v 929.755n 0.0v 934.745n 0.0v 934.755n 0.95v 939.745n 0.95v 939.755n 0.0v 944.745n 0.0v 944.755n 0.0v 949.745n 0.0v 949.755n 0.0v 954.745n 0.0v 954.755n 0.0v 959.745n 0.0v 959.755n 0.0v 964.745n 0.0v 964.755n 0.0v 969.745n 0.0v 969.755n 0.0v 974.745n 0.0v 974.755n 0.0v 979.745n 0.0v 979.755n 0.0v 984.745n 0.0v 984.755n 0.0v 989.745n 0.0v 989.755n 0.0v 994.745n 0.0v 994.755n 0.0v 999.745n 0.0v 999.755n 0.0v 1004.745n 0.0v 1004.755n 0.0v 1009.745n 0.0v 1009.755n 0.0v 1014.745n 0.0v 1014.755n 0.0v 1019.745n 0.0v 1019.755n 0.0v 1024.745n 0.0v 1024.755n 0.0v )
* (time, data): [(0, 0), (5, 1), (10, 0), (15, 0), (20, 0), (25, 0), (30, 0), (35, 0), (40, 0), (45, 0), (50, 0), (55, 0), (60, 0), (65, 0), (70, 0), (75, 1), (80, 1), (85, 1), (90, 1), (95, 1), (100, 1), (105, 1), (110, 1), (115, 0), (120, 0), (125, 0), (130, 0), (135, 0), (140, 0), (145, 0), (150, 1), (155, 1), (160, 0), (165, 0), (170, 0), (175, 0), (180, 0), (185, 0), (190, 1), (195, 1), (200, 1), (205, 1), (210, 1), (215, 1), (220, 1), (225, 1), (230, 1), (235, 1), (240, 1), (245, 1), (250, 1), (255, 1), (260, 1), (265, 0), (270, 0), (275, 0), (280, 0), (285, 0), (290, 0), (295, 0), (300, 0), (305, 0), (310, 0), (315, 0), (320, 0), (325, 1), (330, 0), (335, 0), (340, 0), (345, 0), (350, 0), (355, 0), (360, 0), (365, 0), (370, 0), (375, 0), (380, 0), (385, 0), (390, 0), (395, 0), (400, 0), (405, 0), (410, 1), (415, 1), (420, 1), (425, 1), (430, 1), (435, 1), (440, 1), (445, 1), (450, 1), (455, 1), (460, 1), (465, 1), (470, 1), (475, 1), (480, 1), (485, 1), (490, 1), (495, 1), (500, 1), (505, 1), (510, 1), (515, 1), (520, 1), (525, 1), (530, 0), (535, 0), (540, 0), (545, 0), (550, 1), (555, 1), (560, 1), (565, 1), (570, 1), (575, 1), (580, 1), (585, 1), (590, 1), (595, 1), (600, 0), (605, 0), (610, 0), (615, 1), (620, 1), (625, 1), (630, 1), (635, 1), (640, 1), (645, 1), (650, 1), (655, 1), (660, 1), (665, 1), (670, 1), (675, 1), (680, 1), (685, 1), (690, 1), (695, 1), (700, 1), (705, 1), (710, 1), (715, 1), (720, 0), (725, 0), (730, 0), (735, 0), (740, 0), (745, 0), (750, 0), (755, 0), (760, 0), (765, 0), (770, 0), (775, 0), (780, 0), (785, 0), (790, 1), (795, 1), (800, 1), (805, 1), (810, 1), (815, 1), (820, 0), (825, 0), (830, 0), (835, 0), (840, 0), (845, 1), (850, 1), (855, 1), (860, 0), (865, 0), (870, 0), (875, 1), (880, 1), (885, 1), (890, 1), (895, 1), (900, 0), (905, 1), (910, 1), (915, 1), (920, 1), (925, 1), (930, 1), (935, 1), (940, 1), (945, 1), (950, 1), (955, 1), (960, 1), (965, 1), (970, 0), (975, 0), (980, 0), (985, 0), (990, 0), (995, 0), (1000, 0), (1005, 0), (1010, 0), (1015, 0), (1020, 0), (1025, 0)]
Vdin0_10  din0_10  0 PWL (0n 0.0v 4.745n 0.0v 4.755n 0.95v 9.745n 0.95v 9.755n 0.0v 14.745n 0.0v 14.755n 0.0v 19.745n 0.0v 19.755n 0.0v 24.745n 0.0v 24.755n 0.0v 29.745n 0.0v 29.755n 0.0v 34.745n 0.0v 34.755n 0.0v 39.745n 0.0v 39.755n 0.0v 44.745n 0.0v 44.755n 0.0v 49.745n 0.0v 49.755n 0.0v 54.745n 0.0v 54.755n 0.0v 59.745n 0.0v 59.755n 0.0v 64.745n 0.0v 64.755n 0.0v 69.745n 0.0v 69.755n 0.0v 74.745n 0.0v 74.755n 0.95v 79.745n 0.95v 79.755n 0.95v 84.745n 0.95v 84.755n 0.95v 89.745n 0.95v 89.755n 0.95v 94.745n 0.95v 94.755n 0.95v 99.745n 0.95v 99.755n 0.95v 104.745n 0.95v 104.755n 0.95v 109.745n 0.95v 109.755n 0.95v 114.745n 0.95v 114.755n 0.0v 119.745n 0.0v 119.755n 0.0v 124.745n 0.0v 124.755n 0.0v 129.745n 0.0v 129.755n 0.0v 134.745n 0.0v 134.755n 0.0v 139.745n 0.0v 139.755n 0.0v 144.745n 0.0v 144.755n 0.0v 149.745n 0.0v 149.755n 0.95v 154.745n 0.95v 154.755n 0.95v 159.745n 0.95v 159.755n 0.0v 164.745n 0.0v 164.755n 0.0v 169.745n 0.0v 169.755n 0.0v 174.745n 0.0v 174.755n 0.0v 179.745n 0.0v 179.755n 0.0v 184.745n 0.0v 184.755n 0.0v 189.745n 0.0v 189.755n 0.95v 194.745n 0.95v 194.755n 0.95v 199.745n 0.95v 199.755n 0.95v 204.745n 0.95v 204.755n 0.95v 209.745n 0.95v 209.755n 0.95v 214.745n 0.95v 214.755n 0.95v 219.745n 0.95v 219.755n 0.95v 224.745n 0.95v 224.755n 0.95v 229.745n 0.95v 229.755n 0.95v 234.745n 0.95v 234.755n 0.95v 239.745n 0.95v 239.755n 0.95v 244.745n 0.95v 244.755n 0.95v 249.745n 0.95v 249.755n 0.95v 254.745n 0.95v 254.755n 0.95v 259.745n 0.95v 259.755n 0.95v 264.745n 0.95v 264.755n 0.0v 269.745n 0.0v 269.755n 0.0v 274.745n 0.0v 274.755n 0.0v 279.745n 0.0v 279.755n 0.0v 284.745n 0.0v 284.755n 0.0v 289.745n 0.0v 289.755n 0.0v 294.745n 0.0v 294.755n 0.0v 299.745n 0.0v 299.755n 0.0v 304.745n 0.0v 304.755n 0.0v 309.745n 0.0v 309.755n 0.0v 314.745n 0.0v 314.755n 0.0v 319.745n 0.0v 319.755n 0.0v 324.745n 0.0v 324.755n 0.95v 329.745n 0.95v 329.755n 0.0v 334.745n 0.0v 334.755n 0.0v 339.745n 0.0v 339.755n 0.0v 344.745n 0.0v 344.755n 0.0v 349.745n 0.0v 349.755n 0.0v 354.745n 0.0v 354.755n 0.0v 359.745n 0.0v 359.755n 0.0v 364.745n 0.0v 364.755n 0.0v 369.745n 0.0v 369.755n 0.0v 374.745n 0.0v 374.755n 0.0v 379.745n 0.0v 379.755n 0.0v 384.745n 0.0v 384.755n 0.0v 389.745n 0.0v 389.755n 0.0v 394.745n 0.0v 394.755n 0.0v 399.745n 0.0v 399.755n 0.0v 404.745n 0.0v 404.755n 0.0v 409.745n 0.0v 409.755n 0.95v 414.745n 0.95v 414.755n 0.95v 419.745n 0.95v 419.755n 0.95v 424.745n 0.95v 424.755n 0.95v 429.745n 0.95v 429.755n 0.95v 434.745n 0.95v 434.755n 0.95v 439.745n 0.95v 439.755n 0.95v 444.745n 0.95v 444.755n 0.95v 449.745n 0.95v 449.755n 0.95v 454.745n 0.95v 454.755n 0.95v 459.745n 0.95v 459.755n 0.95v 464.745n 0.95v 464.755n 0.95v 469.745n 0.95v 469.755n 0.95v 474.745n 0.95v 474.755n 0.95v 479.745n 0.95v 479.755n 0.95v 484.745n 0.95v 484.755n 0.95v 489.745n 0.95v 489.755n 0.95v 494.745n 0.95v 494.755n 0.95v 499.745n 0.95v 499.755n 0.95v 504.745n 0.95v 504.755n 0.95v 509.745n 0.95v 509.755n 0.95v 514.745n 0.95v 514.755n 0.95v 519.745n 0.95v 519.755n 0.95v 524.745n 0.95v 524.755n 0.95v 529.745n 0.95v 529.755n 0.0v 534.745n 0.0v 534.755n 0.0v 539.745n 0.0v 539.755n 0.0v 544.745n 0.0v 544.755n 0.0v 549.745n 0.0v 549.755n 0.95v 554.745n 0.95v 554.755n 0.95v 559.745n 0.95v 559.755n 0.95v 564.745n 0.95v 564.755n 0.95v 569.745n 0.95v 569.755n 0.95v 574.745n 0.95v 574.755n 0.95v 579.745n 0.95v 579.755n 0.95v 584.745n 0.95v 584.755n 0.95v 589.745n 0.95v 589.755n 0.95v 594.745n 0.95v 594.755n 0.95v 599.745n 0.95v 599.755n 0.0v 604.745n 0.0v 604.755n 0.0v 609.745n 0.0v 609.755n 0.0v 614.745n 0.0v 614.755n 0.95v 619.745n 0.95v 619.755n 0.95v 624.745n 0.95v 624.755n 0.95v 629.745n 0.95v 629.755n 0.95v 634.745n 0.95v 634.755n 0.95v 639.745n 0.95v 639.755n 0.95v 644.745n 0.95v 644.755n 0.95v 649.745n 0.95v 649.755n 0.95v 654.745n 0.95v 654.755n 0.95v 659.745n 0.95v 659.755n 0.95v 664.745n 0.95v 664.755n 0.95v 669.745n 0.95v 669.755n 0.95v 674.745n 0.95v 674.755n 0.95v 679.745n 0.95v 679.755n 0.95v 684.745n 0.95v 684.755n 0.95v 689.745n 0.95v 689.755n 0.95v 694.745n 0.95v 694.755n 0.95v 699.745n 0.95v 699.755n 0.95v 704.745n 0.95v 704.755n 0.95v 709.745n 0.95v 709.755n 0.95v 714.745n 0.95v 714.755n 0.95v 719.745n 0.95v 719.755n 0.0v 724.745n 0.0v 724.755n 0.0v 729.745n 0.0v 729.755n 0.0v 734.745n 0.0v 734.755n 0.0v 739.745n 0.0v 739.755n 0.0v 744.745n 0.0v 744.755n 0.0v 749.745n 0.0v 749.755n 0.0v 754.745n 0.0v 754.755n 0.0v 759.745n 0.0v 759.755n 0.0v 764.745n 0.0v 764.755n 0.0v 769.745n 0.0v 769.755n 0.0v 774.745n 0.0v 774.755n 0.0v 779.745n 0.0v 779.755n 0.0v 784.745n 0.0v 784.755n 0.0v 789.745n 0.0v 789.755n 0.95v 794.745n 0.95v 794.755n 0.95v 799.745n 0.95v 799.755n 0.95v 804.745n 0.95v 804.755n 0.95v 809.745n 0.95v 809.755n 0.95v 814.745n 0.95v 814.755n 0.95v 819.745n 0.95v 819.755n 0.0v 824.745n 0.0v 824.755n 0.0v 829.745n 0.0v 829.755n 0.0v 834.745n 0.0v 834.755n 0.0v 839.745n 0.0v 839.755n 0.0v 844.745n 0.0v 844.755n 0.95v 849.745n 0.95v 849.755n 0.95v 854.745n 0.95v 854.755n 0.95v 859.745n 0.95v 859.755n 0.0v 864.745n 0.0v 864.755n 0.0v 869.745n 0.0v 869.755n 0.0v 874.745n 0.0v 874.755n 0.95v 879.745n 0.95v 879.755n 0.95v 884.745n 0.95v 884.755n 0.95v 889.745n 0.95v 889.755n 0.95v 894.745n 0.95v 894.755n 0.95v 899.745n 0.95v 899.755n 0.0v 904.745n 0.0v 904.755n 0.95v 909.745n 0.95v 909.755n 0.95v 914.745n 0.95v 914.755n 0.95v 919.745n 0.95v 919.755n 0.95v 924.745n 0.95v 924.755n 0.95v 929.745n 0.95v 929.755n 0.95v 934.745n 0.95v 934.755n 0.95v 939.745n 0.95v 939.755n 0.95v 944.745n 0.95v 944.755n 0.95v 949.745n 0.95v 949.755n 0.95v 954.745n 0.95v 954.755n 0.95v 959.745n 0.95v 959.755n 0.95v 964.745n 0.95v 964.755n 0.95v 969.745n 0.95v 969.755n 0.0v 974.745n 0.0v 974.755n 0.0v 979.745n 0.0v 979.755n 0.0v 984.745n 0.0v 984.755n 0.0v 989.745n 0.0v 989.755n 0.0v 994.745n 0.0v 994.755n 0.0v 999.745n 0.0v 999.755n 0.0v 1004.745n 0.0v 1004.755n 0.0v 1009.745n 0.0v 1009.755n 0.0v 1014.745n 0.0v 1014.755n 0.0v 1019.745n 0.0v 1019.755n 0.0v 1024.745n 0.0v 1024.755n 0.0v )
* (time, data): [(0, 0), (5, 0), (10, 0), (15, 0), (20, 0), (25, 0), (30, 0), (35, 0), (40, 0), (45, 0), (50, 0), (55, 0), (60, 0), (65, 0), (70, 0), (75, 1), (80, 1), (85, 1), (90, 1), (95, 0), (100, 0), (105, 0), (110, 0), (115, 0), (120, 0), (125, 0), (130, 0), (135, 0), (140, 0), (145, 0), (150, 1), (155, 1), (160, 0), (165, 1), (170, 1), (175, 1), (180, 1), (185, 1), (190, 1), (195, 1), (200, 1), (205, 1), (210, 1), (215, 1), (220, 1), (225, 1), (230, 1), (235, 1), (240, 1), (245, 1), (250, 1), (255, 1), (260, 1), (265, 0), (270, 0), (275, 0), (280, 0), (285, 0), (290, 0), (295, 0), (300, 0), (305, 0), (310, 0), (315, 0), (320, 0), (325, 0), (330, 0), (335, 0), (340, 0), (345, 0), (350, 0), (355, 0), (360, 0), (365, 0), (370, 0), (375, 0), (380, 0), (385, 0), (390, 0), (395, 0), (400, 0), (405, 0), (410, 1), (415, 1), (420, 1), (425, 0), (430, 0), (435, 0), (440, 0), (445, 0), (450, 0), (455, 0), (460, 0), (465, 0), (470, 0), (475, 0), (480, 0), (485, 0), (490, 0), (495, 0), (500, 0), (505, 0), (510, 0), (515, 0), (520, 0), (525, 1), (530, 0), (535, 0), (540, 0), (545, 0), (550, 0), (555, 0), (560, 0), (565, 0), (570, 1), (575, 1), (580, 1), (585, 1), (590, 0), (595, 0), (600, 1), (605, 1), (610, 1), (615, 0), (620, 0), (625, 0), (630, 0), (635, 0), (640, 0), (645, 0), (650, 0), (655, 0), (660, 0), (665, 0), (670, 0), (675, 0), (680, 0), (685, 0), (690, 0), (695, 0), (700, 0), (705, 0), (710, 0), (715, 0), (720, 0), (725, 0), (730, 0), (735, 0), (740, 0), (745, 0), (750, 0), (755, 0), (760, 0), (765, 0), (770, 0), (775, 0), (780, 0), (785, 0), (790, 0), (795, 0), (800, 0), (805, 0), (810, 0), (815, 0), (820, 0), (825, 0), (830, 1), (835, 1), (840, 1), (845, 0), (850, 0), (855, 0), (860, 1), (865, 1), (870, 1), (875, 1), (880, 1), (885, 1), (890, 1), (895, 1), (900, 1), (905, 1), (910, 1), (915, 1), (920, 1), (925, 1), (930, 1), (935, 1), (940, 0), (945, 0), (950, 0), (955, 0), (960, 0), (965, 0), (970, 0), (975, 0), (980, 0), (985, 0), (990, 0), (995, 0), (1000, 0), (1005, 0), (1010, 0), (1015, 0), (1020, 0), (1025, 0)]
Vdin0_11  din0_11  0 PWL (0n 0.0v 4.745n 0.0v 4.755n 0.0v 9.745n 0.0v 9.755n 0.0v 14.745n 0.0v 14.755n 0.0v 19.745n 0.0v 19.755n 0.0v 24.745n 0.0v 24.755n 0.0v 29.745n 0.0v 29.755n 0.0v 34.745n 0.0v 34.755n 0.0v 39.745n 0.0v 39.755n 0.0v 44.745n 0.0v 44.755n 0.0v 49.745n 0.0v 49.755n 0.0v 54.745n 0.0v 54.755n 0.0v 59.745n 0.0v 59.755n 0.0v 64.745n 0.0v 64.755n 0.0v 69.745n 0.0v 69.755n 0.0v 74.745n 0.0v 74.755n 0.95v 79.745n 0.95v 79.755n 0.95v 84.745n 0.95v 84.755n 0.95v 89.745n 0.95v 89.755n 0.95v 94.745n 0.95v 94.755n 0.0v 99.745n 0.0v 99.755n 0.0v 104.745n 0.0v 104.755n 0.0v 109.745n 0.0v 109.755n 0.0v 114.745n 0.0v 114.755n 0.0v 119.745n 0.0v 119.755n 0.0v 124.745n 0.0v 124.755n 0.0v 129.745n 0.0v 129.755n 0.0v 134.745n 0.0v 134.755n 0.0v 139.745n 0.0v 139.755n 0.0v 144.745n 0.0v 144.755n 0.0v 149.745n 0.0v 149.755n 0.95v 154.745n 0.95v 154.755n 0.95v 159.745n 0.95v 159.755n 0.0v 164.745n 0.0v 164.755n 0.95v 169.745n 0.95v 169.755n 0.95v 174.745n 0.95v 174.755n 0.95v 179.745n 0.95v 179.755n 0.95v 184.745n 0.95v 184.755n 0.95v 189.745n 0.95v 189.755n 0.95v 194.745n 0.95v 194.755n 0.95v 199.745n 0.95v 199.755n 0.95v 204.745n 0.95v 204.755n 0.95v 209.745n 0.95v 209.755n 0.95v 214.745n 0.95v 214.755n 0.95v 219.745n 0.95v 219.755n 0.95v 224.745n 0.95v 224.755n 0.95v 229.745n 0.95v 229.755n 0.95v 234.745n 0.95v 234.755n 0.95v 239.745n 0.95v 239.755n 0.95v 244.745n 0.95v 244.755n 0.95v 249.745n 0.95v 249.755n 0.95v 254.745n 0.95v 254.755n 0.95v 259.745n 0.95v 259.755n 0.95v 264.745n 0.95v 264.755n 0.0v 269.745n 0.0v 269.755n 0.0v 274.745n 0.0v 274.755n 0.0v 279.745n 0.0v 279.755n 0.0v 284.745n 0.0v 284.755n 0.0v 289.745n 0.0v 289.755n 0.0v 294.745n 0.0v 294.755n 0.0v 299.745n 0.0v 299.755n 0.0v 304.745n 0.0v 304.755n 0.0v 309.745n 0.0v 309.755n 0.0v 314.745n 0.0v 314.755n 0.0v 319.745n 0.0v 319.755n 0.0v 324.745n 0.0v 324.755n 0.0v 329.745n 0.0v 329.755n 0.0v 334.745n 0.0v 334.755n 0.0v 339.745n 0.0v 339.755n 0.0v 344.745n 0.0v 344.755n 0.0v 349.745n 0.0v 349.755n 0.0v 354.745n 0.0v 354.755n 0.0v 359.745n 0.0v 359.755n 0.0v 364.745n 0.0v 364.755n 0.0v 369.745n 0.0v 369.755n 0.0v 374.745n 0.0v 374.755n 0.0v 379.745n 0.0v 379.755n 0.0v 384.745n 0.0v 384.755n 0.0v 389.745n 0.0v 389.755n 0.0v 394.745n 0.0v 394.755n 0.0v 399.745n 0.0v 399.755n 0.0v 404.745n 0.0v 404.755n 0.0v 409.745n 0.0v 409.755n 0.95v 414.745n 0.95v 414.755n 0.95v 419.745n 0.95v 419.755n 0.95v 424.745n 0.95v 424.755n 0.0v 429.745n 0.0v 429.755n 0.0v 434.745n 0.0v 434.755n 0.0v 439.745n 0.0v 439.755n 0.0v 444.745n 0.0v 444.755n 0.0v 449.745n 0.0v 449.755n 0.0v 454.745n 0.0v 454.755n 0.0v 459.745n 0.0v 459.755n 0.0v 464.745n 0.0v 464.755n 0.0v 469.745n 0.0v 469.755n 0.0v 474.745n 0.0v 474.755n 0.0v 479.745n 0.0v 479.755n 0.0v 484.745n 0.0v 484.755n 0.0v 489.745n 0.0v 489.755n 0.0v 494.745n 0.0v 494.755n 0.0v 499.745n 0.0v 499.755n 0.0v 504.745n 0.0v 504.755n 0.0v 509.745n 0.0v 509.755n 0.0v 514.745n 0.0v 514.755n 0.0v 519.745n 0.0v 519.755n 0.0v 524.745n 0.0v 524.755n 0.95v 529.745n 0.95v 529.755n 0.0v 534.745n 0.0v 534.755n 0.0v 539.745n 0.0v 539.755n 0.0v 544.745n 0.0v 544.755n 0.0v 549.745n 0.0v 549.755n 0.0v 554.745n 0.0v 554.755n 0.0v 559.745n 0.0v 559.755n 0.0v 564.745n 0.0v 564.755n 0.0v 569.745n 0.0v 569.755n 0.95v 574.745n 0.95v 574.755n 0.95v 579.745n 0.95v 579.755n 0.95v 584.745n 0.95v 584.755n 0.95v 589.745n 0.95v 589.755n 0.0v 594.745n 0.0v 594.755n 0.0v 599.745n 0.0v 599.755n 0.95v 604.745n 0.95v 604.755n 0.95v 609.745n 0.95v 609.755n 0.95v 614.745n 0.95v 614.755n 0.0v 619.745n 0.0v 619.755n 0.0v 624.745n 0.0v 624.755n 0.0v 629.745n 0.0v 629.755n 0.0v 634.745n 0.0v 634.755n 0.0v 639.745n 0.0v 639.755n 0.0v 644.745n 0.0v 644.755n 0.0v 649.745n 0.0v 649.755n 0.0v 654.745n 0.0v 654.755n 0.0v 659.745n 0.0v 659.755n 0.0v 664.745n 0.0v 664.755n 0.0v 669.745n 0.0v 669.755n 0.0v 674.745n 0.0v 674.755n 0.0v 679.745n 0.0v 679.755n 0.0v 684.745n 0.0v 684.755n 0.0v 689.745n 0.0v 689.755n 0.0v 694.745n 0.0v 694.755n 0.0v 699.745n 0.0v 699.755n 0.0v 704.745n 0.0v 704.755n 0.0v 709.745n 0.0v 709.755n 0.0v 714.745n 0.0v 714.755n 0.0v 719.745n 0.0v 719.755n 0.0v 724.745n 0.0v 724.755n 0.0v 729.745n 0.0v 729.755n 0.0v 734.745n 0.0v 734.755n 0.0v 739.745n 0.0v 739.755n 0.0v 744.745n 0.0v 744.755n 0.0v 749.745n 0.0v 749.755n 0.0v 754.745n 0.0v 754.755n 0.0v 759.745n 0.0v 759.755n 0.0v 764.745n 0.0v 764.755n 0.0v 769.745n 0.0v 769.755n 0.0v 774.745n 0.0v 774.755n 0.0v 779.745n 0.0v 779.755n 0.0v 784.745n 0.0v 784.755n 0.0v 789.745n 0.0v 789.755n 0.0v 794.745n 0.0v 794.755n 0.0v 799.745n 0.0v 799.755n 0.0v 804.745n 0.0v 804.755n 0.0v 809.745n 0.0v 809.755n 0.0v 814.745n 0.0v 814.755n 0.0v 819.745n 0.0v 819.755n 0.0v 824.745n 0.0v 824.755n 0.0v 829.745n 0.0v 829.755n 0.95v 834.745n 0.95v 834.755n 0.95v 839.745n 0.95v 839.755n 0.95v 844.745n 0.95v 844.755n 0.0v 849.745n 0.0v 849.755n 0.0v 854.745n 0.0v 854.755n 0.0v 859.745n 0.0v 859.755n 0.95v 864.745n 0.95v 864.755n 0.95v 869.745n 0.95v 869.755n 0.95v 874.745n 0.95v 874.755n 0.95v 879.745n 0.95v 879.755n 0.95v 884.745n 0.95v 884.755n 0.95v 889.745n 0.95v 889.755n 0.95v 894.745n 0.95v 894.755n 0.95v 899.745n 0.95v 899.755n 0.95v 904.745n 0.95v 904.755n 0.95v 909.745n 0.95v 909.755n 0.95v 914.745n 0.95v 914.755n 0.95v 919.745n 0.95v 919.755n 0.95v 924.745n 0.95v 924.755n 0.95v 929.745n 0.95v 929.755n 0.95v 934.745n 0.95v 934.755n 0.95v 939.745n 0.95v 939.755n 0.0v 944.745n 0.0v 944.755n 0.0v 949.745n 0.0v 949.755n 0.0v 954.745n 0.0v 954.755n 0.0v 959.745n 0.0v 959.755n 0.0v 964.745n 0.0v 964.755n 0.0v 969.745n 0.0v 969.755n 0.0v 974.745n 0.0v 974.755n 0.0v 979.745n 0.0v 979.755n 0.0v 984.745n 0.0v 984.755n 0.0v 989.745n 0.0v 989.755n 0.0v 994.745n 0.0v 994.755n 0.0v 999.745n 0.0v 999.755n 0.0v 1004.745n 0.0v 1004.755n 0.0v 1009.745n 0.0v 1009.755n 0.0v 1014.745n 0.0v 1014.755n 0.0v 1019.745n 0.0v 1019.755n 0.0v 1024.745n 0.0v 1024.755n 0.0v )
* (time, data): [(0, 0), (5, 1), (10, 0), (15, 1), (20, 1), (25, 1), (30, 1), (35, 1), (40, 1), (45, 1), (50, 1), (55, 1), (60, 1), (65, 1), (70, 1), (75, 1), (80, 1), (85, 1), (90, 1), (95, 0), (100, 0), (105, 0), (110, 0), (115, 1), (120, 1), (125, 1), (130, 1), (135, 1), (140, 1), (145, 1), (150, 0), (155, 0), (160, 0), (165, 0), (170, 0), (175, 0), (180, 0), (185, 0), (190, 1), (195, 1), (200, 1), (205, 1), (210, 1), (215, 1), (220, 1), (225, 1), (230, 1), (235, 1), (240, 0), (245, 0), (250, 0), (255, 0), (260, 0), (265, 1), (270, 1), (275, 1), (280, 1), (285, 1), (290, 0), (295, 0), (300, 0), (305, 0), (310, 0), (315, 0), (320, 0), (325, 0), (330, 1), (335, 1), (340, 1), (345, 1), (350, 1), (355, 1), (360, 1), (365, 1), (370, 1), (375, 1), (380, 1), (385, 1), (390, 1), (395, 1), (400, 1), (405, 1), (410, 0), (415, 0), (420, 0), (425, 0), (430, 0), (435, 0), (440, 0), (445, 0), (450, 0), (455, 0), (460, 0), (465, 0), (470, 0), (475, 0), (480, 0), (485, 0), (490, 0), (495, 0), (500, 0), (505, 0), (510, 1), (515, 1), (520, 1), (525, 1), (530, 1), (535, 1), (540, 1), (545, 1), (550, 0), (555, 0), (560, 0), (565, 0), (570, 1), (575, 1), (580, 1), (585, 1), (590, 0), (595, 0), (600, 1), (605, 1), (610, 1), (615, 0), (620, 0), (625, 0), (630, 0), (635, 0), (640, 0), (645, 0), (650, 0), (655, 1), (660, 1), (665, 1), (670, 1), (675, 1), (680, 1), (685, 0), (690, 0), (695, 0), (700, 0), (705, 0), (710, 0), (715, 0), (720, 1), (725, 1), (730, 1), (735, 1), (740, 1), (745, 1), (750, 1), (755, 1), (760, 1), (765, 1), (770, 1), (775, 1), (780, 1), (785, 1), (790, 1), (795, 1), (800, 1), (805, 1), (810, 1), (815, 1), (820, 1), (825, 1), (830, 1), (835, 1), (840, 1), (845, 0), (850, 0), (855, 0), (860, 0), (865, 0), (870, 0), (875, 1), (880, 1), (885, 1), (890, 1), (895, 1), (900, 1), (905, 1), (910, 1), (915, 1), (920, 1), (925, 1), (930, 1), (935, 1), (940, 1), (945, 1), (950, 1), (955, 1), (960, 1), (965, 1), (970, 1), (975, 1), (980, 1), (985, 1), (990, 1), (995, 1), (1000, 1), (1005, 1), (1010, 1), (1015, 1), (1020, 1), (1025, 1)]
Vdin0_12  din0_12  0 PWL (0n 0.0v 4.745n 0.0v 4.755n 0.95v 9.745n 0.95v 9.755n 0.0v 14.745n 0.0v 14.755n 0.95v 19.745n 0.95v 19.755n 0.95v 24.745n 0.95v 24.755n 0.95v 29.745n 0.95v 29.755n 0.95v 34.745n 0.95v 34.755n 0.95v 39.745n 0.95v 39.755n 0.95v 44.745n 0.95v 44.755n 0.95v 49.745n 0.95v 49.755n 0.95v 54.745n 0.95v 54.755n 0.95v 59.745n 0.95v 59.755n 0.95v 64.745n 0.95v 64.755n 0.95v 69.745n 0.95v 69.755n 0.95v 74.745n 0.95v 74.755n 0.95v 79.745n 0.95v 79.755n 0.95v 84.745n 0.95v 84.755n 0.95v 89.745n 0.95v 89.755n 0.95v 94.745n 0.95v 94.755n 0.0v 99.745n 0.0v 99.755n 0.0v 104.745n 0.0v 104.755n 0.0v 109.745n 0.0v 109.755n 0.0v 114.745n 0.0v 114.755n 0.95v 119.745n 0.95v 119.755n 0.95v 124.745n 0.95v 124.755n 0.95v 129.745n 0.95v 129.755n 0.95v 134.745n 0.95v 134.755n 0.95v 139.745n 0.95v 139.755n 0.95v 144.745n 0.95v 144.755n 0.95v 149.745n 0.95v 149.755n 0.0v 154.745n 0.0v 154.755n 0.0v 159.745n 0.0v 159.755n 0.0v 164.745n 0.0v 164.755n 0.0v 169.745n 0.0v 169.755n 0.0v 174.745n 0.0v 174.755n 0.0v 179.745n 0.0v 179.755n 0.0v 184.745n 0.0v 184.755n 0.0v 189.745n 0.0v 189.755n 0.95v 194.745n 0.95v 194.755n 0.95v 199.745n 0.95v 199.755n 0.95v 204.745n 0.95v 204.755n 0.95v 209.745n 0.95v 209.755n 0.95v 214.745n 0.95v 214.755n 0.95v 219.745n 0.95v 219.755n 0.95v 224.745n 0.95v 224.755n 0.95v 229.745n 0.95v 229.755n 0.95v 234.745n 0.95v 234.755n 0.95v 239.745n 0.95v 239.755n 0.0v 244.745n 0.0v 244.755n 0.0v 249.745n 0.0v 249.755n 0.0v 254.745n 0.0v 254.755n 0.0v 259.745n 0.0v 259.755n 0.0v 264.745n 0.0v 264.755n 0.95v 269.745n 0.95v 269.755n 0.95v 274.745n 0.95v 274.755n 0.95v 279.745n 0.95v 279.755n 0.95v 284.745n 0.95v 284.755n 0.95v 289.745n 0.95v 289.755n 0.0v 294.745n 0.0v 294.755n 0.0v 299.745n 0.0v 299.755n 0.0v 304.745n 0.0v 304.755n 0.0v 309.745n 0.0v 309.755n 0.0v 314.745n 0.0v 314.755n 0.0v 319.745n 0.0v 319.755n 0.0v 324.745n 0.0v 324.755n 0.0v 329.745n 0.0v 329.755n 0.95v 334.745n 0.95v 334.755n 0.95v 339.745n 0.95v 339.755n 0.95v 344.745n 0.95v 344.755n 0.95v 349.745n 0.95v 349.755n 0.95v 354.745n 0.95v 354.755n 0.95v 359.745n 0.95v 359.755n 0.95v 364.745n 0.95v 364.755n 0.95v 369.745n 0.95v 369.755n 0.95v 374.745n 0.95v 374.755n 0.95v 379.745n 0.95v 379.755n 0.95v 384.745n 0.95v 384.755n 0.95v 389.745n 0.95v 389.755n 0.95v 394.745n 0.95v 394.755n 0.95v 399.745n 0.95v 399.755n 0.95v 404.745n 0.95v 404.755n 0.95v 409.745n 0.95v 409.755n 0.0v 414.745n 0.0v 414.755n 0.0v 419.745n 0.0v 419.755n 0.0v 424.745n 0.0v 424.755n 0.0v 429.745n 0.0v 429.755n 0.0v 434.745n 0.0v 434.755n 0.0v 439.745n 0.0v 439.755n 0.0v 444.745n 0.0v 444.755n 0.0v 449.745n 0.0v 449.755n 0.0v 454.745n 0.0v 454.755n 0.0v 459.745n 0.0v 459.755n 0.0v 464.745n 0.0v 464.755n 0.0v 469.745n 0.0v 469.755n 0.0v 474.745n 0.0v 474.755n 0.0v 479.745n 0.0v 479.755n 0.0v 484.745n 0.0v 484.755n 0.0v 489.745n 0.0v 489.755n 0.0v 494.745n 0.0v 494.755n 0.0v 499.745n 0.0v 499.755n 0.0v 504.745n 0.0v 504.755n 0.0v 509.745n 0.0v 509.755n 0.95v 514.745n 0.95v 514.755n 0.95v 519.745n 0.95v 519.755n 0.95v 524.745n 0.95v 524.755n 0.95v 529.745n 0.95v 529.755n 0.95v 534.745n 0.95v 534.755n 0.95v 539.745n 0.95v 539.755n 0.95v 544.745n 0.95v 544.755n 0.95v 549.745n 0.95v 549.755n 0.0v 554.745n 0.0v 554.755n 0.0v 559.745n 0.0v 559.755n 0.0v 564.745n 0.0v 564.755n 0.0v 569.745n 0.0v 569.755n 0.95v 574.745n 0.95v 574.755n 0.95v 579.745n 0.95v 579.755n 0.95v 584.745n 0.95v 584.755n 0.95v 589.745n 0.95v 589.755n 0.0v 594.745n 0.0v 594.755n 0.0v 599.745n 0.0v 599.755n 0.95v 604.745n 0.95v 604.755n 0.95v 609.745n 0.95v 609.755n 0.95v 614.745n 0.95v 614.755n 0.0v 619.745n 0.0v 619.755n 0.0v 624.745n 0.0v 624.755n 0.0v 629.745n 0.0v 629.755n 0.0v 634.745n 0.0v 634.755n 0.0v 639.745n 0.0v 639.755n 0.0v 644.745n 0.0v 644.755n 0.0v 649.745n 0.0v 649.755n 0.0v 654.745n 0.0v 654.755n 0.95v 659.745n 0.95v 659.755n 0.95v 664.745n 0.95v 664.755n 0.95v 669.745n 0.95v 669.755n 0.95v 674.745n 0.95v 674.755n 0.95v 679.745n 0.95v 679.755n 0.95v 684.745n 0.95v 684.755n 0.0v 689.745n 0.0v 689.755n 0.0v 694.745n 0.0v 694.755n 0.0v 699.745n 0.0v 699.755n 0.0v 704.745n 0.0v 704.755n 0.0v 709.745n 0.0v 709.755n 0.0v 714.745n 0.0v 714.755n 0.0v 719.745n 0.0v 719.755n 0.95v 724.745n 0.95v 724.755n 0.95v 729.745n 0.95v 729.755n 0.95v 734.745n 0.95v 734.755n 0.95v 739.745n 0.95v 739.755n 0.95v 744.745n 0.95v 744.755n 0.95v 749.745n 0.95v 749.755n 0.95v 754.745n 0.95v 754.755n 0.95v 759.745n 0.95v 759.755n 0.95v 764.745n 0.95v 764.755n 0.95v 769.745n 0.95v 769.755n 0.95v 774.745n 0.95v 774.755n 0.95v 779.745n 0.95v 779.755n 0.95v 784.745n 0.95v 784.755n 0.95v 789.745n 0.95v 789.755n 0.95v 794.745n 0.95v 794.755n 0.95v 799.745n 0.95v 799.755n 0.95v 804.745n 0.95v 804.755n 0.95v 809.745n 0.95v 809.755n 0.95v 814.745n 0.95v 814.755n 0.95v 819.745n 0.95v 819.755n 0.95v 824.745n 0.95v 824.755n 0.95v 829.745n 0.95v 829.755n 0.95v 834.745n 0.95v 834.755n 0.95v 839.745n 0.95v 839.755n 0.95v 844.745n 0.95v 844.755n 0.0v 849.745n 0.0v 849.755n 0.0v 854.745n 0.0v 854.755n 0.0v 859.745n 0.0v 859.755n 0.0v 864.745n 0.0v 864.755n 0.0v 869.745n 0.0v 869.755n 0.0v 874.745n 0.0v 874.755n 0.95v 879.745n 0.95v 879.755n 0.95v 884.745n 0.95v 884.755n 0.95v 889.745n 0.95v 889.755n 0.95v 894.745n 0.95v 894.755n 0.95v 899.745n 0.95v 899.755n 0.95v 904.745n 0.95v 904.755n 0.95v 909.745n 0.95v 909.755n 0.95v 914.745n 0.95v 914.755n 0.95v 919.745n 0.95v 919.755n 0.95v 924.745n 0.95v 924.755n 0.95v 929.745n 0.95v 929.755n 0.95v 934.745n 0.95v 934.755n 0.95v 939.745n 0.95v 939.755n 0.95v 944.745n 0.95v 944.755n 0.95v 949.745n 0.95v 949.755n 0.95v 954.745n 0.95v 954.755n 0.95v 959.745n 0.95v 959.755n 0.95v 964.745n 0.95v 964.755n 0.95v 969.745n 0.95v 969.755n 0.95v 974.745n 0.95v 974.755n 0.95v 979.745n 0.95v 979.755n 0.95v 984.745n 0.95v 984.755n 0.95v 989.745n 0.95v 989.755n 0.95v 994.745n 0.95v 994.755n 0.95v 999.745n 0.95v 999.755n 0.95v 1004.745n 0.95v 1004.755n 0.95v 1009.745n 0.95v 1009.755n 0.95v 1014.745n 0.95v 1014.755n 0.95v 1019.745n 0.95v 1019.755n 0.95v 1024.745n 0.95v 1024.755n 0.95v )
* (time, data): [(0, 0), (5, 0), (10, 0), (15, 1), (20, 1), (25, 1), (30, 1), (35, 1), (40, 1), (45, 1), (50, 0), (55, 0), (60, 0), (65, 0), (70, 0), (75, 1), (80, 1), (85, 1), (90, 1), (95, 0), (100, 0), (105, 0), (110, 0), (115, 0), (120, 0), (125, 0), (130, 0), (135, 0), (140, 0), (145, 0), (150, 0), (155, 0), (160, 0), (165, 1), (170, 1), (175, 1), (180, 1), (185, 1), (190, 0), (195, 0), (200, 0), (205, 0), (210, 0), (215, 0), (220, 0), (225, 0), (230, 0), (235, 0), (240, 0), (245, 0), (250, 0), (255, 0), (260, 0), (265, 0), (270, 0), (275, 0), (280, 0), (285, 0), (290, 0), (295, 0), (300, 0), (305, 0), (310, 0), (315, 0), (320, 1), (325, 1), (330, 1), (335, 1), (340, 1), (345, 1), (350, 1), (355, 1), (360, 1), (365, 1), (370, 1), (375, 1), (380, 1), (385, 1), (390, 1), (395, 1), (400, 1), (405, 1), (410, 1), (415, 1), (420, 1), (425, 0), (430, 0), (435, 0), (440, 0), (445, 0), (450, 0), (455, 0), (460, 0), (465, 0), (470, 0), (475, 0), (480, 0), (485, 0), (490, 0), (495, 0), (500, 0), (505, 0), (510, 0), (515, 0), (520, 0), (525, 1), (530, 0), (535, 0), (540, 0), (545, 0), (550, 1), (555, 1), (560, 1), (565, 1), (570, 1), (575, 1), (580, 1), (585, 1), (590, 1), (595, 1), (600, 1), (605, 1), (610, 1), (615, 1), (620, 1), (625, 1), (630, 1), (635, 1), (640, 1), (645, 1), (650, 1), (655, 0), (660, 0), (665, 0), (670, 0), (675, 0), (680, 0), (685, 0), (690, 0), (695, 0), (700, 0), (705, 0), (710, 0), (715, 0), (720, 1), (725, 1), (730, 1), (735, 1), (740, 1), (745, 1), (750, 1), (755, 1), (760, 1), (765, 1), (770, 0), (775, 0), (780, 0), (785, 0), (790, 1), (795, 1), (800, 1), (805, 1), (810, 1), (815, 1), (820, 0), (825, 0), (830, 1), (835, 1), (840, 1), (845, 1), (850, 1), (855, 1), (860, 0), (865, 0), (870, 0), (875, 1), (880, 1), (885, 1), (890, 1), (895, 1), (900, 1), (905, 0), (910, 0), (915, 0), (920, 0), (925, 0), (930, 0), (935, 0), (940, 1), (945, 1), (950, 1), (955, 1), (960, 1), (965, 1), (970, 1), (975, 1), (980, 1), (985, 1), (990, 1), (995, 1), (1000, 0), (1005, 0), (1010, 0), (1015, 0), (1020, 0), (1025, 0)]
Vdin0_13  din0_13  0 PWL (0n 0.0v 4.745n 0.0v 4.755n 0.0v 9.745n 0.0v 9.755n 0.0v 14.745n 0.0v 14.755n 0.95v 19.745n 0.95v 19.755n 0.95v 24.745n 0.95v 24.755n 0.95v 29.745n 0.95v 29.755n 0.95v 34.745n 0.95v 34.755n 0.95v 39.745n 0.95v 39.755n 0.95v 44.745n 0.95v 44.755n 0.95v 49.745n 0.95v 49.755n 0.0v 54.745n 0.0v 54.755n 0.0v 59.745n 0.0v 59.755n 0.0v 64.745n 0.0v 64.755n 0.0v 69.745n 0.0v 69.755n 0.0v 74.745n 0.0v 74.755n 0.95v 79.745n 0.95v 79.755n 0.95v 84.745n 0.95v 84.755n 0.95v 89.745n 0.95v 89.755n 0.95v 94.745n 0.95v 94.755n 0.0v 99.745n 0.0v 99.755n 0.0v 104.745n 0.0v 104.755n 0.0v 109.745n 0.0v 109.755n 0.0v 114.745n 0.0v 114.755n 0.0v 119.745n 0.0v 119.755n 0.0v 124.745n 0.0v 124.755n 0.0v 129.745n 0.0v 129.755n 0.0v 134.745n 0.0v 134.755n 0.0v 139.745n 0.0v 139.755n 0.0v 144.745n 0.0v 144.755n 0.0v 149.745n 0.0v 149.755n 0.0v 154.745n 0.0v 154.755n 0.0v 159.745n 0.0v 159.755n 0.0v 164.745n 0.0v 164.755n 0.95v 169.745n 0.95v 169.755n 0.95v 174.745n 0.95v 174.755n 0.95v 179.745n 0.95v 179.755n 0.95v 184.745n 0.95v 184.755n 0.95v 189.745n 0.95v 189.755n 0.0v 194.745n 0.0v 194.755n 0.0v 199.745n 0.0v 199.755n 0.0v 204.745n 0.0v 204.755n 0.0v 209.745n 0.0v 209.755n 0.0v 214.745n 0.0v 214.755n 0.0v 219.745n 0.0v 219.755n 0.0v 224.745n 0.0v 224.755n 0.0v 229.745n 0.0v 229.755n 0.0v 234.745n 0.0v 234.755n 0.0v 239.745n 0.0v 239.755n 0.0v 244.745n 0.0v 244.755n 0.0v 249.745n 0.0v 249.755n 0.0v 254.745n 0.0v 254.755n 0.0v 259.745n 0.0v 259.755n 0.0v 264.745n 0.0v 264.755n 0.0v 269.745n 0.0v 269.755n 0.0v 274.745n 0.0v 274.755n 0.0v 279.745n 0.0v 279.755n 0.0v 284.745n 0.0v 284.755n 0.0v 289.745n 0.0v 289.755n 0.0v 294.745n 0.0v 294.755n 0.0v 299.745n 0.0v 299.755n 0.0v 304.745n 0.0v 304.755n 0.0v 309.745n 0.0v 309.755n 0.0v 314.745n 0.0v 314.755n 0.0v 319.745n 0.0v 319.755n 0.95v 324.745n 0.95v 324.755n 0.95v 329.745n 0.95v 329.755n 0.95v 334.745n 0.95v 334.755n 0.95v 339.745n 0.95v 339.755n 0.95v 344.745n 0.95v 344.755n 0.95v 349.745n 0.95v 349.755n 0.95v 354.745n 0.95v 354.755n 0.95v 359.745n 0.95v 359.755n 0.95v 364.745n 0.95v 364.755n 0.95v 369.745n 0.95v 369.755n 0.95v 374.745n 0.95v 374.755n 0.95v 379.745n 0.95v 379.755n 0.95v 384.745n 0.95v 384.755n 0.95v 389.745n 0.95v 389.755n 0.95v 394.745n 0.95v 394.755n 0.95v 399.745n 0.95v 399.755n 0.95v 404.745n 0.95v 404.755n 0.95v 409.745n 0.95v 409.755n 0.95v 414.745n 0.95v 414.755n 0.95v 419.745n 0.95v 419.755n 0.95v 424.745n 0.95v 424.755n 0.0v 429.745n 0.0v 429.755n 0.0v 434.745n 0.0v 434.755n 0.0v 439.745n 0.0v 439.755n 0.0v 444.745n 0.0v 444.755n 0.0v 449.745n 0.0v 449.755n 0.0v 454.745n 0.0v 454.755n 0.0v 459.745n 0.0v 459.755n 0.0v 464.745n 0.0v 464.755n 0.0v 469.745n 0.0v 469.755n 0.0v 474.745n 0.0v 474.755n 0.0v 479.745n 0.0v 479.755n 0.0v 484.745n 0.0v 484.755n 0.0v 489.745n 0.0v 489.755n 0.0v 494.745n 0.0v 494.755n 0.0v 499.745n 0.0v 499.755n 0.0v 504.745n 0.0v 504.755n 0.0v 509.745n 0.0v 509.755n 0.0v 514.745n 0.0v 514.755n 0.0v 519.745n 0.0v 519.755n 0.0v 524.745n 0.0v 524.755n 0.95v 529.745n 0.95v 529.755n 0.0v 534.745n 0.0v 534.755n 0.0v 539.745n 0.0v 539.755n 0.0v 544.745n 0.0v 544.755n 0.0v 549.745n 0.0v 549.755n 0.95v 554.745n 0.95v 554.755n 0.95v 559.745n 0.95v 559.755n 0.95v 564.745n 0.95v 564.755n 0.95v 569.745n 0.95v 569.755n 0.95v 574.745n 0.95v 574.755n 0.95v 579.745n 0.95v 579.755n 0.95v 584.745n 0.95v 584.755n 0.95v 589.745n 0.95v 589.755n 0.95v 594.745n 0.95v 594.755n 0.95v 599.745n 0.95v 599.755n 0.95v 604.745n 0.95v 604.755n 0.95v 609.745n 0.95v 609.755n 0.95v 614.745n 0.95v 614.755n 0.95v 619.745n 0.95v 619.755n 0.95v 624.745n 0.95v 624.755n 0.95v 629.745n 0.95v 629.755n 0.95v 634.745n 0.95v 634.755n 0.95v 639.745n 0.95v 639.755n 0.95v 644.745n 0.95v 644.755n 0.95v 649.745n 0.95v 649.755n 0.95v 654.745n 0.95v 654.755n 0.0v 659.745n 0.0v 659.755n 0.0v 664.745n 0.0v 664.755n 0.0v 669.745n 0.0v 669.755n 0.0v 674.745n 0.0v 674.755n 0.0v 679.745n 0.0v 679.755n 0.0v 684.745n 0.0v 684.755n 0.0v 689.745n 0.0v 689.755n 0.0v 694.745n 0.0v 694.755n 0.0v 699.745n 0.0v 699.755n 0.0v 704.745n 0.0v 704.755n 0.0v 709.745n 0.0v 709.755n 0.0v 714.745n 0.0v 714.755n 0.0v 719.745n 0.0v 719.755n 0.95v 724.745n 0.95v 724.755n 0.95v 729.745n 0.95v 729.755n 0.95v 734.745n 0.95v 734.755n 0.95v 739.745n 0.95v 739.755n 0.95v 744.745n 0.95v 744.755n 0.95v 749.745n 0.95v 749.755n 0.95v 754.745n 0.95v 754.755n 0.95v 759.745n 0.95v 759.755n 0.95v 764.745n 0.95v 764.755n 0.95v 769.745n 0.95v 769.755n 0.0v 774.745n 0.0v 774.755n 0.0v 779.745n 0.0v 779.755n 0.0v 784.745n 0.0v 784.755n 0.0v 789.745n 0.0v 789.755n 0.95v 794.745n 0.95v 794.755n 0.95v 799.745n 0.95v 799.755n 0.95v 804.745n 0.95v 804.755n 0.95v 809.745n 0.95v 809.755n 0.95v 814.745n 0.95v 814.755n 0.95v 819.745n 0.95v 819.755n 0.0v 824.745n 0.0v 824.755n 0.0v 829.745n 0.0v 829.755n 0.95v 834.745n 0.95v 834.755n 0.95v 839.745n 0.95v 839.755n 0.95v 844.745n 0.95v 844.755n 0.95v 849.745n 0.95v 849.755n 0.95v 854.745n 0.95v 854.755n 0.95v 859.745n 0.95v 859.755n 0.0v 864.745n 0.0v 864.755n 0.0v 869.745n 0.0v 869.755n 0.0v 874.745n 0.0v 874.755n 0.95v 879.745n 0.95v 879.755n 0.95v 884.745n 0.95v 884.755n 0.95v 889.745n 0.95v 889.755n 0.95v 894.745n 0.95v 894.755n 0.95v 899.745n 0.95v 899.755n 0.95v 904.745n 0.95v 904.755n 0.0v 909.745n 0.0v 909.755n 0.0v 914.745n 0.0v 914.755n 0.0v 919.745n 0.0v 919.755n 0.0v 924.745n 0.0v 924.755n 0.0v 929.745n 0.0v 929.755n 0.0v 934.745n 0.0v 934.755n 0.0v 939.745n 0.0v 939.755n 0.95v 944.745n 0.95v 944.755n 0.95v 949.745n 0.95v 949.755n 0.95v 954.745n 0.95v 954.755n 0.95v 959.745n 0.95v 959.755n 0.95v 964.745n 0.95v 964.755n 0.95v 969.745n 0.95v 969.755n 0.95v 974.745n 0.95v 974.755n 0.95v 979.745n 0.95v 979.755n 0.95v 984.745n 0.95v 984.755n 0.95v 989.745n 0.95v 989.755n 0.95v 994.745n 0.95v 994.755n 0.95v 999.745n 0.95v 999.755n 0.0v 1004.745n 0.0v 1004.755n 0.0v 1009.745n 0.0v 1009.755n 0.0v 1014.745n 0.0v 1014.755n 0.0v 1019.745n 0.0v 1019.755n 0.0v 1024.745n 0.0v 1024.755n 0.0v )
* (time, data): [(0, 0), (5, 1), (10, 1), (15, 1), (20, 1), (25, 1), (30, 1), (35, 1), (40, 1), (45, 1), (50, 1), (55, 1), (60, 1), (65, 1), (70, 1), (75, 0), (80, 0), (85, 0), (90, 0), (95, 1), (100, 1), (105, 1), (110, 1), (115, 1), (120, 1), (125, 1), (130, 1), (135, 1), (140, 1), (145, 1), (150, 0), (155, 0), (160, 0), (165, 1), (170, 1), (175, 1), (180, 1), (185, 1), (190, 0), (195, 0), (200, 0), (205, 0), (210, 0), (215, 0), (220, 0), (225, 0), (230, 0), (235, 0), (240, 1), (245, 1), (250, 1), (255, 1), (260, 1), (265, 0), (270, 0), (275, 0), (280, 0), (285, 0), (290, 0), (295, 0), (300, 0), (305, 0), (310, 0), (315, 0), (320, 1), (325, 1), (330, 0), (335, 0), (340, 0), (345, 0), (350, 0), (355, 0), (360, 0), (365, 0), (370, 0), (375, 0), (380, 0), (385, 0), (390, 0), (395, 0), (400, 0), (405, 0), (410, 0), (415, 0), (420, 0), (425, 0), (430, 0), (435, 0), (440, 0), (445, 0), (450, 0), (455, 0), (460, 0), (465, 0), (470, 0), (475, 0), (480, 0), (485, 0), (490, 0), (495, 0), (500, 0), (505, 0), (510, 1), (515, 1), (520, 1), (525, 0), (530, 0), (535, 0), (540, 0), (545, 0), (550, 1), (555, 1), (560, 1), (565, 1), (570, 0), (575, 0), (580, 0), (585, 0), (590, 1), (595, 1), (600, 1), (605, 1), (610, 1), (615, 1), (620, 1), (625, 1), (630, 1), (635, 1), (640, 1), (645, 1), (650, 1), (655, 0), (660, 0), (665, 0), (670, 0), (675, 0), (680, 0), (685, 0), (690, 0), (695, 0), (700, 0), (705, 0), (710, 0), (715, 0), (720, 1), (725, 1), (730, 1), (735, 1), (740, 1), (745, 1), (750, 1), (755, 1), (760, 1), (765, 1), (770, 0), (775, 0), (780, 0), (785, 0), (790, 0), (795, 0), (800, 0), (805, 0), (810, 0), (815, 0), (820, 1), (825, 1), (830, 1), (835, 1), (840, 1), (845, 1), (850, 1), (855, 1), (860, 0), (865, 0), (870, 0), (875, 1), (880, 1), (885, 1), (890, 1), (895, 1), (900, 1), (905, 1), (910, 1), (915, 1), (920, 1), (925, 1), (930, 1), (935, 0), (940, 1), (945, 1), (950, 1), (955, 1), (960, 1), (965, 1), (970, 0), (975, 0), (980, 0), (985, 0), (990, 0), (995, 0), (1000, 1), (1005, 1), (1010, 1), (1015, 1), (1020, 1), (1025, 1)]
Vdin0_14  din0_14  0 PWL (0n 0.0v 4.745n 0.0v 4.755n 0.95v 9.745n 0.95v 9.755n 0.95v 14.745n 0.95v 14.755n 0.95v 19.745n 0.95v 19.755n 0.95v 24.745n 0.95v 24.755n 0.95v 29.745n 0.95v 29.755n 0.95v 34.745n 0.95v 34.755n 0.95v 39.745n 0.95v 39.755n 0.95v 44.745n 0.95v 44.755n 0.95v 49.745n 0.95v 49.755n 0.95v 54.745n 0.95v 54.755n 0.95v 59.745n 0.95v 59.755n 0.95v 64.745n 0.95v 64.755n 0.95v 69.745n 0.95v 69.755n 0.95v 74.745n 0.95v 74.755n 0.0v 79.745n 0.0v 79.755n 0.0v 84.745n 0.0v 84.755n 0.0v 89.745n 0.0v 89.755n 0.0v 94.745n 0.0v 94.755n 0.95v 99.745n 0.95v 99.755n 0.95v 104.745n 0.95v 104.755n 0.95v 109.745n 0.95v 109.755n 0.95v 114.745n 0.95v 114.755n 0.95v 119.745n 0.95v 119.755n 0.95v 124.745n 0.95v 124.755n 0.95v 129.745n 0.95v 129.755n 0.95v 134.745n 0.95v 134.755n 0.95v 139.745n 0.95v 139.755n 0.95v 144.745n 0.95v 144.755n 0.95v 149.745n 0.95v 149.755n 0.0v 154.745n 0.0v 154.755n 0.0v 159.745n 0.0v 159.755n 0.0v 164.745n 0.0v 164.755n 0.95v 169.745n 0.95v 169.755n 0.95v 174.745n 0.95v 174.755n 0.95v 179.745n 0.95v 179.755n 0.95v 184.745n 0.95v 184.755n 0.95v 189.745n 0.95v 189.755n 0.0v 194.745n 0.0v 194.755n 0.0v 199.745n 0.0v 199.755n 0.0v 204.745n 0.0v 204.755n 0.0v 209.745n 0.0v 209.755n 0.0v 214.745n 0.0v 214.755n 0.0v 219.745n 0.0v 219.755n 0.0v 224.745n 0.0v 224.755n 0.0v 229.745n 0.0v 229.755n 0.0v 234.745n 0.0v 234.755n 0.0v 239.745n 0.0v 239.755n 0.95v 244.745n 0.95v 244.755n 0.95v 249.745n 0.95v 249.755n 0.95v 254.745n 0.95v 254.755n 0.95v 259.745n 0.95v 259.755n 0.95v 264.745n 0.95v 264.755n 0.0v 269.745n 0.0v 269.755n 0.0v 274.745n 0.0v 274.755n 0.0v 279.745n 0.0v 279.755n 0.0v 284.745n 0.0v 284.755n 0.0v 289.745n 0.0v 289.755n 0.0v 294.745n 0.0v 294.755n 0.0v 299.745n 0.0v 299.755n 0.0v 304.745n 0.0v 304.755n 0.0v 309.745n 0.0v 309.755n 0.0v 314.745n 0.0v 314.755n 0.0v 319.745n 0.0v 319.755n 0.95v 324.745n 0.95v 324.755n 0.95v 329.745n 0.95v 329.755n 0.0v 334.745n 0.0v 334.755n 0.0v 339.745n 0.0v 339.755n 0.0v 344.745n 0.0v 344.755n 0.0v 349.745n 0.0v 349.755n 0.0v 354.745n 0.0v 354.755n 0.0v 359.745n 0.0v 359.755n 0.0v 364.745n 0.0v 364.755n 0.0v 369.745n 0.0v 369.755n 0.0v 374.745n 0.0v 374.755n 0.0v 379.745n 0.0v 379.755n 0.0v 384.745n 0.0v 384.755n 0.0v 389.745n 0.0v 389.755n 0.0v 394.745n 0.0v 394.755n 0.0v 399.745n 0.0v 399.755n 0.0v 404.745n 0.0v 404.755n 0.0v 409.745n 0.0v 409.755n 0.0v 414.745n 0.0v 414.755n 0.0v 419.745n 0.0v 419.755n 0.0v 424.745n 0.0v 424.755n 0.0v 429.745n 0.0v 429.755n 0.0v 434.745n 0.0v 434.755n 0.0v 439.745n 0.0v 439.755n 0.0v 444.745n 0.0v 444.755n 0.0v 449.745n 0.0v 449.755n 0.0v 454.745n 0.0v 454.755n 0.0v 459.745n 0.0v 459.755n 0.0v 464.745n 0.0v 464.755n 0.0v 469.745n 0.0v 469.755n 0.0v 474.745n 0.0v 474.755n 0.0v 479.745n 0.0v 479.755n 0.0v 484.745n 0.0v 484.755n 0.0v 489.745n 0.0v 489.755n 0.0v 494.745n 0.0v 494.755n 0.0v 499.745n 0.0v 499.755n 0.0v 504.745n 0.0v 504.755n 0.0v 509.745n 0.0v 509.755n 0.95v 514.745n 0.95v 514.755n 0.95v 519.745n 0.95v 519.755n 0.95v 524.745n 0.95v 524.755n 0.0v 529.745n 0.0v 529.755n 0.0v 534.745n 0.0v 534.755n 0.0v 539.745n 0.0v 539.755n 0.0v 544.745n 0.0v 544.755n 0.0v 549.745n 0.0v 549.755n 0.95v 554.745n 0.95v 554.755n 0.95v 559.745n 0.95v 559.755n 0.95v 564.745n 0.95v 564.755n 0.95v 569.745n 0.95v 569.755n 0.0v 574.745n 0.0v 574.755n 0.0v 579.745n 0.0v 579.755n 0.0v 584.745n 0.0v 584.755n 0.0v 589.745n 0.0v 589.755n 0.95v 594.745n 0.95v 594.755n 0.95v 599.745n 0.95v 599.755n 0.95v 604.745n 0.95v 604.755n 0.95v 609.745n 0.95v 609.755n 0.95v 614.745n 0.95v 614.755n 0.95v 619.745n 0.95v 619.755n 0.95v 624.745n 0.95v 624.755n 0.95v 629.745n 0.95v 629.755n 0.95v 634.745n 0.95v 634.755n 0.95v 639.745n 0.95v 639.755n 0.95v 644.745n 0.95v 644.755n 0.95v 649.745n 0.95v 649.755n 0.95v 654.745n 0.95v 654.755n 0.0v 659.745n 0.0v 659.755n 0.0v 664.745n 0.0v 664.755n 0.0v 669.745n 0.0v 669.755n 0.0v 674.745n 0.0v 674.755n 0.0v 679.745n 0.0v 679.755n 0.0v 684.745n 0.0v 684.755n 0.0v 689.745n 0.0v 689.755n 0.0v 694.745n 0.0v 694.755n 0.0v 699.745n 0.0v 699.755n 0.0v 704.745n 0.0v 704.755n 0.0v 709.745n 0.0v 709.755n 0.0v 714.745n 0.0v 714.755n 0.0v 719.745n 0.0v 719.755n 0.95v 724.745n 0.95v 724.755n 0.95v 729.745n 0.95v 729.755n 0.95v 734.745n 0.95v 734.755n 0.95v 739.745n 0.95v 739.755n 0.95v 744.745n 0.95v 744.755n 0.95v 749.745n 0.95v 749.755n 0.95v 754.745n 0.95v 754.755n 0.95v 759.745n 0.95v 759.755n 0.95v 764.745n 0.95v 764.755n 0.95v 769.745n 0.95v 769.755n 0.0v 774.745n 0.0v 774.755n 0.0v 779.745n 0.0v 779.755n 0.0v 784.745n 0.0v 784.755n 0.0v 789.745n 0.0v 789.755n 0.0v 794.745n 0.0v 794.755n 0.0v 799.745n 0.0v 799.755n 0.0v 804.745n 0.0v 804.755n 0.0v 809.745n 0.0v 809.755n 0.0v 814.745n 0.0v 814.755n 0.0v 819.745n 0.0v 819.755n 0.95v 824.745n 0.95v 824.755n 0.95v 829.745n 0.95v 829.755n 0.95v 834.745n 0.95v 834.755n 0.95v 839.745n 0.95v 839.755n 0.95v 844.745n 0.95v 844.755n 0.95v 849.745n 0.95v 849.755n 0.95v 854.745n 0.95v 854.755n 0.95v 859.745n 0.95v 859.755n 0.0v 864.745n 0.0v 864.755n 0.0v 869.745n 0.0v 869.755n 0.0v 874.745n 0.0v 874.755n 0.95v 879.745n 0.95v 879.755n 0.95v 884.745n 0.95v 884.755n 0.95v 889.745n 0.95v 889.755n 0.95v 894.745n 0.95v 894.755n 0.95v 899.745n 0.95v 899.755n 0.95v 904.745n 0.95v 904.755n 0.95v 909.745n 0.95v 909.755n 0.95v 914.745n 0.95v 914.755n 0.95v 919.745n 0.95v 919.755n 0.95v 924.745n 0.95v 924.755n 0.95v 929.745n 0.95v 929.755n 0.95v 934.745n 0.95v 934.755n 0.0v 939.745n 0.0v 939.755n 0.95v 944.745n 0.95v 944.755n 0.95v 949.745n 0.95v 949.755n 0.95v 954.745n 0.95v 954.755n 0.95v 959.745n 0.95v 959.755n 0.95v 964.745n 0.95v 964.755n 0.95v 969.745n 0.95v 969.755n 0.0v 974.745n 0.0v 974.755n 0.0v 979.745n 0.0v 979.755n 0.0v 984.745n 0.0v 984.755n 0.0v 989.745n 0.0v 989.755n 0.0v 994.745n 0.0v 994.755n 0.0v 999.745n 0.0v 999.755n 0.95v 1004.745n 0.95v 1004.755n 0.95v 1009.745n 0.95v 1009.755n 0.95v 1014.745n 0.95v 1014.755n 0.95v 1019.745n 0.95v 1019.755n 0.95v 1024.745n 0.95v 1024.755n 0.95v )
* (time, data): [(0, 0), (5, 0), (10, 1), (15, 0), (20, 0), (25, 0), (30, 0), (35, 0), (40, 0), (45, 0), (50, 1), (55, 1), (60, 1), (65, 1), (70, 1), (75, 0), (80, 0), (85, 0), (90, 0), (95, 1), (100, 1), (105, 1), (110, 1), (115, 1), (120, 1), (125, 1), (130, 1), (135, 1), (140, 1), (145, 1), (150, 1), (155, 1), (160, 0), (165, 0), (170, 0), (175, 0), (180, 0), (185, 0), (190, 1), (195, 1), (200, 1), (205, 1), (210, 1), (215, 1), (220, 1), (225, 1), (230, 1), (235, 1), (240, 0), (245, 0), (250, 0), (255, 0), (260, 0), (265, 0), (270, 0), (275, 0), (280, 0), (285, 0), (290, 1), (295, 1), (300, 1), (305, 1), (310, 1), (315, 1), (320, 1), (325, 1), (330, 0), (335, 0), (340, 0), (345, 0), (350, 0), (355, 0), (360, 0), (365, 0), (370, 0), (375, 0), (380, 0), (385, 0), (390, 0), (395, 0), (400, 0), (405, 0), (410, 0), (415, 0), (420, 0), (425, 1), (430, 1), (435, 1), (440, 1), (445, 1), (450, 1), (455, 1), (460, 1), (465, 1), (470, 1), (475, 1), (480, 1), (485, 1), (490, 1), (495, 1), (500, 1), (505, 1), (510, 1), (515, 1), (520, 1), (525, 0), (530, 1), (535, 1), (540, 1), (545, 1), (550, 0), (555, 0), (560, 0), (565, 0), (570, 0), (575, 0), (580, 0), (585, 0), (590, 0), (595, 0), (600, 0), (605, 0), (610, 0), (615, 0), (620, 0), (625, 0), (630, 0), (635, 0), (640, 0), (645, 0), (650, 0), (655, 1), (660, 1), (665, 1), (670, 1), (675, 1), (680, 1), (685, 0), (690, 0), (695, 0), (700, 0), (705, 0), (710, 0), (715, 0), (720, 0), (725, 0), (730, 0), (735, 0), (740, 0), (745, 0), (750, 0), (755, 0), (760, 0), (765, 0), (770, 1), (775, 1), (780, 1), (785, 1), (790, 0), (795, 0), (800, 0), (805, 0), (810, 0), (815, 0), (820, 1), (825, 1), (830, 0), (835, 0), (840, 0), (845, 0), (850, 0), (855, 0), (860, 1), (865, 1), (870, 1), (875, 0), (880, 0), (885, 0), (890, 0), (895, 0), (900, 0), (905, 1), (910, 1), (915, 1), (920, 1), (925, 1), (930, 1), (935, 0), (940, 1), (945, 1), (950, 1), (955, 1), (960, 1), (965, 1), (970, 1), (975, 1), (980, 1), (985, 1), (990, 1), (995, 1), (1000, 0), (1005, 0), (1010, 0), (1015, 0), (1020, 0), (1025, 0)]
Vdin0_15  din0_15  0 PWL (0n 0.0v 4.745n 0.0v 4.755n 0.0v 9.745n 0.0v 9.755n 0.95v 14.745n 0.95v 14.755n 0.0v 19.745n 0.0v 19.755n 0.0v 24.745n 0.0v 24.755n 0.0v 29.745n 0.0v 29.755n 0.0v 34.745n 0.0v 34.755n 0.0v 39.745n 0.0v 39.755n 0.0v 44.745n 0.0v 44.755n 0.0v 49.745n 0.0v 49.755n 0.95v 54.745n 0.95v 54.755n 0.95v 59.745n 0.95v 59.755n 0.95v 64.745n 0.95v 64.755n 0.95v 69.745n 0.95v 69.755n 0.95v 74.745n 0.95v 74.755n 0.0v 79.745n 0.0v 79.755n 0.0v 84.745n 0.0v 84.755n 0.0v 89.745n 0.0v 89.755n 0.0v 94.745n 0.0v 94.755n 0.95v 99.745n 0.95v 99.755n 0.95v 104.745n 0.95v 104.755n 0.95v 109.745n 0.95v 109.755n 0.95v 114.745n 0.95v 114.755n 0.95v 119.745n 0.95v 119.755n 0.95v 124.745n 0.95v 124.755n 0.95v 129.745n 0.95v 129.755n 0.95v 134.745n 0.95v 134.755n 0.95v 139.745n 0.95v 139.755n 0.95v 144.745n 0.95v 144.755n 0.95v 149.745n 0.95v 149.755n 0.95v 154.745n 0.95v 154.755n 0.95v 159.745n 0.95v 159.755n 0.0v 164.745n 0.0v 164.755n 0.0v 169.745n 0.0v 169.755n 0.0v 174.745n 0.0v 174.755n 0.0v 179.745n 0.0v 179.755n 0.0v 184.745n 0.0v 184.755n 0.0v 189.745n 0.0v 189.755n 0.95v 194.745n 0.95v 194.755n 0.95v 199.745n 0.95v 199.755n 0.95v 204.745n 0.95v 204.755n 0.95v 209.745n 0.95v 209.755n 0.95v 214.745n 0.95v 214.755n 0.95v 219.745n 0.95v 219.755n 0.95v 224.745n 0.95v 224.755n 0.95v 229.745n 0.95v 229.755n 0.95v 234.745n 0.95v 234.755n 0.95v 239.745n 0.95v 239.755n 0.0v 244.745n 0.0v 244.755n 0.0v 249.745n 0.0v 249.755n 0.0v 254.745n 0.0v 254.755n 0.0v 259.745n 0.0v 259.755n 0.0v 264.745n 0.0v 264.755n 0.0v 269.745n 0.0v 269.755n 0.0v 274.745n 0.0v 274.755n 0.0v 279.745n 0.0v 279.755n 0.0v 284.745n 0.0v 284.755n 0.0v 289.745n 0.0v 289.755n 0.95v 294.745n 0.95v 294.755n 0.95v 299.745n 0.95v 299.755n 0.95v 304.745n 0.95v 304.755n 0.95v 309.745n 0.95v 309.755n 0.95v 314.745n 0.95v 314.755n 0.95v 319.745n 0.95v 319.755n 0.95v 324.745n 0.95v 324.755n 0.95v 329.745n 0.95v 329.755n 0.0v 334.745n 0.0v 334.755n 0.0v 339.745n 0.0v 339.755n 0.0v 344.745n 0.0v 344.755n 0.0v 349.745n 0.0v 349.755n 0.0v 354.745n 0.0v 354.755n 0.0v 359.745n 0.0v 359.755n 0.0v 364.745n 0.0v 364.755n 0.0v 369.745n 0.0v 369.755n 0.0v 374.745n 0.0v 374.755n 0.0v 379.745n 0.0v 379.755n 0.0v 384.745n 0.0v 384.755n 0.0v 389.745n 0.0v 389.755n 0.0v 394.745n 0.0v 394.755n 0.0v 399.745n 0.0v 399.755n 0.0v 404.745n 0.0v 404.755n 0.0v 409.745n 0.0v 409.755n 0.0v 414.745n 0.0v 414.755n 0.0v 419.745n 0.0v 419.755n 0.0v 424.745n 0.0v 424.755n 0.95v 429.745n 0.95v 429.755n 0.95v 434.745n 0.95v 434.755n 0.95v 439.745n 0.95v 439.755n 0.95v 444.745n 0.95v 444.755n 0.95v 449.745n 0.95v 449.755n 0.95v 454.745n 0.95v 454.755n 0.95v 459.745n 0.95v 459.755n 0.95v 464.745n 0.95v 464.755n 0.95v 469.745n 0.95v 469.755n 0.95v 474.745n 0.95v 474.755n 0.95v 479.745n 0.95v 479.755n 0.95v 484.745n 0.95v 484.755n 0.95v 489.745n 0.95v 489.755n 0.95v 494.745n 0.95v 494.755n 0.95v 499.745n 0.95v 499.755n 0.95v 504.745n 0.95v 504.755n 0.95v 509.745n 0.95v 509.755n 0.95v 514.745n 0.95v 514.755n 0.95v 519.745n 0.95v 519.755n 0.95v 524.745n 0.95v 524.755n 0.0v 529.745n 0.0v 529.755n 0.95v 534.745n 0.95v 534.755n 0.95v 539.745n 0.95v 539.755n 0.95v 544.745n 0.95v 544.755n 0.95v 549.745n 0.95v 549.755n 0.0v 554.745n 0.0v 554.755n 0.0v 559.745n 0.0v 559.755n 0.0v 564.745n 0.0v 564.755n 0.0v 569.745n 0.0v 569.755n 0.0v 574.745n 0.0v 574.755n 0.0v 579.745n 0.0v 579.755n 0.0v 584.745n 0.0v 584.755n 0.0v 589.745n 0.0v 589.755n 0.0v 594.745n 0.0v 594.755n 0.0v 599.745n 0.0v 599.755n 0.0v 604.745n 0.0v 604.755n 0.0v 609.745n 0.0v 609.755n 0.0v 614.745n 0.0v 614.755n 0.0v 619.745n 0.0v 619.755n 0.0v 624.745n 0.0v 624.755n 0.0v 629.745n 0.0v 629.755n 0.0v 634.745n 0.0v 634.755n 0.0v 639.745n 0.0v 639.755n 0.0v 644.745n 0.0v 644.755n 0.0v 649.745n 0.0v 649.755n 0.0v 654.745n 0.0v 654.755n 0.95v 659.745n 0.95v 659.755n 0.95v 664.745n 0.95v 664.755n 0.95v 669.745n 0.95v 669.755n 0.95v 674.745n 0.95v 674.755n 0.95v 679.745n 0.95v 679.755n 0.95v 684.745n 0.95v 684.755n 0.0v 689.745n 0.0v 689.755n 0.0v 694.745n 0.0v 694.755n 0.0v 699.745n 0.0v 699.755n 0.0v 704.745n 0.0v 704.755n 0.0v 709.745n 0.0v 709.755n 0.0v 714.745n 0.0v 714.755n 0.0v 719.745n 0.0v 719.755n 0.0v 724.745n 0.0v 724.755n 0.0v 729.745n 0.0v 729.755n 0.0v 734.745n 0.0v 734.755n 0.0v 739.745n 0.0v 739.755n 0.0v 744.745n 0.0v 744.755n 0.0v 749.745n 0.0v 749.755n 0.0v 754.745n 0.0v 754.755n 0.0v 759.745n 0.0v 759.755n 0.0v 764.745n 0.0v 764.755n 0.0v 769.745n 0.0v 769.755n 0.95v 774.745n 0.95v 774.755n 0.95v 779.745n 0.95v 779.755n 0.95v 784.745n 0.95v 784.755n 0.95v 789.745n 0.95v 789.755n 0.0v 794.745n 0.0v 794.755n 0.0v 799.745n 0.0v 799.755n 0.0v 804.745n 0.0v 804.755n 0.0v 809.745n 0.0v 809.755n 0.0v 814.745n 0.0v 814.755n 0.0v 819.745n 0.0v 819.755n 0.95v 824.745n 0.95v 824.755n 0.95v 829.745n 0.95v 829.755n 0.0v 834.745n 0.0v 834.755n 0.0v 839.745n 0.0v 839.755n 0.0v 844.745n 0.0v 844.755n 0.0v 849.745n 0.0v 849.755n 0.0v 854.745n 0.0v 854.755n 0.0v 859.745n 0.0v 859.755n 0.95v 864.745n 0.95v 864.755n 0.95v 869.745n 0.95v 869.755n 0.95v 874.745n 0.95v 874.755n 0.0v 879.745n 0.0v 879.755n 0.0v 884.745n 0.0v 884.755n 0.0v 889.745n 0.0v 889.755n 0.0v 894.745n 0.0v 894.755n 0.0v 899.745n 0.0v 899.755n 0.0v 904.745n 0.0v 904.755n 0.95v 909.745n 0.95v 909.755n 0.95v 914.745n 0.95v 914.755n 0.95v 919.745n 0.95v 919.755n 0.95v 924.745n 0.95v 924.755n 0.95v 929.745n 0.95v 929.755n 0.95v 934.745n 0.95v 934.755n 0.0v 939.745n 0.0v 939.755n 0.95v 944.745n 0.95v 944.755n 0.95v 949.745n 0.95v 949.755n 0.95v 954.745n 0.95v 954.755n 0.95v 959.745n 0.95v 959.755n 0.95v 964.745n 0.95v 964.755n 0.95v 969.745n 0.95v 969.755n 0.95v 974.745n 0.95v 974.755n 0.95v 979.745n 0.95v 979.755n 0.95v 984.745n 0.95v 984.755n 0.95v 989.745n 0.95v 989.755n 0.95v 994.745n 0.95v 994.755n 0.95v 999.745n 0.95v 999.755n 0.0v 1004.745n 0.0v 1004.755n 0.0v 1009.745n 0.0v 1009.755n 0.0v 1014.745n 0.0v 1014.755n 0.0v 1019.745n 0.0v 1019.755n 0.0v 1024.745n 0.0v 1024.755n 0.0v )
* (time, data): [(0, 0), (5, 0), (10, 0), (15, 1), (20, 1), (25, 1), (30, 1), (35, 1), (40, 1), (45, 1), (50, 1), (55, 1), (60, 1), (65, 1), (70, 1), (75, 1), (80, 1), (85, 1), (90, 1), (95, 1), (100, 1), (105, 1), (110, 1), (115, 0), (120, 0), (125, 0), (130, 0), (135, 0), (140, 0), (145, 0), (150, 0), (155, 0), (160, 0), (165, 0), (170, 0), (175, 0), (180, 0), (185, 0), (190, 1), (195, 1), (200, 1), (205, 1), (210, 1), (215, 1), (220, 1), (225, 1), (230, 1), (235, 1), (240, 0), (245, 0), (250, 0), (255, 0), (260, 0), (265, 1), (270, 1), (275, 1), (280, 1), (285, 1), (290, 1), (295, 1), (300, 1), (305, 1), (310, 1), (315, 1), (320, 0), (325, 0), (330, 0), (335, 0), (340, 0), (345, 0), (350, 0), (355, 0), (360, 0), (365, 0), (370, 0), (375, 0), (380, 0), (385, 0), (390, 0), (395, 0), (400, 0), (405, 0), (410, 0), (415, 0), (420, 0), (425, 0), (430, 0), (435, 0), (440, 0), (445, 0), (450, 0), (455, 0), (460, 0), (465, 0), (470, 0), (475, 0), (480, 0), (485, 0), (490, 0), (495, 0), (500, 0), (505, 0), (510, 1), (515, 1), (520, 1), (525, 1), (530, 1), (535, 1), (540, 1), (545, 1), (550, 1), (555, 1), (560, 1), (565, 1), (570, 0), (575, 0), (580, 0), (585, 0), (590, 0), (595, 0), (600, 0), (605, 0), (610, 0), (615, 0), (620, 0), (625, 0), (630, 0), (635, 0), (640, 0), (645, 0), (650, 0), (655, 1), (660, 1), (665, 1), (670, 1), (675, 1), (680, 1), (685, 1), (690, 1), (695, 1), (700, 1), (705, 1), (710, 1), (715, 1), (720, 0), (725, 0), (730, 0), (735, 0), (740, 0), (745, 0), (750, 0), (755, 0), (760, 0), (765, 0), (770, 1), (775, 1), (780, 1), (785, 1), (790, 0), (795, 0), (800, 0), (805, 0), (810, 0), (815, 0), (820, 0), (825, 0), (830, 1), (835, 1), (840, 1), (845, 1), (850, 1), (855, 1), (860, 0), (865, 0), (870, 0), (875, 1), (880, 1), (885, 1), (890, 1), (895, 1), (900, 1), (905, 1), (910, 1), (915, 1), (920, 1), (925, 1), (930, 1), (935, 1), (940, 1), (945, 1), (950, 1), (955, 1), (960, 1), (965, 1), (970, 1), (975, 1), (980, 1), (985, 1), (990, 1), (995, 1), (1000, 0), (1005, 0), (1010, 0), (1015, 0), (1020, 0), (1025, 0)]
Vdin0_16  din0_16  0 PWL (0n 0.0v 4.745n 0.0v 4.755n 0.0v 9.745n 0.0v 9.755n 0.0v 14.745n 0.0v 14.755n 0.95v 19.745n 0.95v 19.755n 0.95v 24.745n 0.95v 24.755n 0.95v 29.745n 0.95v 29.755n 0.95v 34.745n 0.95v 34.755n 0.95v 39.745n 0.95v 39.755n 0.95v 44.745n 0.95v 44.755n 0.95v 49.745n 0.95v 49.755n 0.95v 54.745n 0.95v 54.755n 0.95v 59.745n 0.95v 59.755n 0.95v 64.745n 0.95v 64.755n 0.95v 69.745n 0.95v 69.755n 0.95v 74.745n 0.95v 74.755n 0.95v 79.745n 0.95v 79.755n 0.95v 84.745n 0.95v 84.755n 0.95v 89.745n 0.95v 89.755n 0.95v 94.745n 0.95v 94.755n 0.95v 99.745n 0.95v 99.755n 0.95v 104.745n 0.95v 104.755n 0.95v 109.745n 0.95v 109.755n 0.95v 114.745n 0.95v 114.755n 0.0v 119.745n 0.0v 119.755n 0.0v 124.745n 0.0v 124.755n 0.0v 129.745n 0.0v 129.755n 0.0v 134.745n 0.0v 134.755n 0.0v 139.745n 0.0v 139.755n 0.0v 144.745n 0.0v 144.755n 0.0v 149.745n 0.0v 149.755n 0.0v 154.745n 0.0v 154.755n 0.0v 159.745n 0.0v 159.755n 0.0v 164.745n 0.0v 164.755n 0.0v 169.745n 0.0v 169.755n 0.0v 174.745n 0.0v 174.755n 0.0v 179.745n 0.0v 179.755n 0.0v 184.745n 0.0v 184.755n 0.0v 189.745n 0.0v 189.755n 0.95v 194.745n 0.95v 194.755n 0.95v 199.745n 0.95v 199.755n 0.95v 204.745n 0.95v 204.755n 0.95v 209.745n 0.95v 209.755n 0.95v 214.745n 0.95v 214.755n 0.95v 219.745n 0.95v 219.755n 0.95v 224.745n 0.95v 224.755n 0.95v 229.745n 0.95v 229.755n 0.95v 234.745n 0.95v 234.755n 0.95v 239.745n 0.95v 239.755n 0.0v 244.745n 0.0v 244.755n 0.0v 249.745n 0.0v 249.755n 0.0v 254.745n 0.0v 254.755n 0.0v 259.745n 0.0v 259.755n 0.0v 264.745n 0.0v 264.755n 0.95v 269.745n 0.95v 269.755n 0.95v 274.745n 0.95v 274.755n 0.95v 279.745n 0.95v 279.755n 0.95v 284.745n 0.95v 284.755n 0.95v 289.745n 0.95v 289.755n 0.95v 294.745n 0.95v 294.755n 0.95v 299.745n 0.95v 299.755n 0.95v 304.745n 0.95v 304.755n 0.95v 309.745n 0.95v 309.755n 0.95v 314.745n 0.95v 314.755n 0.95v 319.745n 0.95v 319.755n 0.0v 324.745n 0.0v 324.755n 0.0v 329.745n 0.0v 329.755n 0.0v 334.745n 0.0v 334.755n 0.0v 339.745n 0.0v 339.755n 0.0v 344.745n 0.0v 344.755n 0.0v 349.745n 0.0v 349.755n 0.0v 354.745n 0.0v 354.755n 0.0v 359.745n 0.0v 359.755n 0.0v 364.745n 0.0v 364.755n 0.0v 369.745n 0.0v 369.755n 0.0v 374.745n 0.0v 374.755n 0.0v 379.745n 0.0v 379.755n 0.0v 384.745n 0.0v 384.755n 0.0v 389.745n 0.0v 389.755n 0.0v 394.745n 0.0v 394.755n 0.0v 399.745n 0.0v 399.755n 0.0v 404.745n 0.0v 404.755n 0.0v 409.745n 0.0v 409.755n 0.0v 414.745n 0.0v 414.755n 0.0v 419.745n 0.0v 419.755n 0.0v 424.745n 0.0v 424.755n 0.0v 429.745n 0.0v 429.755n 0.0v 434.745n 0.0v 434.755n 0.0v 439.745n 0.0v 439.755n 0.0v 444.745n 0.0v 444.755n 0.0v 449.745n 0.0v 449.755n 0.0v 454.745n 0.0v 454.755n 0.0v 459.745n 0.0v 459.755n 0.0v 464.745n 0.0v 464.755n 0.0v 469.745n 0.0v 469.755n 0.0v 474.745n 0.0v 474.755n 0.0v 479.745n 0.0v 479.755n 0.0v 484.745n 0.0v 484.755n 0.0v 489.745n 0.0v 489.755n 0.0v 494.745n 0.0v 494.755n 0.0v 499.745n 0.0v 499.755n 0.0v 504.745n 0.0v 504.755n 0.0v 509.745n 0.0v 509.755n 0.95v 514.745n 0.95v 514.755n 0.95v 519.745n 0.95v 519.755n 0.95v 524.745n 0.95v 524.755n 0.95v 529.745n 0.95v 529.755n 0.95v 534.745n 0.95v 534.755n 0.95v 539.745n 0.95v 539.755n 0.95v 544.745n 0.95v 544.755n 0.95v 549.745n 0.95v 549.755n 0.95v 554.745n 0.95v 554.755n 0.95v 559.745n 0.95v 559.755n 0.95v 564.745n 0.95v 564.755n 0.95v 569.745n 0.95v 569.755n 0.0v 574.745n 0.0v 574.755n 0.0v 579.745n 0.0v 579.755n 0.0v 584.745n 0.0v 584.755n 0.0v 589.745n 0.0v 589.755n 0.0v 594.745n 0.0v 594.755n 0.0v 599.745n 0.0v 599.755n 0.0v 604.745n 0.0v 604.755n 0.0v 609.745n 0.0v 609.755n 0.0v 614.745n 0.0v 614.755n 0.0v 619.745n 0.0v 619.755n 0.0v 624.745n 0.0v 624.755n 0.0v 629.745n 0.0v 629.755n 0.0v 634.745n 0.0v 634.755n 0.0v 639.745n 0.0v 639.755n 0.0v 644.745n 0.0v 644.755n 0.0v 649.745n 0.0v 649.755n 0.0v 654.745n 0.0v 654.755n 0.95v 659.745n 0.95v 659.755n 0.95v 664.745n 0.95v 664.755n 0.95v 669.745n 0.95v 669.755n 0.95v 674.745n 0.95v 674.755n 0.95v 679.745n 0.95v 679.755n 0.95v 684.745n 0.95v 684.755n 0.95v 689.745n 0.95v 689.755n 0.95v 694.745n 0.95v 694.755n 0.95v 699.745n 0.95v 699.755n 0.95v 704.745n 0.95v 704.755n 0.95v 709.745n 0.95v 709.755n 0.95v 714.745n 0.95v 714.755n 0.95v 719.745n 0.95v 719.755n 0.0v 724.745n 0.0v 724.755n 0.0v 729.745n 0.0v 729.755n 0.0v 734.745n 0.0v 734.755n 0.0v 739.745n 0.0v 739.755n 0.0v 744.745n 0.0v 744.755n 0.0v 749.745n 0.0v 749.755n 0.0v 754.745n 0.0v 754.755n 0.0v 759.745n 0.0v 759.755n 0.0v 764.745n 0.0v 764.755n 0.0v 769.745n 0.0v 769.755n 0.95v 774.745n 0.95v 774.755n 0.95v 779.745n 0.95v 779.755n 0.95v 784.745n 0.95v 784.755n 0.95v 789.745n 0.95v 789.755n 0.0v 794.745n 0.0v 794.755n 0.0v 799.745n 0.0v 799.755n 0.0v 804.745n 0.0v 804.755n 0.0v 809.745n 0.0v 809.755n 0.0v 814.745n 0.0v 814.755n 0.0v 819.745n 0.0v 819.755n 0.0v 824.745n 0.0v 824.755n 0.0v 829.745n 0.0v 829.755n 0.95v 834.745n 0.95v 834.755n 0.95v 839.745n 0.95v 839.755n 0.95v 844.745n 0.95v 844.755n 0.95v 849.745n 0.95v 849.755n 0.95v 854.745n 0.95v 854.755n 0.95v 859.745n 0.95v 859.755n 0.0v 864.745n 0.0v 864.755n 0.0v 869.745n 0.0v 869.755n 0.0v 874.745n 0.0v 874.755n 0.95v 879.745n 0.95v 879.755n 0.95v 884.745n 0.95v 884.755n 0.95v 889.745n 0.95v 889.755n 0.95v 894.745n 0.95v 894.755n 0.95v 899.745n 0.95v 899.755n 0.95v 904.745n 0.95v 904.755n 0.95v 909.745n 0.95v 909.755n 0.95v 914.745n 0.95v 914.755n 0.95v 919.745n 0.95v 919.755n 0.95v 924.745n 0.95v 924.755n 0.95v 929.745n 0.95v 929.755n 0.95v 934.745n 0.95v 934.755n 0.95v 939.745n 0.95v 939.755n 0.95v 944.745n 0.95v 944.755n 0.95v 949.745n 0.95v 949.755n 0.95v 954.745n 0.95v 954.755n 0.95v 959.745n 0.95v 959.755n 0.95v 964.745n 0.95v 964.755n 0.95v 969.745n 0.95v 969.755n 0.95v 974.745n 0.95v 974.755n 0.95v 979.745n 0.95v 979.755n 0.95v 984.745n 0.95v 984.755n 0.95v 989.745n 0.95v 989.755n 0.95v 994.745n 0.95v 994.755n 0.95v 999.745n 0.95v 999.755n 0.0v 1004.745n 0.0v 1004.755n 0.0v 1009.745n 0.0v 1009.755n 0.0v 1014.745n 0.0v 1014.755n 0.0v 1019.745n 0.0v 1019.755n 0.0v 1024.745n 0.0v 1024.755n 0.0v )
* (time, data): [(0, 0), (5, 0), (10, 0), (15, 0), (20, 0), (25, 0), (30, 0), (35, 0), (40, 0), (45, 0), (50, 1), (55, 1), (60, 1), (65, 1), (70, 1), (75, 1), (80, 1), (85, 1), (90, 1), (95, 1), (100, 1), (105, 1), (110, 1), (115, 0), (120, 0), (125, 0), (130, 0), (135, 0), (140, 0), (145, 0), (150, 1), (155, 1), (160, 1), (165, 0), (170, 0), (175, 0), (180, 0), (185, 0), (190, 0), (195, 0), (200, 0), (205, 0), (210, 0), (215, 0), (220, 0), (225, 0), (230, 0), (235, 0), (240, 0), (245, 0), (250, 0), (255, 0), (260, 0), (265, 0), (270, 0), (275, 0), (280, 0), (285, 0), (290, 0), (295, 0), (300, 0), (305, 0), (310, 0), (315, 0), (320, 1), (325, 0), (330, 1), (335, 1), (340, 1), (345, 1), (350, 1), (355, 1), (360, 1), (365, 1), (370, 1), (375, 1), (380, 1), (385, 1), (390, 1), (395, 1), (400, 1), (405, 1), (410, 0), (415, 0), (420, 0), (425, 1), (430, 1), (435, 1), (440, 1), (445, 1), (450, 1), (455, 1), (460, 1), (465, 1), (470, 1), (475, 1), (480, 1), (485, 1), (490, 1), (495, 1), (500, 1), (505, 1), (510, 0), (515, 0), (520, 0), (525, 1), (530, 0), (535, 0), (540, 0), (545, 0), (550, 0), (555, 0), (560, 0), (565, 0), (570, 1), (575, 1), (580, 1), (585, 1), (590, 0), (595, 0), (600, 0), (605, 0), (610, 0), (615, 1), (620, 1), (625, 1), (630, 1), (635, 1), (640, 1), (645, 1), (650, 1), (655, 1), (660, 1), (665, 1), (670, 1), (675, 1), (680, 1), (685, 0), (690, 0), (695, 0), (700, 0), (705, 0), (710, 0), (715, 0), (720, 0), (725, 0), (730, 0), (735, 0), (740, 0), (745, 0), (750, 0), (755, 0), (760, 0), (765, 0), (770, 0), (775, 0), (780, 0), (785, 0), (790, 1), (795, 1), (800, 1), (805, 1), (810, 1), (815, 1), (820, 1), (825, 1), (830, 1), (835, 1), (840, 1), (845, 1), (850, 1), (855, 1), (860, 1), (865, 1), (870, 1), (875, 0), (880, 0), (885, 0), (890, 0), (895, 0), (900, 1), (905, 1), (910, 1), (915, 1), (920, 1), (925, 1), (930, 1), (935, 0), (940, 1), (945, 1), (950, 1), (955, 1), (960, 1), (965, 1), (970, 0), (975, 0), (980, 0), (985, 0), (990, 0), (995, 0), (1000, 0), (1005, 0), (1010, 0), (1015, 0), (1020, 0), (1025, 0)]
Vdin0_17  din0_17  0 PWL (0n 0.0v 4.745n 0.0v 4.755n 0.0v 9.745n 0.0v 9.755n 0.0v 14.745n 0.0v 14.755n 0.0v 19.745n 0.0v 19.755n 0.0v 24.745n 0.0v 24.755n 0.0v 29.745n 0.0v 29.755n 0.0v 34.745n 0.0v 34.755n 0.0v 39.745n 0.0v 39.755n 0.0v 44.745n 0.0v 44.755n 0.0v 49.745n 0.0v 49.755n 0.95v 54.745n 0.95v 54.755n 0.95v 59.745n 0.95v 59.755n 0.95v 64.745n 0.95v 64.755n 0.95v 69.745n 0.95v 69.755n 0.95v 74.745n 0.95v 74.755n 0.95v 79.745n 0.95v 79.755n 0.95v 84.745n 0.95v 84.755n 0.95v 89.745n 0.95v 89.755n 0.95v 94.745n 0.95v 94.755n 0.95v 99.745n 0.95v 99.755n 0.95v 104.745n 0.95v 104.755n 0.95v 109.745n 0.95v 109.755n 0.95v 114.745n 0.95v 114.755n 0.0v 119.745n 0.0v 119.755n 0.0v 124.745n 0.0v 124.755n 0.0v 129.745n 0.0v 129.755n 0.0v 134.745n 0.0v 134.755n 0.0v 139.745n 0.0v 139.755n 0.0v 144.745n 0.0v 144.755n 0.0v 149.745n 0.0v 149.755n 0.95v 154.745n 0.95v 154.755n 0.95v 159.745n 0.95v 159.755n 0.95v 164.745n 0.95v 164.755n 0.0v 169.745n 0.0v 169.755n 0.0v 174.745n 0.0v 174.755n 0.0v 179.745n 0.0v 179.755n 0.0v 184.745n 0.0v 184.755n 0.0v 189.745n 0.0v 189.755n 0.0v 194.745n 0.0v 194.755n 0.0v 199.745n 0.0v 199.755n 0.0v 204.745n 0.0v 204.755n 0.0v 209.745n 0.0v 209.755n 0.0v 214.745n 0.0v 214.755n 0.0v 219.745n 0.0v 219.755n 0.0v 224.745n 0.0v 224.755n 0.0v 229.745n 0.0v 229.755n 0.0v 234.745n 0.0v 234.755n 0.0v 239.745n 0.0v 239.755n 0.0v 244.745n 0.0v 244.755n 0.0v 249.745n 0.0v 249.755n 0.0v 254.745n 0.0v 254.755n 0.0v 259.745n 0.0v 259.755n 0.0v 264.745n 0.0v 264.755n 0.0v 269.745n 0.0v 269.755n 0.0v 274.745n 0.0v 274.755n 0.0v 279.745n 0.0v 279.755n 0.0v 284.745n 0.0v 284.755n 0.0v 289.745n 0.0v 289.755n 0.0v 294.745n 0.0v 294.755n 0.0v 299.745n 0.0v 299.755n 0.0v 304.745n 0.0v 304.755n 0.0v 309.745n 0.0v 309.755n 0.0v 314.745n 0.0v 314.755n 0.0v 319.745n 0.0v 319.755n 0.95v 324.745n 0.95v 324.755n 0.0v 329.745n 0.0v 329.755n 0.95v 334.745n 0.95v 334.755n 0.95v 339.745n 0.95v 339.755n 0.95v 344.745n 0.95v 344.755n 0.95v 349.745n 0.95v 349.755n 0.95v 354.745n 0.95v 354.755n 0.95v 359.745n 0.95v 359.755n 0.95v 364.745n 0.95v 364.755n 0.95v 369.745n 0.95v 369.755n 0.95v 374.745n 0.95v 374.755n 0.95v 379.745n 0.95v 379.755n 0.95v 384.745n 0.95v 384.755n 0.95v 389.745n 0.95v 389.755n 0.95v 394.745n 0.95v 394.755n 0.95v 399.745n 0.95v 399.755n 0.95v 404.745n 0.95v 404.755n 0.95v 409.745n 0.95v 409.755n 0.0v 414.745n 0.0v 414.755n 0.0v 419.745n 0.0v 419.755n 0.0v 424.745n 0.0v 424.755n 0.95v 429.745n 0.95v 429.755n 0.95v 434.745n 0.95v 434.755n 0.95v 439.745n 0.95v 439.755n 0.95v 444.745n 0.95v 444.755n 0.95v 449.745n 0.95v 449.755n 0.95v 454.745n 0.95v 454.755n 0.95v 459.745n 0.95v 459.755n 0.95v 464.745n 0.95v 464.755n 0.95v 469.745n 0.95v 469.755n 0.95v 474.745n 0.95v 474.755n 0.95v 479.745n 0.95v 479.755n 0.95v 484.745n 0.95v 484.755n 0.95v 489.745n 0.95v 489.755n 0.95v 494.745n 0.95v 494.755n 0.95v 499.745n 0.95v 499.755n 0.95v 504.745n 0.95v 504.755n 0.95v 509.745n 0.95v 509.755n 0.0v 514.745n 0.0v 514.755n 0.0v 519.745n 0.0v 519.755n 0.0v 524.745n 0.0v 524.755n 0.95v 529.745n 0.95v 529.755n 0.0v 534.745n 0.0v 534.755n 0.0v 539.745n 0.0v 539.755n 0.0v 544.745n 0.0v 544.755n 0.0v 549.745n 0.0v 549.755n 0.0v 554.745n 0.0v 554.755n 0.0v 559.745n 0.0v 559.755n 0.0v 564.745n 0.0v 564.755n 0.0v 569.745n 0.0v 569.755n 0.95v 574.745n 0.95v 574.755n 0.95v 579.745n 0.95v 579.755n 0.95v 584.745n 0.95v 584.755n 0.95v 589.745n 0.95v 589.755n 0.0v 594.745n 0.0v 594.755n 0.0v 599.745n 0.0v 599.755n 0.0v 604.745n 0.0v 604.755n 0.0v 609.745n 0.0v 609.755n 0.0v 614.745n 0.0v 614.755n 0.95v 619.745n 0.95v 619.755n 0.95v 624.745n 0.95v 624.755n 0.95v 629.745n 0.95v 629.755n 0.95v 634.745n 0.95v 634.755n 0.95v 639.745n 0.95v 639.755n 0.95v 644.745n 0.95v 644.755n 0.95v 649.745n 0.95v 649.755n 0.95v 654.745n 0.95v 654.755n 0.95v 659.745n 0.95v 659.755n 0.95v 664.745n 0.95v 664.755n 0.95v 669.745n 0.95v 669.755n 0.95v 674.745n 0.95v 674.755n 0.95v 679.745n 0.95v 679.755n 0.95v 684.745n 0.95v 684.755n 0.0v 689.745n 0.0v 689.755n 0.0v 694.745n 0.0v 694.755n 0.0v 699.745n 0.0v 699.755n 0.0v 704.745n 0.0v 704.755n 0.0v 709.745n 0.0v 709.755n 0.0v 714.745n 0.0v 714.755n 0.0v 719.745n 0.0v 719.755n 0.0v 724.745n 0.0v 724.755n 0.0v 729.745n 0.0v 729.755n 0.0v 734.745n 0.0v 734.755n 0.0v 739.745n 0.0v 739.755n 0.0v 744.745n 0.0v 744.755n 0.0v 749.745n 0.0v 749.755n 0.0v 754.745n 0.0v 754.755n 0.0v 759.745n 0.0v 759.755n 0.0v 764.745n 0.0v 764.755n 0.0v 769.745n 0.0v 769.755n 0.0v 774.745n 0.0v 774.755n 0.0v 779.745n 0.0v 779.755n 0.0v 784.745n 0.0v 784.755n 0.0v 789.745n 0.0v 789.755n 0.95v 794.745n 0.95v 794.755n 0.95v 799.745n 0.95v 799.755n 0.95v 804.745n 0.95v 804.755n 0.95v 809.745n 0.95v 809.755n 0.95v 814.745n 0.95v 814.755n 0.95v 819.745n 0.95v 819.755n 0.95v 824.745n 0.95v 824.755n 0.95v 829.745n 0.95v 829.755n 0.95v 834.745n 0.95v 834.755n 0.95v 839.745n 0.95v 839.755n 0.95v 844.745n 0.95v 844.755n 0.95v 849.745n 0.95v 849.755n 0.95v 854.745n 0.95v 854.755n 0.95v 859.745n 0.95v 859.755n 0.95v 864.745n 0.95v 864.755n 0.95v 869.745n 0.95v 869.755n 0.95v 874.745n 0.95v 874.755n 0.0v 879.745n 0.0v 879.755n 0.0v 884.745n 0.0v 884.755n 0.0v 889.745n 0.0v 889.755n 0.0v 894.745n 0.0v 894.755n 0.0v 899.745n 0.0v 899.755n 0.95v 904.745n 0.95v 904.755n 0.95v 909.745n 0.95v 909.755n 0.95v 914.745n 0.95v 914.755n 0.95v 919.745n 0.95v 919.755n 0.95v 924.745n 0.95v 924.755n 0.95v 929.745n 0.95v 929.755n 0.95v 934.745n 0.95v 934.755n 0.0v 939.745n 0.0v 939.755n 0.95v 944.745n 0.95v 944.755n 0.95v 949.745n 0.95v 949.755n 0.95v 954.745n 0.95v 954.755n 0.95v 959.745n 0.95v 959.755n 0.95v 964.745n 0.95v 964.755n 0.95v 969.745n 0.95v 969.755n 0.0v 974.745n 0.0v 974.755n 0.0v 979.745n 0.0v 979.755n 0.0v 984.745n 0.0v 984.755n 0.0v 989.745n 0.0v 989.755n 0.0v 994.745n 0.0v 994.755n 0.0v 999.745n 0.0v 999.755n 0.0v 1004.745n 0.0v 1004.755n 0.0v 1009.745n 0.0v 1009.755n 0.0v 1014.745n 0.0v 1014.755n 0.0v 1019.745n 0.0v 1019.755n 0.0v 1024.745n 0.0v 1024.755n 0.0v )
* (time, data): [(0, 0), (5, 0), (10, 0), (15, 1), (20, 1), (25, 1), (30, 1), (35, 1), (40, 1), (45, 1), (50, 1), (55, 1), (60, 1), (65, 1), (70, 1), (75, 0), (80, 0), (85, 0), (90, 0), (95, 1), (100, 1), (105, 1), (110, 1), (115, 0), (120, 0), (125, 0), (130, 0), (135, 0), (140, 0), (145, 0), (150, 0), (155, 0), (160, 1), (165, 0), (170, 0), (175, 0), (180, 0), (185, 0), (190, 0), (195, 0), (200, 0), (205, 0), (210, 0), (215, 0), (220, 0), (225, 0), (230, 0), (235, 0), (240, 0), (245, 0), (250, 0), (255, 0), (260, 0), (265, 0), (270, 0), (275, 0), (280, 0), (285, 0), (290, 0), (295, 0), (300, 0), (305, 0), (310, 0), (315, 0), (320, 1), (325, 1), (330, 0), (335, 0), (340, 0), (345, 0), (350, 0), (355, 0), (360, 0), (365, 0), (370, 0), (375, 0), (380, 0), (385, 0), (390, 0), (395, 0), (400, 0), (405, 0), (410, 0), (415, 0), (420, 0), (425, 1), (430, 1), (435, 1), (440, 1), (445, 1), (450, 1), (455, 1), (460, 1), (465, 1), (470, 1), (475, 1), (480, 1), (485, 1), (490, 1), (495, 1), (500, 1), (505, 1), (510, 0), (515, 0), (520, 0), (525, 1), (530, 0), (535, 0), (540, 0), (545, 0), (550, 0), (555, 0), (560, 0), (565, 0), (570, 0), (575, 0), (580, 0), (585, 0), (590, 0), (595, 0), (600, 1), (605, 1), (610, 1), (615, 1), (620, 1), (625, 1), (630, 1), (635, 1), (640, 1), (645, 1), (650, 1), (655, 0), (660, 0), (665, 0), (670, 0), (675, 0), (680, 0), (685, 1), (690, 1), (695, 1), (700, 1), (705, 1), (710, 1), (715, 1), (720, 0), (725, 0), (730, 0), (735, 0), (740, 0), (745, 0), (750, 0), (755, 0), (760, 0), (765, 0), (770, 1), (775, 1), (780, 1), (785, 1), (790, 0), (795, 0), (800, 0), (805, 0), (810, 0), (815, 0), (820, 1), (825, 1), (830, 1), (835, 1), (840, 1), (845, 1), (850, 1), (855, 1), (860, 0), (865, 0), (870, 0), (875, 1), (880, 1), (885, 1), (890, 1), (895, 1), (900, 1), (905, 1), (910, 1), (915, 1), (920, 1), (925, 1), (930, 1), (935, 0), (940, 1), (945, 1), (950, 1), (955, 1), (960, 1), (965, 1), (970, 1), (975, 1), (980, 1), (985, 1), (990, 1), (995, 1), (1000, 0), (1005, 0), (1010, 0), (1015, 0), (1020, 0), (1025, 0)]
Vdin0_18  din0_18  0 PWL (0n 0.0v 4.745n 0.0v 4.755n 0.0v 9.745n 0.0v 9.755n 0.0v 14.745n 0.0v 14.755n 0.95v 19.745n 0.95v 19.755n 0.95v 24.745n 0.95v 24.755n 0.95v 29.745n 0.95v 29.755n 0.95v 34.745n 0.95v 34.755n 0.95v 39.745n 0.95v 39.755n 0.95v 44.745n 0.95v 44.755n 0.95v 49.745n 0.95v 49.755n 0.95v 54.745n 0.95v 54.755n 0.95v 59.745n 0.95v 59.755n 0.95v 64.745n 0.95v 64.755n 0.95v 69.745n 0.95v 69.755n 0.95v 74.745n 0.95v 74.755n 0.0v 79.745n 0.0v 79.755n 0.0v 84.745n 0.0v 84.755n 0.0v 89.745n 0.0v 89.755n 0.0v 94.745n 0.0v 94.755n 0.95v 99.745n 0.95v 99.755n 0.95v 104.745n 0.95v 104.755n 0.95v 109.745n 0.95v 109.755n 0.95v 114.745n 0.95v 114.755n 0.0v 119.745n 0.0v 119.755n 0.0v 124.745n 0.0v 124.755n 0.0v 129.745n 0.0v 129.755n 0.0v 134.745n 0.0v 134.755n 0.0v 139.745n 0.0v 139.755n 0.0v 144.745n 0.0v 144.755n 0.0v 149.745n 0.0v 149.755n 0.0v 154.745n 0.0v 154.755n 0.0v 159.745n 0.0v 159.755n 0.95v 164.745n 0.95v 164.755n 0.0v 169.745n 0.0v 169.755n 0.0v 174.745n 0.0v 174.755n 0.0v 179.745n 0.0v 179.755n 0.0v 184.745n 0.0v 184.755n 0.0v 189.745n 0.0v 189.755n 0.0v 194.745n 0.0v 194.755n 0.0v 199.745n 0.0v 199.755n 0.0v 204.745n 0.0v 204.755n 0.0v 209.745n 0.0v 209.755n 0.0v 214.745n 0.0v 214.755n 0.0v 219.745n 0.0v 219.755n 0.0v 224.745n 0.0v 224.755n 0.0v 229.745n 0.0v 229.755n 0.0v 234.745n 0.0v 234.755n 0.0v 239.745n 0.0v 239.755n 0.0v 244.745n 0.0v 244.755n 0.0v 249.745n 0.0v 249.755n 0.0v 254.745n 0.0v 254.755n 0.0v 259.745n 0.0v 259.755n 0.0v 264.745n 0.0v 264.755n 0.0v 269.745n 0.0v 269.755n 0.0v 274.745n 0.0v 274.755n 0.0v 279.745n 0.0v 279.755n 0.0v 284.745n 0.0v 284.755n 0.0v 289.745n 0.0v 289.755n 0.0v 294.745n 0.0v 294.755n 0.0v 299.745n 0.0v 299.755n 0.0v 304.745n 0.0v 304.755n 0.0v 309.745n 0.0v 309.755n 0.0v 314.745n 0.0v 314.755n 0.0v 319.745n 0.0v 319.755n 0.95v 324.745n 0.95v 324.755n 0.95v 329.745n 0.95v 329.755n 0.0v 334.745n 0.0v 334.755n 0.0v 339.745n 0.0v 339.755n 0.0v 344.745n 0.0v 344.755n 0.0v 349.745n 0.0v 349.755n 0.0v 354.745n 0.0v 354.755n 0.0v 359.745n 0.0v 359.755n 0.0v 364.745n 0.0v 364.755n 0.0v 369.745n 0.0v 369.755n 0.0v 374.745n 0.0v 374.755n 0.0v 379.745n 0.0v 379.755n 0.0v 384.745n 0.0v 384.755n 0.0v 389.745n 0.0v 389.755n 0.0v 394.745n 0.0v 394.755n 0.0v 399.745n 0.0v 399.755n 0.0v 404.745n 0.0v 404.755n 0.0v 409.745n 0.0v 409.755n 0.0v 414.745n 0.0v 414.755n 0.0v 419.745n 0.0v 419.755n 0.0v 424.745n 0.0v 424.755n 0.95v 429.745n 0.95v 429.755n 0.95v 434.745n 0.95v 434.755n 0.95v 439.745n 0.95v 439.755n 0.95v 444.745n 0.95v 444.755n 0.95v 449.745n 0.95v 449.755n 0.95v 454.745n 0.95v 454.755n 0.95v 459.745n 0.95v 459.755n 0.95v 464.745n 0.95v 464.755n 0.95v 469.745n 0.95v 469.755n 0.95v 474.745n 0.95v 474.755n 0.95v 479.745n 0.95v 479.755n 0.95v 484.745n 0.95v 484.755n 0.95v 489.745n 0.95v 489.755n 0.95v 494.745n 0.95v 494.755n 0.95v 499.745n 0.95v 499.755n 0.95v 504.745n 0.95v 504.755n 0.95v 509.745n 0.95v 509.755n 0.0v 514.745n 0.0v 514.755n 0.0v 519.745n 0.0v 519.755n 0.0v 524.745n 0.0v 524.755n 0.95v 529.745n 0.95v 529.755n 0.0v 534.745n 0.0v 534.755n 0.0v 539.745n 0.0v 539.755n 0.0v 544.745n 0.0v 544.755n 0.0v 549.745n 0.0v 549.755n 0.0v 554.745n 0.0v 554.755n 0.0v 559.745n 0.0v 559.755n 0.0v 564.745n 0.0v 564.755n 0.0v 569.745n 0.0v 569.755n 0.0v 574.745n 0.0v 574.755n 0.0v 579.745n 0.0v 579.755n 0.0v 584.745n 0.0v 584.755n 0.0v 589.745n 0.0v 589.755n 0.0v 594.745n 0.0v 594.755n 0.0v 599.745n 0.0v 599.755n 0.95v 604.745n 0.95v 604.755n 0.95v 609.745n 0.95v 609.755n 0.95v 614.745n 0.95v 614.755n 0.95v 619.745n 0.95v 619.755n 0.95v 624.745n 0.95v 624.755n 0.95v 629.745n 0.95v 629.755n 0.95v 634.745n 0.95v 634.755n 0.95v 639.745n 0.95v 639.755n 0.95v 644.745n 0.95v 644.755n 0.95v 649.745n 0.95v 649.755n 0.95v 654.745n 0.95v 654.755n 0.0v 659.745n 0.0v 659.755n 0.0v 664.745n 0.0v 664.755n 0.0v 669.745n 0.0v 669.755n 0.0v 674.745n 0.0v 674.755n 0.0v 679.745n 0.0v 679.755n 0.0v 684.745n 0.0v 684.755n 0.95v 689.745n 0.95v 689.755n 0.95v 694.745n 0.95v 694.755n 0.95v 699.745n 0.95v 699.755n 0.95v 704.745n 0.95v 704.755n 0.95v 709.745n 0.95v 709.755n 0.95v 714.745n 0.95v 714.755n 0.95v 719.745n 0.95v 719.755n 0.0v 724.745n 0.0v 724.755n 0.0v 729.745n 0.0v 729.755n 0.0v 734.745n 0.0v 734.755n 0.0v 739.745n 0.0v 739.755n 0.0v 744.745n 0.0v 744.755n 0.0v 749.745n 0.0v 749.755n 0.0v 754.745n 0.0v 754.755n 0.0v 759.745n 0.0v 759.755n 0.0v 764.745n 0.0v 764.755n 0.0v 769.745n 0.0v 769.755n 0.95v 774.745n 0.95v 774.755n 0.95v 779.745n 0.95v 779.755n 0.95v 784.745n 0.95v 784.755n 0.95v 789.745n 0.95v 789.755n 0.0v 794.745n 0.0v 794.755n 0.0v 799.745n 0.0v 799.755n 0.0v 804.745n 0.0v 804.755n 0.0v 809.745n 0.0v 809.755n 0.0v 814.745n 0.0v 814.755n 0.0v 819.745n 0.0v 819.755n 0.95v 824.745n 0.95v 824.755n 0.95v 829.745n 0.95v 829.755n 0.95v 834.745n 0.95v 834.755n 0.95v 839.745n 0.95v 839.755n 0.95v 844.745n 0.95v 844.755n 0.95v 849.745n 0.95v 849.755n 0.95v 854.745n 0.95v 854.755n 0.95v 859.745n 0.95v 859.755n 0.0v 864.745n 0.0v 864.755n 0.0v 869.745n 0.0v 869.755n 0.0v 874.745n 0.0v 874.755n 0.95v 879.745n 0.95v 879.755n 0.95v 884.745n 0.95v 884.755n 0.95v 889.745n 0.95v 889.755n 0.95v 894.745n 0.95v 894.755n 0.95v 899.745n 0.95v 899.755n 0.95v 904.745n 0.95v 904.755n 0.95v 909.745n 0.95v 909.755n 0.95v 914.745n 0.95v 914.755n 0.95v 919.745n 0.95v 919.755n 0.95v 924.745n 0.95v 924.755n 0.95v 929.745n 0.95v 929.755n 0.95v 934.745n 0.95v 934.755n 0.0v 939.745n 0.0v 939.755n 0.95v 944.745n 0.95v 944.755n 0.95v 949.745n 0.95v 949.755n 0.95v 954.745n 0.95v 954.755n 0.95v 959.745n 0.95v 959.755n 0.95v 964.745n 0.95v 964.755n 0.95v 969.745n 0.95v 969.755n 0.95v 974.745n 0.95v 974.755n 0.95v 979.745n 0.95v 979.755n 0.95v 984.745n 0.95v 984.755n 0.95v 989.745n 0.95v 989.755n 0.95v 994.745n 0.95v 994.755n 0.95v 999.745n 0.95v 999.755n 0.0v 1004.745n 0.0v 1004.755n 0.0v 1009.745n 0.0v 1009.755n 0.0v 1014.745n 0.0v 1014.755n 0.0v 1019.745n 0.0v 1019.755n 0.0v 1024.745n 0.0v 1024.755n 0.0v )
* (time, data): [(0, 0), (5, 1), (10, 0), (15, 0), (20, 0), (25, 0), (30, 0), (35, 0), (40, 0), (45, 0), (50, 1), (55, 1), (60, 1), (65, 1), (70, 1), (75, 0), (80, 0), (85, 0), (90, 0), (95, 0), (100, 0), (105, 0), (110, 0), (115, 1), (120, 1), (125, 1), (130, 1), (135, 1), (140, 1), (145, 1), (150, 1), (155, 1), (160, 1), (165, 0), (170, 0), (175, 0), (180, 0), (185, 0), (190, 0), (195, 0), (200, 0), (205, 0), (210, 0), (215, 0), (220, 0), (225, 0), (230, 0), (235, 0), (240, 1), (245, 1), (250, 1), (255, 1), (260, 1), (265, 1), (270, 1), (275, 1), (280, 1), (285, 1), (290, 0), (295, 0), (300, 0), (305, 0), (310, 0), (315, 0), (320, 0), (325, 1), (330, 1), (335, 1), (340, 1), (345, 1), (350, 1), (355, 1), (360, 1), (365, 1), (370, 1), (375, 1), (380, 1), (385, 1), (390, 1), (395, 1), (400, 1), (405, 1), (410, 0), (415, 0), (420, 0), (425, 0), (430, 0), (435, 0), (440, 0), (445, 0), (450, 0), (455, 0), (460, 0), (465, 0), (470, 0), (475, 0), (480, 0), (485, 0), (490, 0), (495, 0), (500, 0), (505, 0), (510, 0), (515, 0), (520, 0), (525, 1), (530, 1), (535, 1), (540, 1), (545, 1), (550, 0), (555, 0), (560, 0), (565, 0), (570, 0), (575, 0), (580, 0), (585, 0), (590, 0), (595, 0), (600, 0), (605, 0), (610, 0), (615, 0), (620, 0), (625, 0), (630, 0), (635, 0), (640, 0), (645, 0), (650, 0), (655, 0), (660, 0), (665, 0), (670, 0), (675, 0), (680, 0), (685, 0), (690, 0), (695, 0), (700, 0), (705, 0), (710, 0), (715, 0), (720, 0), (725, 0), (730, 0), (735, 0), (740, 0), (745, 0), (750, 0), (755, 0), (760, 0), (765, 0), (770, 1), (775, 1), (780, 1), (785, 1), (790, 0), (795, 0), (800, 0), (805, 0), (810, 0), (815, 0), (820, 1), (825, 1), (830, 0), (835, 0), (840, 0), (845, 1), (850, 1), (855, 1), (860, 0), (865, 0), (870, 0), (875, 1), (880, 1), (885, 1), (890, 1), (895, 1), (900, 0), (905, 0), (910, 0), (915, 0), (920, 0), (925, 0), (930, 0), (935, 1), (940, 0), (945, 0), (950, 0), (955, 0), (960, 0), (965, 0), (970, 0), (975, 0), (980, 0), (985, 0), (990, 0), (995, 0), (1000, 1), (1005, 1), (1010, 1), (1015, 1), (1020, 1), (1025, 1)]
Vdin0_19  din0_19  0 PWL (0n 0.0v 4.745n 0.0v 4.755n 0.95v 9.745n 0.95v 9.755n 0.0v 14.745n 0.0v 14.755n 0.0v 19.745n 0.0v 19.755n 0.0v 24.745n 0.0v 24.755n 0.0v 29.745n 0.0v 29.755n 0.0v 34.745n 0.0v 34.755n 0.0v 39.745n 0.0v 39.755n 0.0v 44.745n 0.0v 44.755n 0.0v 49.745n 0.0v 49.755n 0.95v 54.745n 0.95v 54.755n 0.95v 59.745n 0.95v 59.755n 0.95v 64.745n 0.95v 64.755n 0.95v 69.745n 0.95v 69.755n 0.95v 74.745n 0.95v 74.755n 0.0v 79.745n 0.0v 79.755n 0.0v 84.745n 0.0v 84.755n 0.0v 89.745n 0.0v 89.755n 0.0v 94.745n 0.0v 94.755n 0.0v 99.745n 0.0v 99.755n 0.0v 104.745n 0.0v 104.755n 0.0v 109.745n 0.0v 109.755n 0.0v 114.745n 0.0v 114.755n 0.95v 119.745n 0.95v 119.755n 0.95v 124.745n 0.95v 124.755n 0.95v 129.745n 0.95v 129.755n 0.95v 134.745n 0.95v 134.755n 0.95v 139.745n 0.95v 139.755n 0.95v 144.745n 0.95v 144.755n 0.95v 149.745n 0.95v 149.755n 0.95v 154.745n 0.95v 154.755n 0.95v 159.745n 0.95v 159.755n 0.95v 164.745n 0.95v 164.755n 0.0v 169.745n 0.0v 169.755n 0.0v 174.745n 0.0v 174.755n 0.0v 179.745n 0.0v 179.755n 0.0v 184.745n 0.0v 184.755n 0.0v 189.745n 0.0v 189.755n 0.0v 194.745n 0.0v 194.755n 0.0v 199.745n 0.0v 199.755n 0.0v 204.745n 0.0v 204.755n 0.0v 209.745n 0.0v 209.755n 0.0v 214.745n 0.0v 214.755n 0.0v 219.745n 0.0v 219.755n 0.0v 224.745n 0.0v 224.755n 0.0v 229.745n 0.0v 229.755n 0.0v 234.745n 0.0v 234.755n 0.0v 239.745n 0.0v 239.755n 0.95v 244.745n 0.95v 244.755n 0.95v 249.745n 0.95v 249.755n 0.95v 254.745n 0.95v 254.755n 0.95v 259.745n 0.95v 259.755n 0.95v 264.745n 0.95v 264.755n 0.95v 269.745n 0.95v 269.755n 0.95v 274.745n 0.95v 274.755n 0.95v 279.745n 0.95v 279.755n 0.95v 284.745n 0.95v 284.755n 0.95v 289.745n 0.95v 289.755n 0.0v 294.745n 0.0v 294.755n 0.0v 299.745n 0.0v 299.755n 0.0v 304.745n 0.0v 304.755n 0.0v 309.745n 0.0v 309.755n 0.0v 314.745n 0.0v 314.755n 0.0v 319.745n 0.0v 319.755n 0.0v 324.745n 0.0v 324.755n 0.95v 329.745n 0.95v 329.755n 0.95v 334.745n 0.95v 334.755n 0.95v 339.745n 0.95v 339.755n 0.95v 344.745n 0.95v 344.755n 0.95v 349.745n 0.95v 349.755n 0.95v 354.745n 0.95v 354.755n 0.95v 359.745n 0.95v 359.755n 0.95v 364.745n 0.95v 364.755n 0.95v 369.745n 0.95v 369.755n 0.95v 374.745n 0.95v 374.755n 0.95v 379.745n 0.95v 379.755n 0.95v 384.745n 0.95v 384.755n 0.95v 389.745n 0.95v 389.755n 0.95v 394.745n 0.95v 394.755n 0.95v 399.745n 0.95v 399.755n 0.95v 404.745n 0.95v 404.755n 0.95v 409.745n 0.95v 409.755n 0.0v 414.745n 0.0v 414.755n 0.0v 419.745n 0.0v 419.755n 0.0v 424.745n 0.0v 424.755n 0.0v 429.745n 0.0v 429.755n 0.0v 434.745n 0.0v 434.755n 0.0v 439.745n 0.0v 439.755n 0.0v 444.745n 0.0v 444.755n 0.0v 449.745n 0.0v 449.755n 0.0v 454.745n 0.0v 454.755n 0.0v 459.745n 0.0v 459.755n 0.0v 464.745n 0.0v 464.755n 0.0v 469.745n 0.0v 469.755n 0.0v 474.745n 0.0v 474.755n 0.0v 479.745n 0.0v 479.755n 0.0v 484.745n 0.0v 484.755n 0.0v 489.745n 0.0v 489.755n 0.0v 494.745n 0.0v 494.755n 0.0v 499.745n 0.0v 499.755n 0.0v 504.745n 0.0v 504.755n 0.0v 509.745n 0.0v 509.755n 0.0v 514.745n 0.0v 514.755n 0.0v 519.745n 0.0v 519.755n 0.0v 524.745n 0.0v 524.755n 0.95v 529.745n 0.95v 529.755n 0.95v 534.745n 0.95v 534.755n 0.95v 539.745n 0.95v 539.755n 0.95v 544.745n 0.95v 544.755n 0.95v 549.745n 0.95v 549.755n 0.0v 554.745n 0.0v 554.755n 0.0v 559.745n 0.0v 559.755n 0.0v 564.745n 0.0v 564.755n 0.0v 569.745n 0.0v 569.755n 0.0v 574.745n 0.0v 574.755n 0.0v 579.745n 0.0v 579.755n 0.0v 584.745n 0.0v 584.755n 0.0v 589.745n 0.0v 589.755n 0.0v 594.745n 0.0v 594.755n 0.0v 599.745n 0.0v 599.755n 0.0v 604.745n 0.0v 604.755n 0.0v 609.745n 0.0v 609.755n 0.0v 614.745n 0.0v 614.755n 0.0v 619.745n 0.0v 619.755n 0.0v 624.745n 0.0v 624.755n 0.0v 629.745n 0.0v 629.755n 0.0v 634.745n 0.0v 634.755n 0.0v 639.745n 0.0v 639.755n 0.0v 644.745n 0.0v 644.755n 0.0v 649.745n 0.0v 649.755n 0.0v 654.745n 0.0v 654.755n 0.0v 659.745n 0.0v 659.755n 0.0v 664.745n 0.0v 664.755n 0.0v 669.745n 0.0v 669.755n 0.0v 674.745n 0.0v 674.755n 0.0v 679.745n 0.0v 679.755n 0.0v 684.745n 0.0v 684.755n 0.0v 689.745n 0.0v 689.755n 0.0v 694.745n 0.0v 694.755n 0.0v 699.745n 0.0v 699.755n 0.0v 704.745n 0.0v 704.755n 0.0v 709.745n 0.0v 709.755n 0.0v 714.745n 0.0v 714.755n 0.0v 719.745n 0.0v 719.755n 0.0v 724.745n 0.0v 724.755n 0.0v 729.745n 0.0v 729.755n 0.0v 734.745n 0.0v 734.755n 0.0v 739.745n 0.0v 739.755n 0.0v 744.745n 0.0v 744.755n 0.0v 749.745n 0.0v 749.755n 0.0v 754.745n 0.0v 754.755n 0.0v 759.745n 0.0v 759.755n 0.0v 764.745n 0.0v 764.755n 0.0v 769.745n 0.0v 769.755n 0.95v 774.745n 0.95v 774.755n 0.95v 779.745n 0.95v 779.755n 0.95v 784.745n 0.95v 784.755n 0.95v 789.745n 0.95v 789.755n 0.0v 794.745n 0.0v 794.755n 0.0v 799.745n 0.0v 799.755n 0.0v 804.745n 0.0v 804.755n 0.0v 809.745n 0.0v 809.755n 0.0v 814.745n 0.0v 814.755n 0.0v 819.745n 0.0v 819.755n 0.95v 824.745n 0.95v 824.755n 0.95v 829.745n 0.95v 829.755n 0.0v 834.745n 0.0v 834.755n 0.0v 839.745n 0.0v 839.755n 0.0v 844.745n 0.0v 844.755n 0.95v 849.745n 0.95v 849.755n 0.95v 854.745n 0.95v 854.755n 0.95v 859.745n 0.95v 859.755n 0.0v 864.745n 0.0v 864.755n 0.0v 869.745n 0.0v 869.755n 0.0v 874.745n 0.0v 874.755n 0.95v 879.745n 0.95v 879.755n 0.95v 884.745n 0.95v 884.755n 0.95v 889.745n 0.95v 889.755n 0.95v 894.745n 0.95v 894.755n 0.95v 899.745n 0.95v 899.755n 0.0v 904.745n 0.0v 904.755n 0.0v 909.745n 0.0v 909.755n 0.0v 914.745n 0.0v 914.755n 0.0v 919.745n 0.0v 919.755n 0.0v 924.745n 0.0v 924.755n 0.0v 929.745n 0.0v 929.755n 0.0v 934.745n 0.0v 934.755n 0.95v 939.745n 0.95v 939.755n 0.0v 944.745n 0.0v 944.755n 0.0v 949.745n 0.0v 949.755n 0.0v 954.745n 0.0v 954.755n 0.0v 959.745n 0.0v 959.755n 0.0v 964.745n 0.0v 964.755n 0.0v 969.745n 0.0v 969.755n 0.0v 974.745n 0.0v 974.755n 0.0v 979.745n 0.0v 979.755n 0.0v 984.745n 0.0v 984.755n 0.0v 989.745n 0.0v 989.755n 0.0v 994.745n 0.0v 994.755n 0.0v 999.745n 0.0v 999.755n 0.95v 1004.745n 0.95v 1004.755n 0.95v 1009.745n 0.95v 1009.755n 0.95v 1014.745n 0.95v 1014.755n 0.95v 1019.745n 0.95v 1019.755n 0.95v 1024.745n 0.95v 1024.755n 0.95v )
* (time, data): [(0, 0), (5, 0), (10, 0), (15, 0), (20, 0), (25, 0), (30, 0), (35, 0), (40, 0), (45, 0), (50, 1), (55, 1), (60, 1), (65, 1), (70, 1), (75, 0), (80, 0), (85, 0), (90, 0), (95, 1), (100, 1), (105, 1), (110, 1), (115, 0), (120, 0), (125, 0), (130, 0), (135, 0), (140, 0), (145, 0), (150, 1), (155, 1), (160, 1), (165, 1), (170, 1), (175, 1), (180, 1), (185, 1), (190, 0), (195, 0), (200, 0), (205, 0), (210, 0), (215, 0), (220, 0), (225, 0), (230, 0), (235, 0), (240, 1), (245, 1), (250, 1), (255, 1), (260, 1), (265, 0), (270, 0), (275, 0), (280, 0), (285, 0), (290, 1), (295, 1), (300, 1), (305, 1), (310, 1), (315, 1), (320, 1), (325, 0), (330, 0), (335, 0), (340, 0), (345, 0), (350, 0), (355, 0), (360, 0), (365, 0), (370, 0), (375, 0), (380, 0), (385, 0), (390, 0), (395, 0), (400, 0), (405, 0), (410, 0), (415, 0), (420, 0), (425, 1), (430, 1), (435, 1), (440, 1), (445, 1), (450, 1), (455, 1), (460, 1), (465, 1), (470, 1), (475, 1), (480, 1), (485, 1), (490, 1), (495, 1), (500, 1), (505, 1), (510, 0), (515, 0), (520, 0), (525, 0), (530, 1), (535, 1), (540, 1), (545, 1), (550, 0), (555, 0), (560, 0), (565, 0), (570, 0), (575, 0), (580, 0), (585, 0), (590, 1), (595, 1), (600, 0), (605, 0), (610, 0), (615, 1), (620, 1), (625, 1), (630, 1), (635, 1), (640, 1), (645, 1), (650, 1), (655, 0), (660, 0), (665, 0), (670, 0), (675, 0), (680, 0), (685, 0), (690, 0), (695, 0), (700, 0), (705, 0), (710, 0), (715, 0), (720, 0), (725, 0), (730, 0), (735, 0), (740, 0), (745, 0), (750, 0), (755, 0), (760, 0), (765, 0), (770, 0), (775, 0), (780, 0), (785, 0), (790, 0), (795, 0), (800, 0), (805, 0), (810, 0), (815, 0), (820, 1), (825, 1), (830, 0), (835, 0), (840, 0), (845, 1), (850, 1), (855, 1), (860, 1), (865, 1), (870, 1), (875, 0), (880, 0), (885, 0), (890, 0), (895, 0), (900, 1), (905, 0), (910, 0), (915, 0), (920, 0), (925, 0), (930, 0), (935, 0), (940, 0), (945, 0), (950, 0), (955, 0), (960, 0), (965, 0), (970, 0), (975, 0), (980, 0), (985, 0), (990, 0), (995, 0), (1000, 0), (1005, 0), (1010, 0), (1015, 0), (1020, 0), (1025, 0)]
Vdin0_20  din0_20  0 PWL (0n 0.0v 4.745n 0.0v 4.755n 0.0v 9.745n 0.0v 9.755n 0.0v 14.745n 0.0v 14.755n 0.0v 19.745n 0.0v 19.755n 0.0v 24.745n 0.0v 24.755n 0.0v 29.745n 0.0v 29.755n 0.0v 34.745n 0.0v 34.755n 0.0v 39.745n 0.0v 39.755n 0.0v 44.745n 0.0v 44.755n 0.0v 49.745n 0.0v 49.755n 0.95v 54.745n 0.95v 54.755n 0.95v 59.745n 0.95v 59.755n 0.95v 64.745n 0.95v 64.755n 0.95v 69.745n 0.95v 69.755n 0.95v 74.745n 0.95v 74.755n 0.0v 79.745n 0.0v 79.755n 0.0v 84.745n 0.0v 84.755n 0.0v 89.745n 0.0v 89.755n 0.0v 94.745n 0.0v 94.755n 0.95v 99.745n 0.95v 99.755n 0.95v 104.745n 0.95v 104.755n 0.95v 109.745n 0.95v 109.755n 0.95v 114.745n 0.95v 114.755n 0.0v 119.745n 0.0v 119.755n 0.0v 124.745n 0.0v 124.755n 0.0v 129.745n 0.0v 129.755n 0.0v 134.745n 0.0v 134.755n 0.0v 139.745n 0.0v 139.755n 0.0v 144.745n 0.0v 144.755n 0.0v 149.745n 0.0v 149.755n 0.95v 154.745n 0.95v 154.755n 0.95v 159.745n 0.95v 159.755n 0.95v 164.745n 0.95v 164.755n 0.95v 169.745n 0.95v 169.755n 0.95v 174.745n 0.95v 174.755n 0.95v 179.745n 0.95v 179.755n 0.95v 184.745n 0.95v 184.755n 0.95v 189.745n 0.95v 189.755n 0.0v 194.745n 0.0v 194.755n 0.0v 199.745n 0.0v 199.755n 0.0v 204.745n 0.0v 204.755n 0.0v 209.745n 0.0v 209.755n 0.0v 214.745n 0.0v 214.755n 0.0v 219.745n 0.0v 219.755n 0.0v 224.745n 0.0v 224.755n 0.0v 229.745n 0.0v 229.755n 0.0v 234.745n 0.0v 234.755n 0.0v 239.745n 0.0v 239.755n 0.95v 244.745n 0.95v 244.755n 0.95v 249.745n 0.95v 249.755n 0.95v 254.745n 0.95v 254.755n 0.95v 259.745n 0.95v 259.755n 0.95v 264.745n 0.95v 264.755n 0.0v 269.745n 0.0v 269.755n 0.0v 274.745n 0.0v 274.755n 0.0v 279.745n 0.0v 279.755n 0.0v 284.745n 0.0v 284.755n 0.0v 289.745n 0.0v 289.755n 0.95v 294.745n 0.95v 294.755n 0.95v 299.745n 0.95v 299.755n 0.95v 304.745n 0.95v 304.755n 0.95v 309.745n 0.95v 309.755n 0.95v 314.745n 0.95v 314.755n 0.95v 319.745n 0.95v 319.755n 0.95v 324.745n 0.95v 324.755n 0.0v 329.745n 0.0v 329.755n 0.0v 334.745n 0.0v 334.755n 0.0v 339.745n 0.0v 339.755n 0.0v 344.745n 0.0v 344.755n 0.0v 349.745n 0.0v 349.755n 0.0v 354.745n 0.0v 354.755n 0.0v 359.745n 0.0v 359.755n 0.0v 364.745n 0.0v 364.755n 0.0v 369.745n 0.0v 369.755n 0.0v 374.745n 0.0v 374.755n 0.0v 379.745n 0.0v 379.755n 0.0v 384.745n 0.0v 384.755n 0.0v 389.745n 0.0v 389.755n 0.0v 394.745n 0.0v 394.755n 0.0v 399.745n 0.0v 399.755n 0.0v 404.745n 0.0v 404.755n 0.0v 409.745n 0.0v 409.755n 0.0v 414.745n 0.0v 414.755n 0.0v 419.745n 0.0v 419.755n 0.0v 424.745n 0.0v 424.755n 0.95v 429.745n 0.95v 429.755n 0.95v 434.745n 0.95v 434.755n 0.95v 439.745n 0.95v 439.755n 0.95v 444.745n 0.95v 444.755n 0.95v 449.745n 0.95v 449.755n 0.95v 454.745n 0.95v 454.755n 0.95v 459.745n 0.95v 459.755n 0.95v 464.745n 0.95v 464.755n 0.95v 469.745n 0.95v 469.755n 0.95v 474.745n 0.95v 474.755n 0.95v 479.745n 0.95v 479.755n 0.95v 484.745n 0.95v 484.755n 0.95v 489.745n 0.95v 489.755n 0.95v 494.745n 0.95v 494.755n 0.95v 499.745n 0.95v 499.755n 0.95v 504.745n 0.95v 504.755n 0.95v 509.745n 0.95v 509.755n 0.0v 514.745n 0.0v 514.755n 0.0v 519.745n 0.0v 519.755n 0.0v 524.745n 0.0v 524.755n 0.0v 529.745n 0.0v 529.755n 0.95v 534.745n 0.95v 534.755n 0.95v 539.745n 0.95v 539.755n 0.95v 544.745n 0.95v 544.755n 0.95v 549.745n 0.95v 549.755n 0.0v 554.745n 0.0v 554.755n 0.0v 559.745n 0.0v 559.755n 0.0v 564.745n 0.0v 564.755n 0.0v 569.745n 0.0v 569.755n 0.0v 574.745n 0.0v 574.755n 0.0v 579.745n 0.0v 579.755n 0.0v 584.745n 0.0v 584.755n 0.0v 589.745n 0.0v 589.755n 0.95v 594.745n 0.95v 594.755n 0.95v 599.745n 0.95v 599.755n 0.0v 604.745n 0.0v 604.755n 0.0v 609.745n 0.0v 609.755n 0.0v 614.745n 0.0v 614.755n 0.95v 619.745n 0.95v 619.755n 0.95v 624.745n 0.95v 624.755n 0.95v 629.745n 0.95v 629.755n 0.95v 634.745n 0.95v 634.755n 0.95v 639.745n 0.95v 639.755n 0.95v 644.745n 0.95v 644.755n 0.95v 649.745n 0.95v 649.755n 0.95v 654.745n 0.95v 654.755n 0.0v 659.745n 0.0v 659.755n 0.0v 664.745n 0.0v 664.755n 0.0v 669.745n 0.0v 669.755n 0.0v 674.745n 0.0v 674.755n 0.0v 679.745n 0.0v 679.755n 0.0v 684.745n 0.0v 684.755n 0.0v 689.745n 0.0v 689.755n 0.0v 694.745n 0.0v 694.755n 0.0v 699.745n 0.0v 699.755n 0.0v 704.745n 0.0v 704.755n 0.0v 709.745n 0.0v 709.755n 0.0v 714.745n 0.0v 714.755n 0.0v 719.745n 0.0v 719.755n 0.0v 724.745n 0.0v 724.755n 0.0v 729.745n 0.0v 729.755n 0.0v 734.745n 0.0v 734.755n 0.0v 739.745n 0.0v 739.755n 0.0v 744.745n 0.0v 744.755n 0.0v 749.745n 0.0v 749.755n 0.0v 754.745n 0.0v 754.755n 0.0v 759.745n 0.0v 759.755n 0.0v 764.745n 0.0v 764.755n 0.0v 769.745n 0.0v 769.755n 0.0v 774.745n 0.0v 774.755n 0.0v 779.745n 0.0v 779.755n 0.0v 784.745n 0.0v 784.755n 0.0v 789.745n 0.0v 789.755n 0.0v 794.745n 0.0v 794.755n 0.0v 799.745n 0.0v 799.755n 0.0v 804.745n 0.0v 804.755n 0.0v 809.745n 0.0v 809.755n 0.0v 814.745n 0.0v 814.755n 0.0v 819.745n 0.0v 819.755n 0.95v 824.745n 0.95v 824.755n 0.95v 829.745n 0.95v 829.755n 0.0v 834.745n 0.0v 834.755n 0.0v 839.745n 0.0v 839.755n 0.0v 844.745n 0.0v 844.755n 0.95v 849.745n 0.95v 849.755n 0.95v 854.745n 0.95v 854.755n 0.95v 859.745n 0.95v 859.755n 0.95v 864.745n 0.95v 864.755n 0.95v 869.745n 0.95v 869.755n 0.95v 874.745n 0.95v 874.755n 0.0v 879.745n 0.0v 879.755n 0.0v 884.745n 0.0v 884.755n 0.0v 889.745n 0.0v 889.755n 0.0v 894.745n 0.0v 894.755n 0.0v 899.745n 0.0v 899.755n 0.95v 904.745n 0.95v 904.755n 0.0v 909.745n 0.0v 909.755n 0.0v 914.745n 0.0v 914.755n 0.0v 919.745n 0.0v 919.755n 0.0v 924.745n 0.0v 924.755n 0.0v 929.745n 0.0v 929.755n 0.0v 934.745n 0.0v 934.755n 0.0v 939.745n 0.0v 939.755n 0.0v 944.745n 0.0v 944.755n 0.0v 949.745n 0.0v 949.755n 0.0v 954.745n 0.0v 954.755n 0.0v 959.745n 0.0v 959.755n 0.0v 964.745n 0.0v 964.755n 0.0v 969.745n 0.0v 969.755n 0.0v 974.745n 0.0v 974.755n 0.0v 979.745n 0.0v 979.755n 0.0v 984.745n 0.0v 984.755n 0.0v 989.745n 0.0v 989.755n 0.0v 994.745n 0.0v 994.755n 0.0v 999.745n 0.0v 999.755n 0.0v 1004.745n 0.0v 1004.755n 0.0v 1009.745n 0.0v 1009.755n 0.0v 1014.745n 0.0v 1014.755n 0.0v 1019.745n 0.0v 1019.755n 0.0v 1024.745n 0.0v 1024.755n 0.0v )
* (time, data): [(0, 0), (5, 1), (10, 0), (15, 0), (20, 0), (25, 0), (30, 0), (35, 0), (40, 0), (45, 0), (50, 1), (55, 1), (60, 1), (65, 1), (70, 1), (75, 0), (80, 0), (85, 0), (90, 0), (95, 1), (100, 1), (105, 1), (110, 1), (115, 0), (120, 0), (125, 0), (130, 0), (135, 0), (140, 0), (145, 0), (150, 0), (155, 0), (160, 1), (165, 1), (170, 1), (175, 1), (180, 1), (185, 1), (190, 1), (195, 1), (200, 1), (205, 1), (210, 1), (215, 1), (220, 1), (225, 1), (230, 1), (235, 1), (240, 1), (245, 1), (250, 1), (255, 1), (260, 1), (265, 1), (270, 1), (275, 1), (280, 1), (285, 1), (290, 1), (295, 1), (300, 1), (305, 1), (310, 1), (315, 1), (320, 0), (325, 0), (330, 0), (335, 0), (340, 0), (345, 0), (350, 0), (355, 0), (360, 0), (365, 0), (370, 0), (375, 0), (380, 0), (385, 0), (390, 0), (395, 0), (400, 0), (405, 0), (410, 1), (415, 1), (420, 1), (425, 1), (430, 1), (435, 1), (440, 1), (445, 1), (450, 1), (455, 1), (460, 1), (465, 1), (470, 1), (475, 1), (480, 1), (485, 1), (490, 1), (495, 1), (500, 1), (505, 1), (510, 0), (515, 0), (520, 0), (525, 1), (530, 1), (535, 1), (540, 1), (545, 1), (550, 1), (555, 1), (560, 1), (565, 1), (570, 1), (575, 1), (580, 1), (585, 1), (590, 1), (595, 1), (600, 1), (605, 1), (610, 1), (615, 1), (620, 1), (625, 1), (630, 1), (635, 1), (640, 1), (645, 1), (650, 1), (655, 1), (660, 1), (665, 1), (670, 1), (675, 1), (680, 1), (685, 1), (690, 1), (695, 1), (700, 1), (705, 1), (710, 1), (715, 1), (720, 1), (725, 1), (730, 1), (735, 1), (740, 1), (745, 1), (750, 1), (755, 1), (760, 1), (765, 1), (770, 1), (775, 1), (780, 1), (785, 1), (790, 1), (795, 1), (800, 1), (805, 1), (810, 1), (815, 1), (820, 1), (825, 1), (830, 0), (835, 0), (840, 0), (845, 1), (850, 1), (855, 1), (860, 0), (865, 0), (870, 0), (875, 0), (880, 0), (885, 0), (890, 0), (895, 0), (900, 1), (905, 1), (910, 1), (915, 1), (920, 1), (925, 1), (930, 1), (935, 1), (940, 0), (945, 0), (950, 0), (955, 0), (960, 0), (965, 0), (970, 0), (975, 0), (980, 0), (985, 0), (990, 0), (995, 0), (1000, 0), (1005, 0), (1010, 0), (1015, 0), (1020, 0), (1025, 0)]
Vdin0_21  din0_21  0 PWL (0n 0.0v 4.745n 0.0v 4.755n 0.95v 9.745n 0.95v 9.755n 0.0v 14.745n 0.0v 14.755n 0.0v 19.745n 0.0v 19.755n 0.0v 24.745n 0.0v 24.755n 0.0v 29.745n 0.0v 29.755n 0.0v 34.745n 0.0v 34.755n 0.0v 39.745n 0.0v 39.755n 0.0v 44.745n 0.0v 44.755n 0.0v 49.745n 0.0v 49.755n 0.95v 54.745n 0.95v 54.755n 0.95v 59.745n 0.95v 59.755n 0.95v 64.745n 0.95v 64.755n 0.95v 69.745n 0.95v 69.755n 0.95v 74.745n 0.95v 74.755n 0.0v 79.745n 0.0v 79.755n 0.0v 84.745n 0.0v 84.755n 0.0v 89.745n 0.0v 89.755n 0.0v 94.745n 0.0v 94.755n 0.95v 99.745n 0.95v 99.755n 0.95v 104.745n 0.95v 104.755n 0.95v 109.745n 0.95v 109.755n 0.95v 114.745n 0.95v 114.755n 0.0v 119.745n 0.0v 119.755n 0.0v 124.745n 0.0v 124.755n 0.0v 129.745n 0.0v 129.755n 0.0v 134.745n 0.0v 134.755n 0.0v 139.745n 0.0v 139.755n 0.0v 144.745n 0.0v 144.755n 0.0v 149.745n 0.0v 149.755n 0.0v 154.745n 0.0v 154.755n 0.0v 159.745n 0.0v 159.755n 0.95v 164.745n 0.95v 164.755n 0.95v 169.745n 0.95v 169.755n 0.95v 174.745n 0.95v 174.755n 0.95v 179.745n 0.95v 179.755n 0.95v 184.745n 0.95v 184.755n 0.95v 189.745n 0.95v 189.755n 0.95v 194.745n 0.95v 194.755n 0.95v 199.745n 0.95v 199.755n 0.95v 204.745n 0.95v 204.755n 0.95v 209.745n 0.95v 209.755n 0.95v 214.745n 0.95v 214.755n 0.95v 219.745n 0.95v 219.755n 0.95v 224.745n 0.95v 224.755n 0.95v 229.745n 0.95v 229.755n 0.95v 234.745n 0.95v 234.755n 0.95v 239.745n 0.95v 239.755n 0.95v 244.745n 0.95v 244.755n 0.95v 249.745n 0.95v 249.755n 0.95v 254.745n 0.95v 254.755n 0.95v 259.745n 0.95v 259.755n 0.95v 264.745n 0.95v 264.755n 0.95v 269.745n 0.95v 269.755n 0.95v 274.745n 0.95v 274.755n 0.95v 279.745n 0.95v 279.755n 0.95v 284.745n 0.95v 284.755n 0.95v 289.745n 0.95v 289.755n 0.95v 294.745n 0.95v 294.755n 0.95v 299.745n 0.95v 299.755n 0.95v 304.745n 0.95v 304.755n 0.95v 309.745n 0.95v 309.755n 0.95v 314.745n 0.95v 314.755n 0.95v 319.745n 0.95v 319.755n 0.0v 324.745n 0.0v 324.755n 0.0v 329.745n 0.0v 329.755n 0.0v 334.745n 0.0v 334.755n 0.0v 339.745n 0.0v 339.755n 0.0v 344.745n 0.0v 344.755n 0.0v 349.745n 0.0v 349.755n 0.0v 354.745n 0.0v 354.755n 0.0v 359.745n 0.0v 359.755n 0.0v 364.745n 0.0v 364.755n 0.0v 369.745n 0.0v 369.755n 0.0v 374.745n 0.0v 374.755n 0.0v 379.745n 0.0v 379.755n 0.0v 384.745n 0.0v 384.755n 0.0v 389.745n 0.0v 389.755n 0.0v 394.745n 0.0v 394.755n 0.0v 399.745n 0.0v 399.755n 0.0v 404.745n 0.0v 404.755n 0.0v 409.745n 0.0v 409.755n 0.95v 414.745n 0.95v 414.755n 0.95v 419.745n 0.95v 419.755n 0.95v 424.745n 0.95v 424.755n 0.95v 429.745n 0.95v 429.755n 0.95v 434.745n 0.95v 434.755n 0.95v 439.745n 0.95v 439.755n 0.95v 444.745n 0.95v 444.755n 0.95v 449.745n 0.95v 449.755n 0.95v 454.745n 0.95v 454.755n 0.95v 459.745n 0.95v 459.755n 0.95v 464.745n 0.95v 464.755n 0.95v 469.745n 0.95v 469.755n 0.95v 474.745n 0.95v 474.755n 0.95v 479.745n 0.95v 479.755n 0.95v 484.745n 0.95v 484.755n 0.95v 489.745n 0.95v 489.755n 0.95v 494.745n 0.95v 494.755n 0.95v 499.745n 0.95v 499.755n 0.95v 504.745n 0.95v 504.755n 0.95v 509.745n 0.95v 509.755n 0.0v 514.745n 0.0v 514.755n 0.0v 519.745n 0.0v 519.755n 0.0v 524.745n 0.0v 524.755n 0.95v 529.745n 0.95v 529.755n 0.95v 534.745n 0.95v 534.755n 0.95v 539.745n 0.95v 539.755n 0.95v 544.745n 0.95v 544.755n 0.95v 549.745n 0.95v 549.755n 0.95v 554.745n 0.95v 554.755n 0.95v 559.745n 0.95v 559.755n 0.95v 564.745n 0.95v 564.755n 0.95v 569.745n 0.95v 569.755n 0.95v 574.745n 0.95v 574.755n 0.95v 579.745n 0.95v 579.755n 0.95v 584.745n 0.95v 584.755n 0.95v 589.745n 0.95v 589.755n 0.95v 594.745n 0.95v 594.755n 0.95v 599.745n 0.95v 599.755n 0.95v 604.745n 0.95v 604.755n 0.95v 609.745n 0.95v 609.755n 0.95v 614.745n 0.95v 614.755n 0.95v 619.745n 0.95v 619.755n 0.95v 624.745n 0.95v 624.755n 0.95v 629.745n 0.95v 629.755n 0.95v 634.745n 0.95v 634.755n 0.95v 639.745n 0.95v 639.755n 0.95v 644.745n 0.95v 644.755n 0.95v 649.745n 0.95v 649.755n 0.95v 654.745n 0.95v 654.755n 0.95v 659.745n 0.95v 659.755n 0.95v 664.745n 0.95v 664.755n 0.95v 669.745n 0.95v 669.755n 0.95v 674.745n 0.95v 674.755n 0.95v 679.745n 0.95v 679.755n 0.95v 684.745n 0.95v 684.755n 0.95v 689.745n 0.95v 689.755n 0.95v 694.745n 0.95v 694.755n 0.95v 699.745n 0.95v 699.755n 0.95v 704.745n 0.95v 704.755n 0.95v 709.745n 0.95v 709.755n 0.95v 714.745n 0.95v 714.755n 0.95v 719.745n 0.95v 719.755n 0.95v 724.745n 0.95v 724.755n 0.95v 729.745n 0.95v 729.755n 0.95v 734.745n 0.95v 734.755n 0.95v 739.745n 0.95v 739.755n 0.95v 744.745n 0.95v 744.755n 0.95v 749.745n 0.95v 749.755n 0.95v 754.745n 0.95v 754.755n 0.95v 759.745n 0.95v 759.755n 0.95v 764.745n 0.95v 764.755n 0.95v 769.745n 0.95v 769.755n 0.95v 774.745n 0.95v 774.755n 0.95v 779.745n 0.95v 779.755n 0.95v 784.745n 0.95v 784.755n 0.95v 789.745n 0.95v 789.755n 0.95v 794.745n 0.95v 794.755n 0.95v 799.745n 0.95v 799.755n 0.95v 804.745n 0.95v 804.755n 0.95v 809.745n 0.95v 809.755n 0.95v 814.745n 0.95v 814.755n 0.95v 819.745n 0.95v 819.755n 0.95v 824.745n 0.95v 824.755n 0.95v 829.745n 0.95v 829.755n 0.0v 834.745n 0.0v 834.755n 0.0v 839.745n 0.0v 839.755n 0.0v 844.745n 0.0v 844.755n 0.95v 849.745n 0.95v 849.755n 0.95v 854.745n 0.95v 854.755n 0.95v 859.745n 0.95v 859.755n 0.0v 864.745n 0.0v 864.755n 0.0v 869.745n 0.0v 869.755n 0.0v 874.745n 0.0v 874.755n 0.0v 879.745n 0.0v 879.755n 0.0v 884.745n 0.0v 884.755n 0.0v 889.745n 0.0v 889.755n 0.0v 894.745n 0.0v 894.755n 0.0v 899.745n 0.0v 899.755n 0.95v 904.745n 0.95v 904.755n 0.95v 909.745n 0.95v 909.755n 0.95v 914.745n 0.95v 914.755n 0.95v 919.745n 0.95v 919.755n 0.95v 924.745n 0.95v 924.755n 0.95v 929.745n 0.95v 929.755n 0.95v 934.745n 0.95v 934.755n 0.95v 939.745n 0.95v 939.755n 0.0v 944.745n 0.0v 944.755n 0.0v 949.745n 0.0v 949.755n 0.0v 954.745n 0.0v 954.755n 0.0v 959.745n 0.0v 959.755n 0.0v 964.745n 0.0v 964.755n 0.0v 969.745n 0.0v 969.755n 0.0v 974.745n 0.0v 974.755n 0.0v 979.745n 0.0v 979.755n 0.0v 984.745n 0.0v 984.755n 0.0v 989.745n 0.0v 989.755n 0.0v 994.745n 0.0v 994.755n 0.0v 999.745n 0.0v 999.755n 0.0v 1004.745n 0.0v 1004.755n 0.0v 1009.745n 0.0v 1009.755n 0.0v 1014.745n 0.0v 1014.755n 0.0v 1019.745n 0.0v 1019.755n 0.0v 1024.745n 0.0v 1024.755n 0.0v )
* (time, data): [(0, 0), (5, 0), (10, 1), (15, 0), (20, 0), (25, 0), (30, 0), (35, 0), (40, 0), (45, 0), (50, 0), (55, 0), (60, 0), (65, 0), (70, 0), (75, 0), (80, 0), (85, 0), (90, 0), (95, 0), (100, 0), (105, 0), (110, 0), (115, 1), (120, 1), (125, 1), (130, 1), (135, 1), (140, 1), (145, 1), (150, 0), (155, 0), (160, 1), (165, 0), (170, 0), (175, 0), (180, 0), (185, 0), (190, 0), (195, 0), (200, 0), (205, 0), (210, 0), (215, 0), (220, 0), (225, 0), (230, 0), (235, 0), (240, 1), (245, 1), (250, 1), (255, 1), (260, 1), (265, 0), (270, 0), (275, 0), (280, 0), (285, 0), (290, 0), (295, 0), (300, 0), (305, 0), (310, 0), (315, 0), (320, 0), (325, 0), (330, 0), (335, 0), (340, 0), (345, 0), (350, 0), (355, 0), (360, 0), (365, 0), (370, 0), (375, 0), (380, 0), (385, 0), (390, 0), (395, 0), (400, 0), (405, 0), (410, 1), (415, 1), (420, 1), (425, 1), (430, 1), (435, 1), (440, 1), (445, 1), (450, 1), (455, 1), (460, 1), (465, 1), (470, 1), (475, 1), (480, 1), (485, 1), (490, 1), (495, 1), (500, 1), (505, 1), (510, 1), (515, 1), (520, 1), (525, 1), (530, 1), (535, 1), (540, 1), (545, 1), (550, 0), (555, 0), (560, 0), (565, 0), (570, 0), (575, 0), (580, 0), (585, 0), (590, 1), (595, 1), (600, 1), (605, 1), (610, 1), (615, 0), (620, 0), (625, 0), (630, 0), (635, 0), (640, 0), (645, 0), (650, 0), (655, 0), (660, 0), (665, 0), (670, 0), (675, 0), (680, 0), (685, 0), (690, 0), (695, 0), (700, 0), (705, 0), (710, 0), (715, 0), (720, 1), (725, 1), (730, 1), (735, 1), (740, 1), (745, 1), (750, 1), (755, 1), (760, 1), (765, 1), (770, 0), (775, 0), (780, 0), (785, 0), (790, 0), (795, 0), (800, 0), (805, 0), (810, 0), (815, 0), (820, 0), (825, 0), (830, 0), (835, 0), (840, 0), (845, 1), (850, 1), (855, 1), (860, 0), (865, 0), (870, 0), (875, 1), (880, 1), (885, 1), (890, 1), (895, 1), (900, 1), (905, 0), (910, 0), (915, 0), (920, 0), (925, 0), (930, 0), (935, 1), (940, 0), (945, 0), (950, 0), (955, 0), (960, 0), (965, 0), (970, 1), (975, 1), (980, 1), (985, 1), (990, 1), (995, 1), (1000, 0), (1005, 0), (1010, 0), (1015, 0), (1020, 0), (1025, 0)]
Vdin0_22  din0_22  0 PWL (0n 0.0v 4.745n 0.0v 4.755n 0.0v 9.745n 0.0v 9.755n 0.95v 14.745n 0.95v 14.755n 0.0v 19.745n 0.0v 19.755n 0.0v 24.745n 0.0v 24.755n 0.0v 29.745n 0.0v 29.755n 0.0v 34.745n 0.0v 34.755n 0.0v 39.745n 0.0v 39.755n 0.0v 44.745n 0.0v 44.755n 0.0v 49.745n 0.0v 49.755n 0.0v 54.745n 0.0v 54.755n 0.0v 59.745n 0.0v 59.755n 0.0v 64.745n 0.0v 64.755n 0.0v 69.745n 0.0v 69.755n 0.0v 74.745n 0.0v 74.755n 0.0v 79.745n 0.0v 79.755n 0.0v 84.745n 0.0v 84.755n 0.0v 89.745n 0.0v 89.755n 0.0v 94.745n 0.0v 94.755n 0.0v 99.745n 0.0v 99.755n 0.0v 104.745n 0.0v 104.755n 0.0v 109.745n 0.0v 109.755n 0.0v 114.745n 0.0v 114.755n 0.95v 119.745n 0.95v 119.755n 0.95v 124.745n 0.95v 124.755n 0.95v 129.745n 0.95v 129.755n 0.95v 134.745n 0.95v 134.755n 0.95v 139.745n 0.95v 139.755n 0.95v 144.745n 0.95v 144.755n 0.95v 149.745n 0.95v 149.755n 0.0v 154.745n 0.0v 154.755n 0.0v 159.745n 0.0v 159.755n 0.95v 164.745n 0.95v 164.755n 0.0v 169.745n 0.0v 169.755n 0.0v 174.745n 0.0v 174.755n 0.0v 179.745n 0.0v 179.755n 0.0v 184.745n 0.0v 184.755n 0.0v 189.745n 0.0v 189.755n 0.0v 194.745n 0.0v 194.755n 0.0v 199.745n 0.0v 199.755n 0.0v 204.745n 0.0v 204.755n 0.0v 209.745n 0.0v 209.755n 0.0v 214.745n 0.0v 214.755n 0.0v 219.745n 0.0v 219.755n 0.0v 224.745n 0.0v 224.755n 0.0v 229.745n 0.0v 229.755n 0.0v 234.745n 0.0v 234.755n 0.0v 239.745n 0.0v 239.755n 0.95v 244.745n 0.95v 244.755n 0.95v 249.745n 0.95v 249.755n 0.95v 254.745n 0.95v 254.755n 0.95v 259.745n 0.95v 259.755n 0.95v 264.745n 0.95v 264.755n 0.0v 269.745n 0.0v 269.755n 0.0v 274.745n 0.0v 274.755n 0.0v 279.745n 0.0v 279.755n 0.0v 284.745n 0.0v 284.755n 0.0v 289.745n 0.0v 289.755n 0.0v 294.745n 0.0v 294.755n 0.0v 299.745n 0.0v 299.755n 0.0v 304.745n 0.0v 304.755n 0.0v 309.745n 0.0v 309.755n 0.0v 314.745n 0.0v 314.755n 0.0v 319.745n 0.0v 319.755n 0.0v 324.745n 0.0v 324.755n 0.0v 329.745n 0.0v 329.755n 0.0v 334.745n 0.0v 334.755n 0.0v 339.745n 0.0v 339.755n 0.0v 344.745n 0.0v 344.755n 0.0v 349.745n 0.0v 349.755n 0.0v 354.745n 0.0v 354.755n 0.0v 359.745n 0.0v 359.755n 0.0v 364.745n 0.0v 364.755n 0.0v 369.745n 0.0v 369.755n 0.0v 374.745n 0.0v 374.755n 0.0v 379.745n 0.0v 379.755n 0.0v 384.745n 0.0v 384.755n 0.0v 389.745n 0.0v 389.755n 0.0v 394.745n 0.0v 394.755n 0.0v 399.745n 0.0v 399.755n 0.0v 404.745n 0.0v 404.755n 0.0v 409.745n 0.0v 409.755n 0.95v 414.745n 0.95v 414.755n 0.95v 419.745n 0.95v 419.755n 0.95v 424.745n 0.95v 424.755n 0.95v 429.745n 0.95v 429.755n 0.95v 434.745n 0.95v 434.755n 0.95v 439.745n 0.95v 439.755n 0.95v 444.745n 0.95v 444.755n 0.95v 449.745n 0.95v 449.755n 0.95v 454.745n 0.95v 454.755n 0.95v 459.745n 0.95v 459.755n 0.95v 464.745n 0.95v 464.755n 0.95v 469.745n 0.95v 469.755n 0.95v 474.745n 0.95v 474.755n 0.95v 479.745n 0.95v 479.755n 0.95v 484.745n 0.95v 484.755n 0.95v 489.745n 0.95v 489.755n 0.95v 494.745n 0.95v 494.755n 0.95v 499.745n 0.95v 499.755n 0.95v 504.745n 0.95v 504.755n 0.95v 509.745n 0.95v 509.755n 0.95v 514.745n 0.95v 514.755n 0.95v 519.745n 0.95v 519.755n 0.95v 524.745n 0.95v 524.755n 0.95v 529.745n 0.95v 529.755n 0.95v 534.745n 0.95v 534.755n 0.95v 539.745n 0.95v 539.755n 0.95v 544.745n 0.95v 544.755n 0.95v 549.745n 0.95v 549.755n 0.0v 554.745n 0.0v 554.755n 0.0v 559.745n 0.0v 559.755n 0.0v 564.745n 0.0v 564.755n 0.0v 569.745n 0.0v 569.755n 0.0v 574.745n 0.0v 574.755n 0.0v 579.745n 0.0v 579.755n 0.0v 584.745n 0.0v 584.755n 0.0v 589.745n 0.0v 589.755n 0.95v 594.745n 0.95v 594.755n 0.95v 599.745n 0.95v 599.755n 0.95v 604.745n 0.95v 604.755n 0.95v 609.745n 0.95v 609.755n 0.95v 614.745n 0.95v 614.755n 0.0v 619.745n 0.0v 619.755n 0.0v 624.745n 0.0v 624.755n 0.0v 629.745n 0.0v 629.755n 0.0v 634.745n 0.0v 634.755n 0.0v 639.745n 0.0v 639.755n 0.0v 644.745n 0.0v 644.755n 0.0v 649.745n 0.0v 649.755n 0.0v 654.745n 0.0v 654.755n 0.0v 659.745n 0.0v 659.755n 0.0v 664.745n 0.0v 664.755n 0.0v 669.745n 0.0v 669.755n 0.0v 674.745n 0.0v 674.755n 0.0v 679.745n 0.0v 679.755n 0.0v 684.745n 0.0v 684.755n 0.0v 689.745n 0.0v 689.755n 0.0v 694.745n 0.0v 694.755n 0.0v 699.745n 0.0v 699.755n 0.0v 704.745n 0.0v 704.755n 0.0v 709.745n 0.0v 709.755n 0.0v 714.745n 0.0v 714.755n 0.0v 719.745n 0.0v 719.755n 0.95v 724.745n 0.95v 724.755n 0.95v 729.745n 0.95v 729.755n 0.95v 734.745n 0.95v 734.755n 0.95v 739.745n 0.95v 739.755n 0.95v 744.745n 0.95v 744.755n 0.95v 749.745n 0.95v 749.755n 0.95v 754.745n 0.95v 754.755n 0.95v 759.745n 0.95v 759.755n 0.95v 764.745n 0.95v 764.755n 0.95v 769.745n 0.95v 769.755n 0.0v 774.745n 0.0v 774.755n 0.0v 779.745n 0.0v 779.755n 0.0v 784.745n 0.0v 784.755n 0.0v 789.745n 0.0v 789.755n 0.0v 794.745n 0.0v 794.755n 0.0v 799.745n 0.0v 799.755n 0.0v 804.745n 0.0v 804.755n 0.0v 809.745n 0.0v 809.755n 0.0v 814.745n 0.0v 814.755n 0.0v 819.745n 0.0v 819.755n 0.0v 824.745n 0.0v 824.755n 0.0v 829.745n 0.0v 829.755n 0.0v 834.745n 0.0v 834.755n 0.0v 839.745n 0.0v 839.755n 0.0v 844.745n 0.0v 844.755n 0.95v 849.745n 0.95v 849.755n 0.95v 854.745n 0.95v 854.755n 0.95v 859.745n 0.95v 859.755n 0.0v 864.745n 0.0v 864.755n 0.0v 869.745n 0.0v 869.755n 0.0v 874.745n 0.0v 874.755n 0.95v 879.745n 0.95v 879.755n 0.95v 884.745n 0.95v 884.755n 0.95v 889.745n 0.95v 889.755n 0.95v 894.745n 0.95v 894.755n 0.95v 899.745n 0.95v 899.755n 0.95v 904.745n 0.95v 904.755n 0.0v 909.745n 0.0v 909.755n 0.0v 914.745n 0.0v 914.755n 0.0v 919.745n 0.0v 919.755n 0.0v 924.745n 0.0v 924.755n 0.0v 929.745n 0.0v 929.755n 0.0v 934.745n 0.0v 934.755n 0.95v 939.745n 0.95v 939.755n 0.0v 944.745n 0.0v 944.755n 0.0v 949.745n 0.0v 949.755n 0.0v 954.745n 0.0v 954.755n 0.0v 959.745n 0.0v 959.755n 0.0v 964.745n 0.0v 964.755n 0.0v 969.745n 0.0v 969.755n 0.95v 974.745n 0.95v 974.755n 0.95v 979.745n 0.95v 979.755n 0.95v 984.745n 0.95v 984.755n 0.95v 989.745n 0.95v 989.755n 0.95v 994.745n 0.95v 994.755n 0.95v 999.745n 0.95v 999.755n 0.0v 1004.745n 0.0v 1004.755n 0.0v 1009.745n 0.0v 1009.755n 0.0v 1014.745n 0.0v 1014.755n 0.0v 1019.745n 0.0v 1019.755n 0.0v 1024.745n 0.0v 1024.755n 0.0v )
* (time, data): [(0, 0), (5, 0), (10, 0), (15, 1), (20, 1), (25, 1), (30, 1), (35, 1), (40, 1), (45, 1), (50, 0), (55, 0), (60, 0), (65, 0), (70, 0), (75, 0), (80, 0), (85, 0), (90, 0), (95, 1), (100, 1), (105, 1), (110, 1), (115, 1), (120, 1), (125, 1), (130, 1), (135, 1), (140, 1), (145, 1), (150, 0), (155, 0), (160, 1), (165, 1), (170, 1), (175, 1), (180, 1), (185, 1), (190, 0), (195, 0), (200, 0), (205, 0), (210, 0), (215, 0), (220, 0), (225, 0), (230, 0), (235, 0), (240, 1), (245, 1), (250, 1), (255, 1), (260, 1), (265, 0), (270, 0), (275, 0), (280, 0), (285, 0), (290, 1), (295, 1), (300, 1), (305, 1), (310, 1), (315, 1), (320, 1), (325, 0), (330, 0), (335, 0), (340, 0), (345, 0), (350, 0), (355, 0), (360, 0), (365, 0), (370, 0), (375, 0), (380, 0), (385, 0), (390, 0), (395, 0), (400, 0), (405, 0), (410, 1), (415, 1), (420, 1), (425, 0), (430, 0), (435, 0), (440, 0), (445, 0), (450, 0), (455, 0), (460, 0), (465, 0), (470, 0), (475, 0), (480, 0), (485, 0), (490, 0), (495, 0), (500, 0), (505, 0), (510, 1), (515, 1), (520, 1), (525, 1), (530, 1), (535, 1), (540, 1), (545, 1), (550, 0), (555, 0), (560, 0), (565, 0), (570, 0), (575, 0), (580, 0), (585, 0), (590, 1), (595, 1), (600, 1), (605, 1), (610, 1), (615, 0), (620, 0), (625, 0), (630, 0), (635, 0), (640, 0), (645, 0), (650, 0), (655, 0), (660, 0), (665, 0), (670, 0), (675, 0), (680, 0), (685, 0), (690, 0), (695, 0), (700, 0), (705, 0), (710, 0), (715, 0), (720, 1), (725, 1), (730, 1), (735, 1), (740, 1), (745, 1), (750, 1), (755, 1), (760, 1), (765, 1), (770, 1), (775, 1), (780, 1), (785, 1), (790, 1), (795, 1), (800, 1), (805, 1), (810, 1), (815, 1), (820, 0), (825, 0), (830, 0), (835, 0), (840, 0), (845, 0), (850, 0), (855, 0), (860, 0), (865, 0), (870, 0), (875, 0), (880, 0), (885, 0), (890, 0), (895, 0), (900, 0), (905, 1), (910, 1), (915, 1), (920, 1), (925, 1), (930, 1), (935, 1), (940, 0), (945, 0), (950, 0), (955, 0), (960, 0), (965, 0), (970, 1), (975, 1), (980, 1), (985, 1), (990, 1), (995, 1), (1000, 1), (1005, 1), (1010, 1), (1015, 1), (1020, 1), (1025, 1)]
Vdin0_23  din0_23  0 PWL (0n 0.0v 4.745n 0.0v 4.755n 0.0v 9.745n 0.0v 9.755n 0.0v 14.745n 0.0v 14.755n 0.95v 19.745n 0.95v 19.755n 0.95v 24.745n 0.95v 24.755n 0.95v 29.745n 0.95v 29.755n 0.95v 34.745n 0.95v 34.755n 0.95v 39.745n 0.95v 39.755n 0.95v 44.745n 0.95v 44.755n 0.95v 49.745n 0.95v 49.755n 0.0v 54.745n 0.0v 54.755n 0.0v 59.745n 0.0v 59.755n 0.0v 64.745n 0.0v 64.755n 0.0v 69.745n 0.0v 69.755n 0.0v 74.745n 0.0v 74.755n 0.0v 79.745n 0.0v 79.755n 0.0v 84.745n 0.0v 84.755n 0.0v 89.745n 0.0v 89.755n 0.0v 94.745n 0.0v 94.755n 0.95v 99.745n 0.95v 99.755n 0.95v 104.745n 0.95v 104.755n 0.95v 109.745n 0.95v 109.755n 0.95v 114.745n 0.95v 114.755n 0.95v 119.745n 0.95v 119.755n 0.95v 124.745n 0.95v 124.755n 0.95v 129.745n 0.95v 129.755n 0.95v 134.745n 0.95v 134.755n 0.95v 139.745n 0.95v 139.755n 0.95v 144.745n 0.95v 144.755n 0.95v 149.745n 0.95v 149.755n 0.0v 154.745n 0.0v 154.755n 0.0v 159.745n 0.0v 159.755n 0.95v 164.745n 0.95v 164.755n 0.95v 169.745n 0.95v 169.755n 0.95v 174.745n 0.95v 174.755n 0.95v 179.745n 0.95v 179.755n 0.95v 184.745n 0.95v 184.755n 0.95v 189.745n 0.95v 189.755n 0.0v 194.745n 0.0v 194.755n 0.0v 199.745n 0.0v 199.755n 0.0v 204.745n 0.0v 204.755n 0.0v 209.745n 0.0v 209.755n 0.0v 214.745n 0.0v 214.755n 0.0v 219.745n 0.0v 219.755n 0.0v 224.745n 0.0v 224.755n 0.0v 229.745n 0.0v 229.755n 0.0v 234.745n 0.0v 234.755n 0.0v 239.745n 0.0v 239.755n 0.95v 244.745n 0.95v 244.755n 0.95v 249.745n 0.95v 249.755n 0.95v 254.745n 0.95v 254.755n 0.95v 259.745n 0.95v 259.755n 0.95v 264.745n 0.95v 264.755n 0.0v 269.745n 0.0v 269.755n 0.0v 274.745n 0.0v 274.755n 0.0v 279.745n 0.0v 279.755n 0.0v 284.745n 0.0v 284.755n 0.0v 289.745n 0.0v 289.755n 0.95v 294.745n 0.95v 294.755n 0.95v 299.745n 0.95v 299.755n 0.95v 304.745n 0.95v 304.755n 0.95v 309.745n 0.95v 309.755n 0.95v 314.745n 0.95v 314.755n 0.95v 319.745n 0.95v 319.755n 0.95v 324.745n 0.95v 324.755n 0.0v 329.745n 0.0v 329.755n 0.0v 334.745n 0.0v 334.755n 0.0v 339.745n 0.0v 339.755n 0.0v 344.745n 0.0v 344.755n 0.0v 349.745n 0.0v 349.755n 0.0v 354.745n 0.0v 354.755n 0.0v 359.745n 0.0v 359.755n 0.0v 364.745n 0.0v 364.755n 0.0v 369.745n 0.0v 369.755n 0.0v 374.745n 0.0v 374.755n 0.0v 379.745n 0.0v 379.755n 0.0v 384.745n 0.0v 384.755n 0.0v 389.745n 0.0v 389.755n 0.0v 394.745n 0.0v 394.755n 0.0v 399.745n 0.0v 399.755n 0.0v 404.745n 0.0v 404.755n 0.0v 409.745n 0.0v 409.755n 0.95v 414.745n 0.95v 414.755n 0.95v 419.745n 0.95v 419.755n 0.95v 424.745n 0.95v 424.755n 0.0v 429.745n 0.0v 429.755n 0.0v 434.745n 0.0v 434.755n 0.0v 439.745n 0.0v 439.755n 0.0v 444.745n 0.0v 444.755n 0.0v 449.745n 0.0v 449.755n 0.0v 454.745n 0.0v 454.755n 0.0v 459.745n 0.0v 459.755n 0.0v 464.745n 0.0v 464.755n 0.0v 469.745n 0.0v 469.755n 0.0v 474.745n 0.0v 474.755n 0.0v 479.745n 0.0v 479.755n 0.0v 484.745n 0.0v 484.755n 0.0v 489.745n 0.0v 489.755n 0.0v 494.745n 0.0v 494.755n 0.0v 499.745n 0.0v 499.755n 0.0v 504.745n 0.0v 504.755n 0.0v 509.745n 0.0v 509.755n 0.95v 514.745n 0.95v 514.755n 0.95v 519.745n 0.95v 519.755n 0.95v 524.745n 0.95v 524.755n 0.95v 529.745n 0.95v 529.755n 0.95v 534.745n 0.95v 534.755n 0.95v 539.745n 0.95v 539.755n 0.95v 544.745n 0.95v 544.755n 0.95v 549.745n 0.95v 549.755n 0.0v 554.745n 0.0v 554.755n 0.0v 559.745n 0.0v 559.755n 0.0v 564.745n 0.0v 564.755n 0.0v 569.745n 0.0v 569.755n 0.0v 574.745n 0.0v 574.755n 0.0v 579.745n 0.0v 579.755n 0.0v 584.745n 0.0v 584.755n 0.0v 589.745n 0.0v 589.755n 0.95v 594.745n 0.95v 594.755n 0.95v 599.745n 0.95v 599.755n 0.95v 604.745n 0.95v 604.755n 0.95v 609.745n 0.95v 609.755n 0.95v 614.745n 0.95v 614.755n 0.0v 619.745n 0.0v 619.755n 0.0v 624.745n 0.0v 624.755n 0.0v 629.745n 0.0v 629.755n 0.0v 634.745n 0.0v 634.755n 0.0v 639.745n 0.0v 639.755n 0.0v 644.745n 0.0v 644.755n 0.0v 649.745n 0.0v 649.755n 0.0v 654.745n 0.0v 654.755n 0.0v 659.745n 0.0v 659.755n 0.0v 664.745n 0.0v 664.755n 0.0v 669.745n 0.0v 669.755n 0.0v 674.745n 0.0v 674.755n 0.0v 679.745n 0.0v 679.755n 0.0v 684.745n 0.0v 684.755n 0.0v 689.745n 0.0v 689.755n 0.0v 694.745n 0.0v 694.755n 0.0v 699.745n 0.0v 699.755n 0.0v 704.745n 0.0v 704.755n 0.0v 709.745n 0.0v 709.755n 0.0v 714.745n 0.0v 714.755n 0.0v 719.745n 0.0v 719.755n 0.95v 724.745n 0.95v 724.755n 0.95v 729.745n 0.95v 729.755n 0.95v 734.745n 0.95v 734.755n 0.95v 739.745n 0.95v 739.755n 0.95v 744.745n 0.95v 744.755n 0.95v 749.745n 0.95v 749.755n 0.95v 754.745n 0.95v 754.755n 0.95v 759.745n 0.95v 759.755n 0.95v 764.745n 0.95v 764.755n 0.95v 769.745n 0.95v 769.755n 0.95v 774.745n 0.95v 774.755n 0.95v 779.745n 0.95v 779.755n 0.95v 784.745n 0.95v 784.755n 0.95v 789.745n 0.95v 789.755n 0.95v 794.745n 0.95v 794.755n 0.95v 799.745n 0.95v 799.755n 0.95v 804.745n 0.95v 804.755n 0.95v 809.745n 0.95v 809.755n 0.95v 814.745n 0.95v 814.755n 0.95v 819.745n 0.95v 819.755n 0.0v 824.745n 0.0v 824.755n 0.0v 829.745n 0.0v 829.755n 0.0v 834.745n 0.0v 834.755n 0.0v 839.745n 0.0v 839.755n 0.0v 844.745n 0.0v 844.755n 0.0v 849.745n 0.0v 849.755n 0.0v 854.745n 0.0v 854.755n 0.0v 859.745n 0.0v 859.755n 0.0v 864.745n 0.0v 864.755n 0.0v 869.745n 0.0v 869.755n 0.0v 874.745n 0.0v 874.755n 0.0v 879.745n 0.0v 879.755n 0.0v 884.745n 0.0v 884.755n 0.0v 889.745n 0.0v 889.755n 0.0v 894.745n 0.0v 894.755n 0.0v 899.745n 0.0v 899.755n 0.0v 904.745n 0.0v 904.755n 0.95v 909.745n 0.95v 909.755n 0.95v 914.745n 0.95v 914.755n 0.95v 919.745n 0.95v 919.755n 0.95v 924.745n 0.95v 924.755n 0.95v 929.745n 0.95v 929.755n 0.95v 934.745n 0.95v 934.755n 0.95v 939.745n 0.95v 939.755n 0.0v 944.745n 0.0v 944.755n 0.0v 949.745n 0.0v 949.755n 0.0v 954.745n 0.0v 954.755n 0.0v 959.745n 0.0v 959.755n 0.0v 964.745n 0.0v 964.755n 0.0v 969.745n 0.0v 969.755n 0.95v 974.745n 0.95v 974.755n 0.95v 979.745n 0.95v 979.755n 0.95v 984.745n 0.95v 984.755n 0.95v 989.745n 0.95v 989.755n 0.95v 994.745n 0.95v 994.755n 0.95v 999.745n 0.95v 999.755n 0.95v 1004.745n 0.95v 1004.755n 0.95v 1009.745n 0.95v 1009.755n 0.95v 1014.745n 0.95v 1014.755n 0.95v 1019.745n 0.95v 1019.755n 0.95v 1024.745n 0.95v 1024.755n 0.95v )
* (time, data): [(0, 0), (5, 1), (10, 0), (15, 1), (20, 1), (25, 1), (30, 1), (35, 1), (40, 1), (45, 1), (50, 1), (55, 1), (60, 1), (65, 1), (70, 1), (75, 0), (80, 0), (85, 0), (90, 0), (95, 0), (100, 0), (105, 0), (110, 0), (115, 1), (120, 1), (125, 1), (130, 1), (135, 1), (140, 1), (145, 1), (150, 0), (155, 0), (160, 1), (165, 1), (170, 1), (175, 1), (180, 1), (185, 1), (190, 1), (195, 1), (200, 1), (205, 1), (210, 1), (215, 1), (220, 1), (225, 1), (230, 1), (235, 1), (240, 0), (245, 0), (250, 0), (255, 0), (260, 0), (265, 1), (270, 1), (275, 1), (280, 1), (285, 1), (290, 0), (295, 0), (300, 0), (305, 0), (310, 0), (315, 0), (320, 1), (325, 1), (330, 1), (335, 1), (340, 1), (345, 1), (350, 1), (355, 1), (360, 1), (365, 1), (370, 1), (375, 1), (380, 1), (385, 1), (390, 1), (395, 1), (400, 1), (405, 1), (410, 0), (415, 0), (420, 0), (425, 1), (430, 1), (435, 1), (440, 1), (445, 1), (450, 1), (455, 1), (460, 1), (465, 1), (470, 1), (475, 1), (480, 1), (485, 1), (490, 1), (495, 1), (500, 1), (505, 1), (510, 1), (515, 1), (520, 1), (525, 0), (530, 1), (535, 1), (540, 1), (545, 1), (550, 0), (555, 0), (560, 0), (565, 0), (570, 1), (575, 1), (580, 1), (585, 1), (590, 1), (595, 1), (600, 1), (605, 1), (610, 1), (615, 0), (620, 0), (625, 0), (630, 0), (635, 0), (640, 0), (645, 0), (650, 0), (655, 0), (660, 0), (665, 0), (670, 0), (675, 0), (680, 0), (685, 0), (690, 0), (695, 0), (700, 0), (705, 0), (710, 0), (715, 0), (720, 1), (725, 1), (730, 1), (735, 1), (740, 1), (745, 1), (750, 1), (755, 1), (760, 1), (765, 1), (770, 1), (775, 1), (780, 1), (785, 1), (790, 0), (795, 0), (800, 0), (805, 0), (810, 0), (815, 0), (820, 0), (825, 0), (830, 1), (835, 1), (840, 1), (845, 1), (850, 1), (855, 1), (860, 0), (865, 0), (870, 0), (875, 1), (880, 1), (885, 1), (890, 1), (895, 1), (900, 0), (905, 0), (910, 0), (915, 0), (920, 0), (925, 0), (930, 0), (935, 1), (940, 1), (945, 1), (950, 1), (955, 1), (960, 1), (965, 1), (970, 0), (975, 0), (980, 0), (985, 0), (990, 0), (995, 0), (1000, 1), (1005, 1), (1010, 1), (1015, 1), (1020, 1), (1025, 1)]
Vdin0_24  din0_24  0 PWL (0n 0.0v 4.745n 0.0v 4.755n 0.95v 9.745n 0.95v 9.755n 0.0v 14.745n 0.0v 14.755n 0.95v 19.745n 0.95v 19.755n 0.95v 24.745n 0.95v 24.755n 0.95v 29.745n 0.95v 29.755n 0.95v 34.745n 0.95v 34.755n 0.95v 39.745n 0.95v 39.755n 0.95v 44.745n 0.95v 44.755n 0.95v 49.745n 0.95v 49.755n 0.95v 54.745n 0.95v 54.755n 0.95v 59.745n 0.95v 59.755n 0.95v 64.745n 0.95v 64.755n 0.95v 69.745n 0.95v 69.755n 0.95v 74.745n 0.95v 74.755n 0.0v 79.745n 0.0v 79.755n 0.0v 84.745n 0.0v 84.755n 0.0v 89.745n 0.0v 89.755n 0.0v 94.745n 0.0v 94.755n 0.0v 99.745n 0.0v 99.755n 0.0v 104.745n 0.0v 104.755n 0.0v 109.745n 0.0v 109.755n 0.0v 114.745n 0.0v 114.755n 0.95v 119.745n 0.95v 119.755n 0.95v 124.745n 0.95v 124.755n 0.95v 129.745n 0.95v 129.755n 0.95v 134.745n 0.95v 134.755n 0.95v 139.745n 0.95v 139.755n 0.95v 144.745n 0.95v 144.755n 0.95v 149.745n 0.95v 149.755n 0.0v 154.745n 0.0v 154.755n 0.0v 159.745n 0.0v 159.755n 0.95v 164.745n 0.95v 164.755n 0.95v 169.745n 0.95v 169.755n 0.95v 174.745n 0.95v 174.755n 0.95v 179.745n 0.95v 179.755n 0.95v 184.745n 0.95v 184.755n 0.95v 189.745n 0.95v 189.755n 0.95v 194.745n 0.95v 194.755n 0.95v 199.745n 0.95v 199.755n 0.95v 204.745n 0.95v 204.755n 0.95v 209.745n 0.95v 209.755n 0.95v 214.745n 0.95v 214.755n 0.95v 219.745n 0.95v 219.755n 0.95v 224.745n 0.95v 224.755n 0.95v 229.745n 0.95v 229.755n 0.95v 234.745n 0.95v 234.755n 0.95v 239.745n 0.95v 239.755n 0.0v 244.745n 0.0v 244.755n 0.0v 249.745n 0.0v 249.755n 0.0v 254.745n 0.0v 254.755n 0.0v 259.745n 0.0v 259.755n 0.0v 264.745n 0.0v 264.755n 0.95v 269.745n 0.95v 269.755n 0.95v 274.745n 0.95v 274.755n 0.95v 279.745n 0.95v 279.755n 0.95v 284.745n 0.95v 284.755n 0.95v 289.745n 0.95v 289.755n 0.0v 294.745n 0.0v 294.755n 0.0v 299.745n 0.0v 299.755n 0.0v 304.745n 0.0v 304.755n 0.0v 309.745n 0.0v 309.755n 0.0v 314.745n 0.0v 314.755n 0.0v 319.745n 0.0v 319.755n 0.95v 324.745n 0.95v 324.755n 0.95v 329.745n 0.95v 329.755n 0.95v 334.745n 0.95v 334.755n 0.95v 339.745n 0.95v 339.755n 0.95v 344.745n 0.95v 344.755n 0.95v 349.745n 0.95v 349.755n 0.95v 354.745n 0.95v 354.755n 0.95v 359.745n 0.95v 359.755n 0.95v 364.745n 0.95v 364.755n 0.95v 369.745n 0.95v 369.755n 0.95v 374.745n 0.95v 374.755n 0.95v 379.745n 0.95v 379.755n 0.95v 384.745n 0.95v 384.755n 0.95v 389.745n 0.95v 389.755n 0.95v 394.745n 0.95v 394.755n 0.95v 399.745n 0.95v 399.755n 0.95v 404.745n 0.95v 404.755n 0.95v 409.745n 0.95v 409.755n 0.0v 414.745n 0.0v 414.755n 0.0v 419.745n 0.0v 419.755n 0.0v 424.745n 0.0v 424.755n 0.95v 429.745n 0.95v 429.755n 0.95v 434.745n 0.95v 434.755n 0.95v 439.745n 0.95v 439.755n 0.95v 444.745n 0.95v 444.755n 0.95v 449.745n 0.95v 449.755n 0.95v 454.745n 0.95v 454.755n 0.95v 459.745n 0.95v 459.755n 0.95v 464.745n 0.95v 464.755n 0.95v 469.745n 0.95v 469.755n 0.95v 474.745n 0.95v 474.755n 0.95v 479.745n 0.95v 479.755n 0.95v 484.745n 0.95v 484.755n 0.95v 489.745n 0.95v 489.755n 0.95v 494.745n 0.95v 494.755n 0.95v 499.745n 0.95v 499.755n 0.95v 504.745n 0.95v 504.755n 0.95v 509.745n 0.95v 509.755n 0.95v 514.745n 0.95v 514.755n 0.95v 519.745n 0.95v 519.755n 0.95v 524.745n 0.95v 524.755n 0.0v 529.745n 0.0v 529.755n 0.95v 534.745n 0.95v 534.755n 0.95v 539.745n 0.95v 539.755n 0.95v 544.745n 0.95v 544.755n 0.95v 549.745n 0.95v 549.755n 0.0v 554.745n 0.0v 554.755n 0.0v 559.745n 0.0v 559.755n 0.0v 564.745n 0.0v 564.755n 0.0v 569.745n 0.0v 569.755n 0.95v 574.745n 0.95v 574.755n 0.95v 579.745n 0.95v 579.755n 0.95v 584.745n 0.95v 584.755n 0.95v 589.745n 0.95v 589.755n 0.95v 594.745n 0.95v 594.755n 0.95v 599.745n 0.95v 599.755n 0.95v 604.745n 0.95v 604.755n 0.95v 609.745n 0.95v 609.755n 0.95v 614.745n 0.95v 614.755n 0.0v 619.745n 0.0v 619.755n 0.0v 624.745n 0.0v 624.755n 0.0v 629.745n 0.0v 629.755n 0.0v 634.745n 0.0v 634.755n 0.0v 639.745n 0.0v 639.755n 0.0v 644.745n 0.0v 644.755n 0.0v 649.745n 0.0v 649.755n 0.0v 654.745n 0.0v 654.755n 0.0v 659.745n 0.0v 659.755n 0.0v 664.745n 0.0v 664.755n 0.0v 669.745n 0.0v 669.755n 0.0v 674.745n 0.0v 674.755n 0.0v 679.745n 0.0v 679.755n 0.0v 684.745n 0.0v 684.755n 0.0v 689.745n 0.0v 689.755n 0.0v 694.745n 0.0v 694.755n 0.0v 699.745n 0.0v 699.755n 0.0v 704.745n 0.0v 704.755n 0.0v 709.745n 0.0v 709.755n 0.0v 714.745n 0.0v 714.755n 0.0v 719.745n 0.0v 719.755n 0.95v 724.745n 0.95v 724.755n 0.95v 729.745n 0.95v 729.755n 0.95v 734.745n 0.95v 734.755n 0.95v 739.745n 0.95v 739.755n 0.95v 744.745n 0.95v 744.755n 0.95v 749.745n 0.95v 749.755n 0.95v 754.745n 0.95v 754.755n 0.95v 759.745n 0.95v 759.755n 0.95v 764.745n 0.95v 764.755n 0.95v 769.745n 0.95v 769.755n 0.95v 774.745n 0.95v 774.755n 0.95v 779.745n 0.95v 779.755n 0.95v 784.745n 0.95v 784.755n 0.95v 789.745n 0.95v 789.755n 0.0v 794.745n 0.0v 794.755n 0.0v 799.745n 0.0v 799.755n 0.0v 804.745n 0.0v 804.755n 0.0v 809.745n 0.0v 809.755n 0.0v 814.745n 0.0v 814.755n 0.0v 819.745n 0.0v 819.755n 0.0v 824.745n 0.0v 824.755n 0.0v 829.745n 0.0v 829.755n 0.95v 834.745n 0.95v 834.755n 0.95v 839.745n 0.95v 839.755n 0.95v 844.745n 0.95v 844.755n 0.95v 849.745n 0.95v 849.755n 0.95v 854.745n 0.95v 854.755n 0.95v 859.745n 0.95v 859.755n 0.0v 864.745n 0.0v 864.755n 0.0v 869.745n 0.0v 869.755n 0.0v 874.745n 0.0v 874.755n 0.95v 879.745n 0.95v 879.755n 0.95v 884.745n 0.95v 884.755n 0.95v 889.745n 0.95v 889.755n 0.95v 894.745n 0.95v 894.755n 0.95v 899.745n 0.95v 899.755n 0.0v 904.745n 0.0v 904.755n 0.0v 909.745n 0.0v 909.755n 0.0v 914.745n 0.0v 914.755n 0.0v 919.745n 0.0v 919.755n 0.0v 924.745n 0.0v 924.755n 0.0v 929.745n 0.0v 929.755n 0.0v 934.745n 0.0v 934.755n 0.95v 939.745n 0.95v 939.755n 0.95v 944.745n 0.95v 944.755n 0.95v 949.745n 0.95v 949.755n 0.95v 954.745n 0.95v 954.755n 0.95v 959.745n 0.95v 959.755n 0.95v 964.745n 0.95v 964.755n 0.95v 969.745n 0.95v 969.755n 0.0v 974.745n 0.0v 974.755n 0.0v 979.745n 0.0v 979.755n 0.0v 984.745n 0.0v 984.755n 0.0v 989.745n 0.0v 989.755n 0.0v 994.745n 0.0v 994.755n 0.0v 999.745n 0.0v 999.755n 0.95v 1004.745n 0.95v 1004.755n 0.95v 1009.745n 0.95v 1009.755n 0.95v 1014.745n 0.95v 1014.755n 0.95v 1019.745n 0.95v 1019.755n 0.95v 1024.745n 0.95v 1024.755n 0.95v )
* (time, data): [(0, 0), (5, 0), (10, 0), (15, 0), (20, 0), (25, 0), (30, 0), (35, 0), (40, 0), (45, 0), (50, 1), (55, 1), (60, 1), (65, 1), (70, 1), (75, 1), (80, 1), (85, 1), (90, 1), (95, 1), (100, 1), (105, 1), (110, 1), (115, 0), (120, 0), (125, 0), (130, 0), (135, 0), (140, 0), (145, 0), (150, 1), (155, 1), (160, 1), (165, 0), (170, 0), (175, 0), (180, 0), (185, 0), (190, 1), (195, 1), (200, 1), (205, 1), (210, 1), (215, 1), (220, 1), (225, 1), (230, 1), (235, 1), (240, 1), (245, 1), (250, 1), (255, 1), (260, 1), (265, 1), (270, 1), (275, 1), (280, 1), (285, 1), (290, 1), (295, 1), (300, 1), (305, 1), (310, 1), (315, 1), (320, 1), (325, 0), (330, 1), (335, 1), (340, 1), (345, 1), (350, 1), (355, 1), (360, 1), (365, 1), (370, 1), (375, 1), (380, 1), (385, 1), (390, 1), (395, 1), (400, 1), (405, 1), (410, 1), (415, 1), (420, 1), (425, 0), (430, 0), (435, 0), (440, 0), (445, 0), (450, 0), (455, 0), (460, 0), (465, 0), (470, 0), (475, 0), (480, 0), (485, 0), (490, 0), (495, 0), (500, 0), (505, 0), (510, 0), (515, 0), (520, 0), (525, 1), (530, 0), (535, 0), (540, 0), (545, 0), (550, 1), (555, 1), (560, 1), (565, 1), (570, 1), (575, 1), (580, 1), (585, 1), (590, 1), (595, 1), (600, 1), (605, 1), (610, 1), (615, 0), (620, 0), (625, 0), (630, 0), (635, 0), (640, 0), (645, 0), (650, 0), (655, 1), (660, 1), (665, 1), (670, 1), (675, 1), (680, 1), (685, 0), (690, 0), (695, 0), (700, 0), (705, 0), (710, 0), (715, 0), (720, 1), (725, 1), (730, 1), (735, 1), (740, 1), (745, 1), (750, 1), (755, 1), (760, 1), (765, 1), (770, 1), (775, 1), (780, 1), (785, 1), (790, 0), (795, 0), (800, 0), (805, 0), (810, 0), (815, 0), (820, 1), (825, 1), (830, 1), (835, 1), (840, 1), (845, 0), (850, 0), (855, 0), (860, 1), (865, 1), (870, 1), (875, 1), (880, 1), (885, 1), (890, 1), (895, 1), (900, 0), (905, 1), (910, 1), (915, 1), (920, 1), (925, 1), (930, 1), (935, 0), (940, 0), (945, 0), (950, 0), (955, 0), (960, 0), (965, 0), (970, 1), (975, 1), (980, 1), (985, 1), (990, 1), (995, 1), (1000, 1), (1005, 1), (1010, 1), (1015, 1), (1020, 1), (1025, 1)]
Vdin0_25  din0_25  0 PWL (0n 0.0v 4.745n 0.0v 4.755n 0.0v 9.745n 0.0v 9.755n 0.0v 14.745n 0.0v 14.755n 0.0v 19.745n 0.0v 19.755n 0.0v 24.745n 0.0v 24.755n 0.0v 29.745n 0.0v 29.755n 0.0v 34.745n 0.0v 34.755n 0.0v 39.745n 0.0v 39.755n 0.0v 44.745n 0.0v 44.755n 0.0v 49.745n 0.0v 49.755n 0.95v 54.745n 0.95v 54.755n 0.95v 59.745n 0.95v 59.755n 0.95v 64.745n 0.95v 64.755n 0.95v 69.745n 0.95v 69.755n 0.95v 74.745n 0.95v 74.755n 0.95v 79.745n 0.95v 79.755n 0.95v 84.745n 0.95v 84.755n 0.95v 89.745n 0.95v 89.755n 0.95v 94.745n 0.95v 94.755n 0.95v 99.745n 0.95v 99.755n 0.95v 104.745n 0.95v 104.755n 0.95v 109.745n 0.95v 109.755n 0.95v 114.745n 0.95v 114.755n 0.0v 119.745n 0.0v 119.755n 0.0v 124.745n 0.0v 124.755n 0.0v 129.745n 0.0v 129.755n 0.0v 134.745n 0.0v 134.755n 0.0v 139.745n 0.0v 139.755n 0.0v 144.745n 0.0v 144.755n 0.0v 149.745n 0.0v 149.755n 0.95v 154.745n 0.95v 154.755n 0.95v 159.745n 0.95v 159.755n 0.95v 164.745n 0.95v 164.755n 0.0v 169.745n 0.0v 169.755n 0.0v 174.745n 0.0v 174.755n 0.0v 179.745n 0.0v 179.755n 0.0v 184.745n 0.0v 184.755n 0.0v 189.745n 0.0v 189.755n 0.95v 194.745n 0.95v 194.755n 0.95v 199.745n 0.95v 199.755n 0.95v 204.745n 0.95v 204.755n 0.95v 209.745n 0.95v 209.755n 0.95v 214.745n 0.95v 214.755n 0.95v 219.745n 0.95v 219.755n 0.95v 224.745n 0.95v 224.755n 0.95v 229.745n 0.95v 229.755n 0.95v 234.745n 0.95v 234.755n 0.95v 239.745n 0.95v 239.755n 0.95v 244.745n 0.95v 244.755n 0.95v 249.745n 0.95v 249.755n 0.95v 254.745n 0.95v 254.755n 0.95v 259.745n 0.95v 259.755n 0.95v 264.745n 0.95v 264.755n 0.95v 269.745n 0.95v 269.755n 0.95v 274.745n 0.95v 274.755n 0.95v 279.745n 0.95v 279.755n 0.95v 284.745n 0.95v 284.755n 0.95v 289.745n 0.95v 289.755n 0.95v 294.745n 0.95v 294.755n 0.95v 299.745n 0.95v 299.755n 0.95v 304.745n 0.95v 304.755n 0.95v 309.745n 0.95v 309.755n 0.95v 314.745n 0.95v 314.755n 0.95v 319.745n 0.95v 319.755n 0.95v 324.745n 0.95v 324.755n 0.0v 329.745n 0.0v 329.755n 0.95v 334.745n 0.95v 334.755n 0.95v 339.745n 0.95v 339.755n 0.95v 344.745n 0.95v 344.755n 0.95v 349.745n 0.95v 349.755n 0.95v 354.745n 0.95v 354.755n 0.95v 359.745n 0.95v 359.755n 0.95v 364.745n 0.95v 364.755n 0.95v 369.745n 0.95v 369.755n 0.95v 374.745n 0.95v 374.755n 0.95v 379.745n 0.95v 379.755n 0.95v 384.745n 0.95v 384.755n 0.95v 389.745n 0.95v 389.755n 0.95v 394.745n 0.95v 394.755n 0.95v 399.745n 0.95v 399.755n 0.95v 404.745n 0.95v 404.755n 0.95v 409.745n 0.95v 409.755n 0.95v 414.745n 0.95v 414.755n 0.95v 419.745n 0.95v 419.755n 0.95v 424.745n 0.95v 424.755n 0.0v 429.745n 0.0v 429.755n 0.0v 434.745n 0.0v 434.755n 0.0v 439.745n 0.0v 439.755n 0.0v 444.745n 0.0v 444.755n 0.0v 449.745n 0.0v 449.755n 0.0v 454.745n 0.0v 454.755n 0.0v 459.745n 0.0v 459.755n 0.0v 464.745n 0.0v 464.755n 0.0v 469.745n 0.0v 469.755n 0.0v 474.745n 0.0v 474.755n 0.0v 479.745n 0.0v 479.755n 0.0v 484.745n 0.0v 484.755n 0.0v 489.745n 0.0v 489.755n 0.0v 494.745n 0.0v 494.755n 0.0v 499.745n 0.0v 499.755n 0.0v 504.745n 0.0v 504.755n 0.0v 509.745n 0.0v 509.755n 0.0v 514.745n 0.0v 514.755n 0.0v 519.745n 0.0v 519.755n 0.0v 524.745n 0.0v 524.755n 0.95v 529.745n 0.95v 529.755n 0.0v 534.745n 0.0v 534.755n 0.0v 539.745n 0.0v 539.755n 0.0v 544.745n 0.0v 544.755n 0.0v 549.745n 0.0v 549.755n 0.95v 554.745n 0.95v 554.755n 0.95v 559.745n 0.95v 559.755n 0.95v 564.745n 0.95v 564.755n 0.95v 569.745n 0.95v 569.755n 0.95v 574.745n 0.95v 574.755n 0.95v 579.745n 0.95v 579.755n 0.95v 584.745n 0.95v 584.755n 0.95v 589.745n 0.95v 589.755n 0.95v 594.745n 0.95v 594.755n 0.95v 599.745n 0.95v 599.755n 0.95v 604.745n 0.95v 604.755n 0.95v 609.745n 0.95v 609.755n 0.95v 614.745n 0.95v 614.755n 0.0v 619.745n 0.0v 619.755n 0.0v 624.745n 0.0v 624.755n 0.0v 629.745n 0.0v 629.755n 0.0v 634.745n 0.0v 634.755n 0.0v 639.745n 0.0v 639.755n 0.0v 644.745n 0.0v 644.755n 0.0v 649.745n 0.0v 649.755n 0.0v 654.745n 0.0v 654.755n 0.95v 659.745n 0.95v 659.755n 0.95v 664.745n 0.95v 664.755n 0.95v 669.745n 0.95v 669.755n 0.95v 674.745n 0.95v 674.755n 0.95v 679.745n 0.95v 679.755n 0.95v 684.745n 0.95v 684.755n 0.0v 689.745n 0.0v 689.755n 0.0v 694.745n 0.0v 694.755n 0.0v 699.745n 0.0v 699.755n 0.0v 704.745n 0.0v 704.755n 0.0v 709.745n 0.0v 709.755n 0.0v 714.745n 0.0v 714.755n 0.0v 719.745n 0.0v 719.755n 0.95v 724.745n 0.95v 724.755n 0.95v 729.745n 0.95v 729.755n 0.95v 734.745n 0.95v 734.755n 0.95v 739.745n 0.95v 739.755n 0.95v 744.745n 0.95v 744.755n 0.95v 749.745n 0.95v 749.755n 0.95v 754.745n 0.95v 754.755n 0.95v 759.745n 0.95v 759.755n 0.95v 764.745n 0.95v 764.755n 0.95v 769.745n 0.95v 769.755n 0.95v 774.745n 0.95v 774.755n 0.95v 779.745n 0.95v 779.755n 0.95v 784.745n 0.95v 784.755n 0.95v 789.745n 0.95v 789.755n 0.0v 794.745n 0.0v 794.755n 0.0v 799.745n 0.0v 799.755n 0.0v 804.745n 0.0v 804.755n 0.0v 809.745n 0.0v 809.755n 0.0v 814.745n 0.0v 814.755n 0.0v 819.745n 0.0v 819.755n 0.95v 824.745n 0.95v 824.755n 0.95v 829.745n 0.95v 829.755n 0.95v 834.745n 0.95v 834.755n 0.95v 839.745n 0.95v 839.755n 0.95v 844.745n 0.95v 844.755n 0.0v 849.745n 0.0v 849.755n 0.0v 854.745n 0.0v 854.755n 0.0v 859.745n 0.0v 859.755n 0.95v 864.745n 0.95v 864.755n 0.95v 869.745n 0.95v 869.755n 0.95v 874.745n 0.95v 874.755n 0.95v 879.745n 0.95v 879.755n 0.95v 884.745n 0.95v 884.755n 0.95v 889.745n 0.95v 889.755n 0.95v 894.745n 0.95v 894.755n 0.95v 899.745n 0.95v 899.755n 0.0v 904.745n 0.0v 904.755n 0.95v 909.745n 0.95v 909.755n 0.95v 914.745n 0.95v 914.755n 0.95v 919.745n 0.95v 919.755n 0.95v 924.745n 0.95v 924.755n 0.95v 929.745n 0.95v 929.755n 0.95v 934.745n 0.95v 934.755n 0.0v 939.745n 0.0v 939.755n 0.0v 944.745n 0.0v 944.755n 0.0v 949.745n 0.0v 949.755n 0.0v 954.745n 0.0v 954.755n 0.0v 959.745n 0.0v 959.755n 0.0v 964.745n 0.0v 964.755n 0.0v 969.745n 0.0v 969.755n 0.95v 974.745n 0.95v 974.755n 0.95v 979.745n 0.95v 979.755n 0.95v 984.745n 0.95v 984.755n 0.95v 989.745n 0.95v 989.755n 0.95v 994.745n 0.95v 994.755n 0.95v 999.745n 0.95v 999.755n 0.95v 1004.745n 0.95v 1004.755n 0.95v 1009.745n 0.95v 1009.755n 0.95v 1014.745n 0.95v 1014.755n 0.95v 1019.745n 0.95v 1019.755n 0.95v 1024.745n 0.95v 1024.755n 0.95v )
* (time, data): [(0, 0), (5, 1), (10, 0), (15, 0), (20, 0), (25, 0), (30, 0), (35, 0), (40, 0), (45, 0), (50, 1), (55, 1), (60, 1), (65, 1), (70, 1), (75, 1), (80, 1), (85, 1), (90, 1), (95, 1), (100, 1), (105, 1), (110, 1), (115, 0), (120, 0), (125, 0), (130, 0), (135, 0), (140, 0), (145, 0), (150, 1), (155, 1), (160, 1), (165, 0), (170, 0), (175, 0), (180, 0), (185, 0), (190, 0), (195, 0), (200, 0), (205, 0), (210, 0), (215, 0), (220, 0), (225, 0), (230, 0), (235, 0), (240, 0), (245, 0), (250, 0), (255, 0), (260, 0), (265, 0), (270, 0), (275, 0), (280, 0), (285, 0), (290, 1), (295, 1), (300, 1), (305, 1), (310, 1), (315, 1), (320, 1), (325, 0), (330, 0), (335, 0), (340, 0), (345, 0), (350, 0), (355, 0), (360, 0), (365, 0), (370, 0), (375, 0), (380, 0), (385, 0), (390, 0), (395, 0), (400, 0), (405, 0), (410, 1), (415, 1), (420, 1), (425, 0), (430, 0), (435, 0), (440, 0), (445, 0), (450, 0), (455, 0), (460, 0), (465, 0), (470, 0), (475, 0), (480, 0), (485, 0), (490, 0), (495, 0), (500, 0), (505, 0), (510, 0), (515, 0), (520, 0), (525, 1), (530, 1), (535, 1), (540, 1), (545, 1), (550, 0), (555, 0), (560, 0), (565, 0), (570, 0), (575, 0), (580, 0), (585, 0), (590, 0), (595, 0), (600, 1), (605, 1), (610, 1), (615, 0), (620, 0), (625, 0), (630, 0), (635, 0), (640, 0), (645, 0), (650, 0), (655, 0), (660, 0), (665, 0), (670, 0), (675, 0), (680, 0), (685, 1), (690, 1), (695, 1), (700, 1), (705, 1), (710, 1), (715, 1), (720, 1), (725, 1), (730, 1), (735, 1), (740, 1), (745, 1), (750, 1), (755, 1), (760, 1), (765, 1), (770, 1), (775, 1), (780, 1), (785, 1), (790, 0), (795, 0), (800, 0), (805, 0), (810, 0), (815, 0), (820, 1), (825, 1), (830, 1), (835, 1), (840, 1), (845, 0), (850, 0), (855, 0), (860, 1), (865, 1), (870, 1), (875, 1), (880, 1), (885, 1), (890, 1), (895, 1), (900, 0), (905, 0), (910, 0), (915, 0), (920, 0), (925, 0), (930, 0), (935, 0), (940, 0), (945, 0), (950, 0), (955, 0), (960, 0), (965, 0), (970, 1), (975, 1), (980, 1), (985, 1), (990, 1), (995, 1), (1000, 0), (1005, 0), (1010, 0), (1015, 0), (1020, 0), (1025, 0)]
Vdin0_26  din0_26  0 PWL (0n 0.0v 4.745n 0.0v 4.755n 0.95v 9.745n 0.95v 9.755n 0.0v 14.745n 0.0v 14.755n 0.0v 19.745n 0.0v 19.755n 0.0v 24.745n 0.0v 24.755n 0.0v 29.745n 0.0v 29.755n 0.0v 34.745n 0.0v 34.755n 0.0v 39.745n 0.0v 39.755n 0.0v 44.745n 0.0v 44.755n 0.0v 49.745n 0.0v 49.755n 0.95v 54.745n 0.95v 54.755n 0.95v 59.745n 0.95v 59.755n 0.95v 64.745n 0.95v 64.755n 0.95v 69.745n 0.95v 69.755n 0.95v 74.745n 0.95v 74.755n 0.95v 79.745n 0.95v 79.755n 0.95v 84.745n 0.95v 84.755n 0.95v 89.745n 0.95v 89.755n 0.95v 94.745n 0.95v 94.755n 0.95v 99.745n 0.95v 99.755n 0.95v 104.745n 0.95v 104.755n 0.95v 109.745n 0.95v 109.755n 0.95v 114.745n 0.95v 114.755n 0.0v 119.745n 0.0v 119.755n 0.0v 124.745n 0.0v 124.755n 0.0v 129.745n 0.0v 129.755n 0.0v 134.745n 0.0v 134.755n 0.0v 139.745n 0.0v 139.755n 0.0v 144.745n 0.0v 144.755n 0.0v 149.745n 0.0v 149.755n 0.95v 154.745n 0.95v 154.755n 0.95v 159.745n 0.95v 159.755n 0.95v 164.745n 0.95v 164.755n 0.0v 169.745n 0.0v 169.755n 0.0v 174.745n 0.0v 174.755n 0.0v 179.745n 0.0v 179.755n 0.0v 184.745n 0.0v 184.755n 0.0v 189.745n 0.0v 189.755n 0.0v 194.745n 0.0v 194.755n 0.0v 199.745n 0.0v 199.755n 0.0v 204.745n 0.0v 204.755n 0.0v 209.745n 0.0v 209.755n 0.0v 214.745n 0.0v 214.755n 0.0v 219.745n 0.0v 219.755n 0.0v 224.745n 0.0v 224.755n 0.0v 229.745n 0.0v 229.755n 0.0v 234.745n 0.0v 234.755n 0.0v 239.745n 0.0v 239.755n 0.0v 244.745n 0.0v 244.755n 0.0v 249.745n 0.0v 249.755n 0.0v 254.745n 0.0v 254.755n 0.0v 259.745n 0.0v 259.755n 0.0v 264.745n 0.0v 264.755n 0.0v 269.745n 0.0v 269.755n 0.0v 274.745n 0.0v 274.755n 0.0v 279.745n 0.0v 279.755n 0.0v 284.745n 0.0v 284.755n 0.0v 289.745n 0.0v 289.755n 0.95v 294.745n 0.95v 294.755n 0.95v 299.745n 0.95v 299.755n 0.95v 304.745n 0.95v 304.755n 0.95v 309.745n 0.95v 309.755n 0.95v 314.745n 0.95v 314.755n 0.95v 319.745n 0.95v 319.755n 0.95v 324.745n 0.95v 324.755n 0.0v 329.745n 0.0v 329.755n 0.0v 334.745n 0.0v 334.755n 0.0v 339.745n 0.0v 339.755n 0.0v 344.745n 0.0v 344.755n 0.0v 349.745n 0.0v 349.755n 0.0v 354.745n 0.0v 354.755n 0.0v 359.745n 0.0v 359.755n 0.0v 364.745n 0.0v 364.755n 0.0v 369.745n 0.0v 369.755n 0.0v 374.745n 0.0v 374.755n 0.0v 379.745n 0.0v 379.755n 0.0v 384.745n 0.0v 384.755n 0.0v 389.745n 0.0v 389.755n 0.0v 394.745n 0.0v 394.755n 0.0v 399.745n 0.0v 399.755n 0.0v 404.745n 0.0v 404.755n 0.0v 409.745n 0.0v 409.755n 0.95v 414.745n 0.95v 414.755n 0.95v 419.745n 0.95v 419.755n 0.95v 424.745n 0.95v 424.755n 0.0v 429.745n 0.0v 429.755n 0.0v 434.745n 0.0v 434.755n 0.0v 439.745n 0.0v 439.755n 0.0v 444.745n 0.0v 444.755n 0.0v 449.745n 0.0v 449.755n 0.0v 454.745n 0.0v 454.755n 0.0v 459.745n 0.0v 459.755n 0.0v 464.745n 0.0v 464.755n 0.0v 469.745n 0.0v 469.755n 0.0v 474.745n 0.0v 474.755n 0.0v 479.745n 0.0v 479.755n 0.0v 484.745n 0.0v 484.755n 0.0v 489.745n 0.0v 489.755n 0.0v 494.745n 0.0v 494.755n 0.0v 499.745n 0.0v 499.755n 0.0v 504.745n 0.0v 504.755n 0.0v 509.745n 0.0v 509.755n 0.0v 514.745n 0.0v 514.755n 0.0v 519.745n 0.0v 519.755n 0.0v 524.745n 0.0v 524.755n 0.95v 529.745n 0.95v 529.755n 0.95v 534.745n 0.95v 534.755n 0.95v 539.745n 0.95v 539.755n 0.95v 544.745n 0.95v 544.755n 0.95v 549.745n 0.95v 549.755n 0.0v 554.745n 0.0v 554.755n 0.0v 559.745n 0.0v 559.755n 0.0v 564.745n 0.0v 564.755n 0.0v 569.745n 0.0v 569.755n 0.0v 574.745n 0.0v 574.755n 0.0v 579.745n 0.0v 579.755n 0.0v 584.745n 0.0v 584.755n 0.0v 589.745n 0.0v 589.755n 0.0v 594.745n 0.0v 594.755n 0.0v 599.745n 0.0v 599.755n 0.95v 604.745n 0.95v 604.755n 0.95v 609.745n 0.95v 609.755n 0.95v 614.745n 0.95v 614.755n 0.0v 619.745n 0.0v 619.755n 0.0v 624.745n 0.0v 624.755n 0.0v 629.745n 0.0v 629.755n 0.0v 634.745n 0.0v 634.755n 0.0v 639.745n 0.0v 639.755n 0.0v 644.745n 0.0v 644.755n 0.0v 649.745n 0.0v 649.755n 0.0v 654.745n 0.0v 654.755n 0.0v 659.745n 0.0v 659.755n 0.0v 664.745n 0.0v 664.755n 0.0v 669.745n 0.0v 669.755n 0.0v 674.745n 0.0v 674.755n 0.0v 679.745n 0.0v 679.755n 0.0v 684.745n 0.0v 684.755n 0.95v 689.745n 0.95v 689.755n 0.95v 694.745n 0.95v 694.755n 0.95v 699.745n 0.95v 699.755n 0.95v 704.745n 0.95v 704.755n 0.95v 709.745n 0.95v 709.755n 0.95v 714.745n 0.95v 714.755n 0.95v 719.745n 0.95v 719.755n 0.95v 724.745n 0.95v 724.755n 0.95v 729.745n 0.95v 729.755n 0.95v 734.745n 0.95v 734.755n 0.95v 739.745n 0.95v 739.755n 0.95v 744.745n 0.95v 744.755n 0.95v 749.745n 0.95v 749.755n 0.95v 754.745n 0.95v 754.755n 0.95v 759.745n 0.95v 759.755n 0.95v 764.745n 0.95v 764.755n 0.95v 769.745n 0.95v 769.755n 0.95v 774.745n 0.95v 774.755n 0.95v 779.745n 0.95v 779.755n 0.95v 784.745n 0.95v 784.755n 0.95v 789.745n 0.95v 789.755n 0.0v 794.745n 0.0v 794.755n 0.0v 799.745n 0.0v 799.755n 0.0v 804.745n 0.0v 804.755n 0.0v 809.745n 0.0v 809.755n 0.0v 814.745n 0.0v 814.755n 0.0v 819.745n 0.0v 819.755n 0.95v 824.745n 0.95v 824.755n 0.95v 829.745n 0.95v 829.755n 0.95v 834.745n 0.95v 834.755n 0.95v 839.745n 0.95v 839.755n 0.95v 844.745n 0.95v 844.755n 0.0v 849.745n 0.0v 849.755n 0.0v 854.745n 0.0v 854.755n 0.0v 859.745n 0.0v 859.755n 0.95v 864.745n 0.95v 864.755n 0.95v 869.745n 0.95v 869.755n 0.95v 874.745n 0.95v 874.755n 0.95v 879.745n 0.95v 879.755n 0.95v 884.745n 0.95v 884.755n 0.95v 889.745n 0.95v 889.755n 0.95v 894.745n 0.95v 894.755n 0.95v 899.745n 0.95v 899.755n 0.0v 904.745n 0.0v 904.755n 0.0v 909.745n 0.0v 909.755n 0.0v 914.745n 0.0v 914.755n 0.0v 919.745n 0.0v 919.755n 0.0v 924.745n 0.0v 924.755n 0.0v 929.745n 0.0v 929.755n 0.0v 934.745n 0.0v 934.755n 0.0v 939.745n 0.0v 939.755n 0.0v 944.745n 0.0v 944.755n 0.0v 949.745n 0.0v 949.755n 0.0v 954.745n 0.0v 954.755n 0.0v 959.745n 0.0v 959.755n 0.0v 964.745n 0.0v 964.755n 0.0v 969.745n 0.0v 969.755n 0.95v 974.745n 0.95v 974.755n 0.95v 979.745n 0.95v 979.755n 0.95v 984.745n 0.95v 984.755n 0.95v 989.745n 0.95v 989.755n 0.95v 994.745n 0.95v 994.755n 0.95v 999.745n 0.95v 999.755n 0.0v 1004.745n 0.0v 1004.755n 0.0v 1009.745n 0.0v 1009.755n 0.0v 1014.745n 0.0v 1014.755n 0.0v 1019.745n 0.0v 1019.755n 0.0v 1024.745n 0.0v 1024.755n 0.0v )
* (time, data): [(0, 0), (5, 0), (10, 0), (15, 0), (20, 0), (25, 0), (30, 0), (35, 0), (40, 0), (45, 0), (50, 0), (55, 0), (60, 0), (65, 0), (70, 0), (75, 1), (80, 1), (85, 1), (90, 1), (95, 0), (100, 0), (105, 0), (110, 0), (115, 1), (120, 1), (125, 1), (130, 1), (135, 1), (140, 1), (145, 1), (150, 0), (155, 0), (160, 1), (165, 1), (170, 1), (175, 1), (180, 1), (185, 1), (190, 1), (195, 1), (200, 1), (205, 1), (210, 1), (215, 1), (220, 1), (225, 1), (230, 1), (235, 1), (240, 1), (245, 1), (250, 1), (255, 1), (260, 1), (265, 1), (270, 1), (275, 1), (280, 1), (285, 1), (290, 1), (295, 1), (300, 1), (305, 1), (310, 1), (315, 1), (320, 1), (325, 1), (330, 0), (335, 0), (340, 0), (345, 0), (350, 0), (355, 0), (360, 0), (365, 0), (370, 0), (375, 0), (380, 0), (385, 0), (390, 0), (395, 0), (400, 0), (405, 0), (410, 1), (415, 1), (420, 1), (425, 1), (430, 1), (435, 1), (440, 1), (445, 1), (450, 1), (455, 1), (460, 1), (465, 1), (470, 1), (475, 1), (480, 1), (485, 1), (490, 1), (495, 1), (500, 1), (505, 1), (510, 1), (515, 1), (520, 1), (525, 1), (530, 1), (535, 1), (540, 1), (545, 1), (550, 0), (555, 0), (560, 0), (565, 0), (570, 0), (575, 0), (580, 0), (585, 0), (590, 0), (595, 0), (600, 0), (605, 0), (610, 0), (615, 1), (620, 1), (625, 1), (630, 1), (635, 1), (640, 1), (645, 1), (650, 1), (655, 1), (660, 1), (665, 1), (670, 1), (675, 1), (680, 1), (685, 1), (690, 1), (695, 1), (700, 1), (705, 1), (710, 1), (715, 1), (720, 1), (725, 1), (730, 1), (735, 1), (740, 1), (745, 1), (750, 1), (755, 1), (760, 1), (765, 1), (770, 1), (775, 1), (780, 1), (785, 1), (790, 0), (795, 0), (800, 0), (805, 0), (810, 0), (815, 0), (820, 1), (825, 1), (830, 1), (835, 1), (840, 1), (845, 1), (850, 1), (855, 1), (860, 1), (865, 1), (870, 1), (875, 0), (880, 0), (885, 0), (890, 0), (895, 0), (900, 1), (905, 0), (910, 0), (915, 0), (920, 0), (925, 0), (930, 0), (935, 0), (940, 1), (945, 1), (950, 1), (955, 1), (960, 1), (965, 1), (970, 0), (975, 0), (980, 0), (985, 0), (990, 0), (995, 0), (1000, 1), (1005, 1), (1010, 1), (1015, 1), (1020, 1), (1025, 1)]
Vdin0_27  din0_27  0 PWL (0n 0.0v 4.745n 0.0v 4.755n 0.0v 9.745n 0.0v 9.755n 0.0v 14.745n 0.0v 14.755n 0.0v 19.745n 0.0v 19.755n 0.0v 24.745n 0.0v 24.755n 0.0v 29.745n 0.0v 29.755n 0.0v 34.745n 0.0v 34.755n 0.0v 39.745n 0.0v 39.755n 0.0v 44.745n 0.0v 44.755n 0.0v 49.745n 0.0v 49.755n 0.0v 54.745n 0.0v 54.755n 0.0v 59.745n 0.0v 59.755n 0.0v 64.745n 0.0v 64.755n 0.0v 69.745n 0.0v 69.755n 0.0v 74.745n 0.0v 74.755n 0.95v 79.745n 0.95v 79.755n 0.95v 84.745n 0.95v 84.755n 0.95v 89.745n 0.95v 89.755n 0.95v 94.745n 0.95v 94.755n 0.0v 99.745n 0.0v 99.755n 0.0v 104.745n 0.0v 104.755n 0.0v 109.745n 0.0v 109.755n 0.0v 114.745n 0.0v 114.755n 0.95v 119.745n 0.95v 119.755n 0.95v 124.745n 0.95v 124.755n 0.95v 129.745n 0.95v 129.755n 0.95v 134.745n 0.95v 134.755n 0.95v 139.745n 0.95v 139.755n 0.95v 144.745n 0.95v 144.755n 0.95v 149.745n 0.95v 149.755n 0.0v 154.745n 0.0v 154.755n 0.0v 159.745n 0.0v 159.755n 0.95v 164.745n 0.95v 164.755n 0.95v 169.745n 0.95v 169.755n 0.95v 174.745n 0.95v 174.755n 0.95v 179.745n 0.95v 179.755n 0.95v 184.745n 0.95v 184.755n 0.95v 189.745n 0.95v 189.755n 0.95v 194.745n 0.95v 194.755n 0.95v 199.745n 0.95v 199.755n 0.95v 204.745n 0.95v 204.755n 0.95v 209.745n 0.95v 209.755n 0.95v 214.745n 0.95v 214.755n 0.95v 219.745n 0.95v 219.755n 0.95v 224.745n 0.95v 224.755n 0.95v 229.745n 0.95v 229.755n 0.95v 234.745n 0.95v 234.755n 0.95v 239.745n 0.95v 239.755n 0.95v 244.745n 0.95v 244.755n 0.95v 249.745n 0.95v 249.755n 0.95v 254.745n 0.95v 254.755n 0.95v 259.745n 0.95v 259.755n 0.95v 264.745n 0.95v 264.755n 0.95v 269.745n 0.95v 269.755n 0.95v 274.745n 0.95v 274.755n 0.95v 279.745n 0.95v 279.755n 0.95v 284.745n 0.95v 284.755n 0.95v 289.745n 0.95v 289.755n 0.95v 294.745n 0.95v 294.755n 0.95v 299.745n 0.95v 299.755n 0.95v 304.745n 0.95v 304.755n 0.95v 309.745n 0.95v 309.755n 0.95v 314.745n 0.95v 314.755n 0.95v 319.745n 0.95v 319.755n 0.95v 324.745n 0.95v 324.755n 0.95v 329.745n 0.95v 329.755n 0.0v 334.745n 0.0v 334.755n 0.0v 339.745n 0.0v 339.755n 0.0v 344.745n 0.0v 344.755n 0.0v 349.745n 0.0v 349.755n 0.0v 354.745n 0.0v 354.755n 0.0v 359.745n 0.0v 359.755n 0.0v 364.745n 0.0v 364.755n 0.0v 369.745n 0.0v 369.755n 0.0v 374.745n 0.0v 374.755n 0.0v 379.745n 0.0v 379.755n 0.0v 384.745n 0.0v 384.755n 0.0v 389.745n 0.0v 389.755n 0.0v 394.745n 0.0v 394.755n 0.0v 399.745n 0.0v 399.755n 0.0v 404.745n 0.0v 404.755n 0.0v 409.745n 0.0v 409.755n 0.95v 414.745n 0.95v 414.755n 0.95v 419.745n 0.95v 419.755n 0.95v 424.745n 0.95v 424.755n 0.95v 429.745n 0.95v 429.755n 0.95v 434.745n 0.95v 434.755n 0.95v 439.745n 0.95v 439.755n 0.95v 444.745n 0.95v 444.755n 0.95v 449.745n 0.95v 449.755n 0.95v 454.745n 0.95v 454.755n 0.95v 459.745n 0.95v 459.755n 0.95v 464.745n 0.95v 464.755n 0.95v 469.745n 0.95v 469.755n 0.95v 474.745n 0.95v 474.755n 0.95v 479.745n 0.95v 479.755n 0.95v 484.745n 0.95v 484.755n 0.95v 489.745n 0.95v 489.755n 0.95v 494.745n 0.95v 494.755n 0.95v 499.745n 0.95v 499.755n 0.95v 504.745n 0.95v 504.755n 0.95v 509.745n 0.95v 509.755n 0.95v 514.745n 0.95v 514.755n 0.95v 519.745n 0.95v 519.755n 0.95v 524.745n 0.95v 524.755n 0.95v 529.745n 0.95v 529.755n 0.95v 534.745n 0.95v 534.755n 0.95v 539.745n 0.95v 539.755n 0.95v 544.745n 0.95v 544.755n 0.95v 549.745n 0.95v 549.755n 0.0v 554.745n 0.0v 554.755n 0.0v 559.745n 0.0v 559.755n 0.0v 564.745n 0.0v 564.755n 0.0v 569.745n 0.0v 569.755n 0.0v 574.745n 0.0v 574.755n 0.0v 579.745n 0.0v 579.755n 0.0v 584.745n 0.0v 584.755n 0.0v 589.745n 0.0v 589.755n 0.0v 594.745n 0.0v 594.755n 0.0v 599.745n 0.0v 599.755n 0.0v 604.745n 0.0v 604.755n 0.0v 609.745n 0.0v 609.755n 0.0v 614.745n 0.0v 614.755n 0.95v 619.745n 0.95v 619.755n 0.95v 624.745n 0.95v 624.755n 0.95v 629.745n 0.95v 629.755n 0.95v 634.745n 0.95v 634.755n 0.95v 639.745n 0.95v 639.755n 0.95v 644.745n 0.95v 644.755n 0.95v 649.745n 0.95v 649.755n 0.95v 654.745n 0.95v 654.755n 0.95v 659.745n 0.95v 659.755n 0.95v 664.745n 0.95v 664.755n 0.95v 669.745n 0.95v 669.755n 0.95v 674.745n 0.95v 674.755n 0.95v 679.745n 0.95v 679.755n 0.95v 684.745n 0.95v 684.755n 0.95v 689.745n 0.95v 689.755n 0.95v 694.745n 0.95v 694.755n 0.95v 699.745n 0.95v 699.755n 0.95v 704.745n 0.95v 704.755n 0.95v 709.745n 0.95v 709.755n 0.95v 714.745n 0.95v 714.755n 0.95v 719.745n 0.95v 719.755n 0.95v 724.745n 0.95v 724.755n 0.95v 729.745n 0.95v 729.755n 0.95v 734.745n 0.95v 734.755n 0.95v 739.745n 0.95v 739.755n 0.95v 744.745n 0.95v 744.755n 0.95v 749.745n 0.95v 749.755n 0.95v 754.745n 0.95v 754.755n 0.95v 759.745n 0.95v 759.755n 0.95v 764.745n 0.95v 764.755n 0.95v 769.745n 0.95v 769.755n 0.95v 774.745n 0.95v 774.755n 0.95v 779.745n 0.95v 779.755n 0.95v 784.745n 0.95v 784.755n 0.95v 789.745n 0.95v 789.755n 0.0v 794.745n 0.0v 794.755n 0.0v 799.745n 0.0v 799.755n 0.0v 804.745n 0.0v 804.755n 0.0v 809.745n 0.0v 809.755n 0.0v 814.745n 0.0v 814.755n 0.0v 819.745n 0.0v 819.755n 0.95v 824.745n 0.95v 824.755n 0.95v 829.745n 0.95v 829.755n 0.95v 834.745n 0.95v 834.755n 0.95v 839.745n 0.95v 839.755n 0.95v 844.745n 0.95v 844.755n 0.95v 849.745n 0.95v 849.755n 0.95v 854.745n 0.95v 854.755n 0.95v 859.745n 0.95v 859.755n 0.95v 864.745n 0.95v 864.755n 0.95v 869.745n 0.95v 869.755n 0.95v 874.745n 0.95v 874.755n 0.0v 879.745n 0.0v 879.755n 0.0v 884.745n 0.0v 884.755n 0.0v 889.745n 0.0v 889.755n 0.0v 894.745n 0.0v 894.755n 0.0v 899.745n 0.0v 899.755n 0.95v 904.745n 0.95v 904.755n 0.0v 909.745n 0.0v 909.755n 0.0v 914.745n 0.0v 914.755n 0.0v 919.745n 0.0v 919.755n 0.0v 924.745n 0.0v 924.755n 0.0v 929.745n 0.0v 929.755n 0.0v 934.745n 0.0v 934.755n 0.0v 939.745n 0.0v 939.755n 0.95v 944.745n 0.95v 944.755n 0.95v 949.745n 0.95v 949.755n 0.95v 954.745n 0.95v 954.755n 0.95v 959.745n 0.95v 959.755n 0.95v 964.745n 0.95v 964.755n 0.95v 969.745n 0.95v 969.755n 0.0v 974.745n 0.0v 974.755n 0.0v 979.745n 0.0v 979.755n 0.0v 984.745n 0.0v 984.755n 0.0v 989.745n 0.0v 989.755n 0.0v 994.745n 0.0v 994.755n 0.0v 999.745n 0.0v 999.755n 0.95v 1004.745n 0.95v 1004.755n 0.95v 1009.745n 0.95v 1009.755n 0.95v 1014.745n 0.95v 1014.755n 0.95v 1019.745n 0.95v 1019.755n 0.95v 1024.745n 0.95v 1024.755n 0.95v )
* (time, data): [(0, 0), (5, 0), (10, 1), (15, 0), (20, 0), (25, 0), (30, 0), (35, 0), (40, 0), (45, 0), (50, 1), (55, 1), (60, 1), (65, 1), (70, 1), (75, 0), (80, 0), (85, 0), (90, 0), (95, 0), (100, 0), (105, 0), (110, 0), (115, 1), (120, 1), (125, 1), (130, 1), (135, 1), (140, 1), (145, 1), (150, 1), (155, 1), (160, 1), (165, 1), (170, 1), (175, 1), (180, 1), (185, 1), (190, 0), (195, 0), (200, 0), (205, 0), (210, 0), (215, 0), (220, 0), (225, 0), (230, 0), (235, 0), (240, 1), (245, 1), (250, 1), (255, 1), (260, 1), (265, 0), (270, 0), (275, 0), (280, 0), (285, 0), (290, 0), (295, 0), (300, 0), (305, 0), (310, 0), (315, 0), (320, 0), (325, 1), (330, 0), (335, 0), (340, 0), (345, 0), (350, 0), (355, 0), (360, 0), (365, 0), (370, 0), (375, 0), (380, 0), (385, 0), (390, 0), (395, 0), (400, 0), (405, 0), (410, 1), (415, 1), (420, 1), (425, 1), (430, 1), (435, 1), (440, 1), (445, 1), (450, 1), (455, 1), (460, 1), (465, 1), (470, 1), (475, 1), (480, 1), (485, 1), (490, 1), (495, 1), (500, 1), (505, 1), (510, 0), (515, 0), (520, 0), (525, 0), (530, 1), (535, 1), (540, 1), (545, 1), (550, 0), (555, 0), (560, 0), (565, 0), (570, 1), (575, 1), (580, 1), (585, 1), (590, 1), (595, 1), (600, 1), (605, 1), (610, 1), (615, 0), (620, 0), (625, 0), (630, 0), (635, 0), (640, 0), (645, 0), (650, 0), (655, 1), (660, 1), (665, 1), (670, 1), (675, 1), (680, 1), (685, 1), (690, 1), (695, 1), (700, 1), (705, 1), (710, 1), (715, 1), (720, 0), (725, 0), (730, 0), (735, 0), (740, 0), (745, 0), (750, 0), (755, 0), (760, 0), (765, 0), (770, 0), (775, 0), (780, 0), (785, 0), (790, 0), (795, 0), (800, 0), (805, 0), (810, 0), (815, 0), (820, 0), (825, 0), (830, 0), (835, 0), (840, 0), (845, 1), (850, 1), (855, 1), (860, 0), (865, 0), (870, 0), (875, 0), (880, 0), (885, 0), (890, 0), (895, 0), (900, 1), (905, 0), (910, 0), (915, 0), (920, 0), (925, 0), (930, 0), (935, 0), (940, 0), (945, 0), (950, 0), (955, 0), (960, 0), (965, 0), (970, 0), (975, 0), (980, 0), (985, 0), (990, 0), (995, 0), (1000, 0), (1005, 0), (1010, 0), (1015, 0), (1020, 0), (1025, 0)]
Vdin0_28  din0_28  0 PWL (0n 0.0v 4.745n 0.0v 4.755n 0.0v 9.745n 0.0v 9.755n 0.95v 14.745n 0.95v 14.755n 0.0v 19.745n 0.0v 19.755n 0.0v 24.745n 0.0v 24.755n 0.0v 29.745n 0.0v 29.755n 0.0v 34.745n 0.0v 34.755n 0.0v 39.745n 0.0v 39.755n 0.0v 44.745n 0.0v 44.755n 0.0v 49.745n 0.0v 49.755n 0.95v 54.745n 0.95v 54.755n 0.95v 59.745n 0.95v 59.755n 0.95v 64.745n 0.95v 64.755n 0.95v 69.745n 0.95v 69.755n 0.95v 74.745n 0.95v 74.755n 0.0v 79.745n 0.0v 79.755n 0.0v 84.745n 0.0v 84.755n 0.0v 89.745n 0.0v 89.755n 0.0v 94.745n 0.0v 94.755n 0.0v 99.745n 0.0v 99.755n 0.0v 104.745n 0.0v 104.755n 0.0v 109.745n 0.0v 109.755n 0.0v 114.745n 0.0v 114.755n 0.95v 119.745n 0.95v 119.755n 0.95v 124.745n 0.95v 124.755n 0.95v 129.745n 0.95v 129.755n 0.95v 134.745n 0.95v 134.755n 0.95v 139.745n 0.95v 139.755n 0.95v 144.745n 0.95v 144.755n 0.95v 149.745n 0.95v 149.755n 0.95v 154.745n 0.95v 154.755n 0.95v 159.745n 0.95v 159.755n 0.95v 164.745n 0.95v 164.755n 0.95v 169.745n 0.95v 169.755n 0.95v 174.745n 0.95v 174.755n 0.95v 179.745n 0.95v 179.755n 0.95v 184.745n 0.95v 184.755n 0.95v 189.745n 0.95v 189.755n 0.0v 194.745n 0.0v 194.755n 0.0v 199.745n 0.0v 199.755n 0.0v 204.745n 0.0v 204.755n 0.0v 209.745n 0.0v 209.755n 0.0v 214.745n 0.0v 214.755n 0.0v 219.745n 0.0v 219.755n 0.0v 224.745n 0.0v 224.755n 0.0v 229.745n 0.0v 229.755n 0.0v 234.745n 0.0v 234.755n 0.0v 239.745n 0.0v 239.755n 0.95v 244.745n 0.95v 244.755n 0.95v 249.745n 0.95v 249.755n 0.95v 254.745n 0.95v 254.755n 0.95v 259.745n 0.95v 259.755n 0.95v 264.745n 0.95v 264.755n 0.0v 269.745n 0.0v 269.755n 0.0v 274.745n 0.0v 274.755n 0.0v 279.745n 0.0v 279.755n 0.0v 284.745n 0.0v 284.755n 0.0v 289.745n 0.0v 289.755n 0.0v 294.745n 0.0v 294.755n 0.0v 299.745n 0.0v 299.755n 0.0v 304.745n 0.0v 304.755n 0.0v 309.745n 0.0v 309.755n 0.0v 314.745n 0.0v 314.755n 0.0v 319.745n 0.0v 319.755n 0.0v 324.745n 0.0v 324.755n 0.95v 329.745n 0.95v 329.755n 0.0v 334.745n 0.0v 334.755n 0.0v 339.745n 0.0v 339.755n 0.0v 344.745n 0.0v 344.755n 0.0v 349.745n 0.0v 349.755n 0.0v 354.745n 0.0v 354.755n 0.0v 359.745n 0.0v 359.755n 0.0v 364.745n 0.0v 364.755n 0.0v 369.745n 0.0v 369.755n 0.0v 374.745n 0.0v 374.755n 0.0v 379.745n 0.0v 379.755n 0.0v 384.745n 0.0v 384.755n 0.0v 389.745n 0.0v 389.755n 0.0v 394.745n 0.0v 394.755n 0.0v 399.745n 0.0v 399.755n 0.0v 404.745n 0.0v 404.755n 0.0v 409.745n 0.0v 409.755n 0.95v 414.745n 0.95v 414.755n 0.95v 419.745n 0.95v 419.755n 0.95v 424.745n 0.95v 424.755n 0.95v 429.745n 0.95v 429.755n 0.95v 434.745n 0.95v 434.755n 0.95v 439.745n 0.95v 439.755n 0.95v 444.745n 0.95v 444.755n 0.95v 449.745n 0.95v 449.755n 0.95v 454.745n 0.95v 454.755n 0.95v 459.745n 0.95v 459.755n 0.95v 464.745n 0.95v 464.755n 0.95v 469.745n 0.95v 469.755n 0.95v 474.745n 0.95v 474.755n 0.95v 479.745n 0.95v 479.755n 0.95v 484.745n 0.95v 484.755n 0.95v 489.745n 0.95v 489.755n 0.95v 494.745n 0.95v 494.755n 0.95v 499.745n 0.95v 499.755n 0.95v 504.745n 0.95v 504.755n 0.95v 509.745n 0.95v 509.755n 0.0v 514.745n 0.0v 514.755n 0.0v 519.745n 0.0v 519.755n 0.0v 524.745n 0.0v 524.755n 0.0v 529.745n 0.0v 529.755n 0.95v 534.745n 0.95v 534.755n 0.95v 539.745n 0.95v 539.755n 0.95v 544.745n 0.95v 544.755n 0.95v 549.745n 0.95v 549.755n 0.0v 554.745n 0.0v 554.755n 0.0v 559.745n 0.0v 559.755n 0.0v 564.745n 0.0v 564.755n 0.0v 569.745n 0.0v 569.755n 0.95v 574.745n 0.95v 574.755n 0.95v 579.745n 0.95v 579.755n 0.95v 584.745n 0.95v 584.755n 0.95v 589.745n 0.95v 589.755n 0.95v 594.745n 0.95v 594.755n 0.95v 599.745n 0.95v 599.755n 0.95v 604.745n 0.95v 604.755n 0.95v 609.745n 0.95v 609.755n 0.95v 614.745n 0.95v 614.755n 0.0v 619.745n 0.0v 619.755n 0.0v 624.745n 0.0v 624.755n 0.0v 629.745n 0.0v 629.755n 0.0v 634.745n 0.0v 634.755n 0.0v 639.745n 0.0v 639.755n 0.0v 644.745n 0.0v 644.755n 0.0v 649.745n 0.0v 649.755n 0.0v 654.745n 0.0v 654.755n 0.95v 659.745n 0.95v 659.755n 0.95v 664.745n 0.95v 664.755n 0.95v 669.745n 0.95v 669.755n 0.95v 674.745n 0.95v 674.755n 0.95v 679.745n 0.95v 679.755n 0.95v 684.745n 0.95v 684.755n 0.95v 689.745n 0.95v 689.755n 0.95v 694.745n 0.95v 694.755n 0.95v 699.745n 0.95v 699.755n 0.95v 704.745n 0.95v 704.755n 0.95v 709.745n 0.95v 709.755n 0.95v 714.745n 0.95v 714.755n 0.95v 719.745n 0.95v 719.755n 0.0v 724.745n 0.0v 724.755n 0.0v 729.745n 0.0v 729.755n 0.0v 734.745n 0.0v 734.755n 0.0v 739.745n 0.0v 739.755n 0.0v 744.745n 0.0v 744.755n 0.0v 749.745n 0.0v 749.755n 0.0v 754.745n 0.0v 754.755n 0.0v 759.745n 0.0v 759.755n 0.0v 764.745n 0.0v 764.755n 0.0v 769.745n 0.0v 769.755n 0.0v 774.745n 0.0v 774.755n 0.0v 779.745n 0.0v 779.755n 0.0v 784.745n 0.0v 784.755n 0.0v 789.745n 0.0v 789.755n 0.0v 794.745n 0.0v 794.755n 0.0v 799.745n 0.0v 799.755n 0.0v 804.745n 0.0v 804.755n 0.0v 809.745n 0.0v 809.755n 0.0v 814.745n 0.0v 814.755n 0.0v 819.745n 0.0v 819.755n 0.0v 824.745n 0.0v 824.755n 0.0v 829.745n 0.0v 829.755n 0.0v 834.745n 0.0v 834.755n 0.0v 839.745n 0.0v 839.755n 0.0v 844.745n 0.0v 844.755n 0.95v 849.745n 0.95v 849.755n 0.95v 854.745n 0.95v 854.755n 0.95v 859.745n 0.95v 859.755n 0.0v 864.745n 0.0v 864.755n 0.0v 869.745n 0.0v 869.755n 0.0v 874.745n 0.0v 874.755n 0.0v 879.745n 0.0v 879.755n 0.0v 884.745n 0.0v 884.755n 0.0v 889.745n 0.0v 889.755n 0.0v 894.745n 0.0v 894.755n 0.0v 899.745n 0.0v 899.755n 0.95v 904.745n 0.95v 904.755n 0.0v 909.745n 0.0v 909.755n 0.0v 914.745n 0.0v 914.755n 0.0v 919.745n 0.0v 919.755n 0.0v 924.745n 0.0v 924.755n 0.0v 929.745n 0.0v 929.755n 0.0v 934.745n 0.0v 934.755n 0.0v 939.745n 0.0v 939.755n 0.0v 944.745n 0.0v 944.755n 0.0v 949.745n 0.0v 949.755n 0.0v 954.745n 0.0v 954.755n 0.0v 959.745n 0.0v 959.755n 0.0v 964.745n 0.0v 964.755n 0.0v 969.745n 0.0v 969.755n 0.0v 974.745n 0.0v 974.755n 0.0v 979.745n 0.0v 979.755n 0.0v 984.745n 0.0v 984.755n 0.0v 989.745n 0.0v 989.755n 0.0v 994.745n 0.0v 994.755n 0.0v 999.745n 0.0v 999.755n 0.0v 1004.745n 0.0v 1004.755n 0.0v 1009.745n 0.0v 1009.755n 0.0v 1014.745n 0.0v 1014.755n 0.0v 1019.745n 0.0v 1019.755n 0.0v 1024.745n 0.0v 1024.755n 0.0v )
* (time, data): [(0, 0), (5, 0), (10, 0), (15, 1), (20, 1), (25, 1), (30, 1), (35, 1), (40, 1), (45, 1), (50, 1), (55, 1), (60, 1), (65, 1), (70, 1), (75, 1), (80, 1), (85, 1), (90, 1), (95, 0), (100, 0), (105, 0), (110, 0), (115, 0), (120, 0), (125, 0), (130, 0), (135, 0), (140, 0), (145, 0), (150, 1), (155, 1), (160, 1), (165, 0), (170, 0), (175, 0), (180, 0), (185, 0), (190, 1), (195, 1), (200, 1), (205, 1), (210, 1), (215, 1), (220, 1), (225, 1), (230, 1), (235, 1), (240, 1), (245, 1), (250, 1), (255, 1), (260, 1), (265, 1), (270, 1), (275, 1), (280, 1), (285, 1), (290, 0), (295, 0), (300, 0), (305, 0), (310, 0), (315, 0), (320, 0), (325, 1), (330, 1), (335, 1), (340, 1), (345, 1), (350, 1), (355, 1), (360, 1), (365, 1), (370, 1), (375, 1), (380, 1), (385, 1), (390, 1), (395, 1), (400, 1), (405, 1), (410, 0), (415, 0), (420, 0), (425, 1), (430, 1), (435, 1), (440, 1), (445, 1), (450, 1), (455, 1), (460, 1), (465, 1), (470, 1), (475, 1), (480, 1), (485, 1), (490, 1), (495, 1), (500, 1), (505, 1), (510, 1), (515, 1), (520, 1), (525, 0), (530, 0), (535, 0), (540, 0), (545, 0), (550, 0), (555, 0), (560, 0), (565, 0), (570, 1), (575, 1), (580, 1), (585, 1), (590, 0), (595, 0), (600, 1), (605, 1), (610, 1), (615, 1), (620, 1), (625, 1), (630, 1), (635, 1), (640, 1), (645, 1), (650, 1), (655, 0), (660, 0), (665, 0), (670, 0), (675, 0), (680, 0), (685, 1), (690, 1), (695, 1), (700, 1), (705, 1), (710, 1), (715, 1), (720, 1), (725, 1), (730, 1), (735, 1), (740, 1), (745, 1), (750, 1), (755, 1), (760, 1), (765, 1), (770, 1), (775, 1), (780, 1), (785, 1), (790, 1), (795, 1), (800, 1), (805, 1), (810, 1), (815, 1), (820, 0), (825, 0), (830, 0), (835, 0), (840, 0), (845, 0), (850, 0), (855, 0), (860, 1), (865, 1), (870, 1), (875, 0), (880, 0), (885, 0), (890, 0), (895, 0), (900, 1), (905, 1), (910, 1), (915, 1), (920, 1), (925, 1), (930, 1), (935, 0), (940, 0), (945, 0), (950, 0), (955, 0), (960, 0), (965, 0), (970, 0), (975, 0), (980, 0), (985, 0), (990, 0), (995, 0), (1000, 1), (1005, 1), (1010, 1), (1015, 1), (1020, 1), (1025, 1)]
Vdin0_29  din0_29  0 PWL (0n 0.0v 4.745n 0.0v 4.755n 0.0v 9.745n 0.0v 9.755n 0.0v 14.745n 0.0v 14.755n 0.95v 19.745n 0.95v 19.755n 0.95v 24.745n 0.95v 24.755n 0.95v 29.745n 0.95v 29.755n 0.95v 34.745n 0.95v 34.755n 0.95v 39.745n 0.95v 39.755n 0.95v 44.745n 0.95v 44.755n 0.95v 49.745n 0.95v 49.755n 0.95v 54.745n 0.95v 54.755n 0.95v 59.745n 0.95v 59.755n 0.95v 64.745n 0.95v 64.755n 0.95v 69.745n 0.95v 69.755n 0.95v 74.745n 0.95v 74.755n 0.95v 79.745n 0.95v 79.755n 0.95v 84.745n 0.95v 84.755n 0.95v 89.745n 0.95v 89.755n 0.95v 94.745n 0.95v 94.755n 0.0v 99.745n 0.0v 99.755n 0.0v 104.745n 0.0v 104.755n 0.0v 109.745n 0.0v 109.755n 0.0v 114.745n 0.0v 114.755n 0.0v 119.745n 0.0v 119.755n 0.0v 124.745n 0.0v 124.755n 0.0v 129.745n 0.0v 129.755n 0.0v 134.745n 0.0v 134.755n 0.0v 139.745n 0.0v 139.755n 0.0v 144.745n 0.0v 144.755n 0.0v 149.745n 0.0v 149.755n 0.95v 154.745n 0.95v 154.755n 0.95v 159.745n 0.95v 159.755n 0.95v 164.745n 0.95v 164.755n 0.0v 169.745n 0.0v 169.755n 0.0v 174.745n 0.0v 174.755n 0.0v 179.745n 0.0v 179.755n 0.0v 184.745n 0.0v 184.755n 0.0v 189.745n 0.0v 189.755n 0.95v 194.745n 0.95v 194.755n 0.95v 199.745n 0.95v 199.755n 0.95v 204.745n 0.95v 204.755n 0.95v 209.745n 0.95v 209.755n 0.95v 214.745n 0.95v 214.755n 0.95v 219.745n 0.95v 219.755n 0.95v 224.745n 0.95v 224.755n 0.95v 229.745n 0.95v 229.755n 0.95v 234.745n 0.95v 234.755n 0.95v 239.745n 0.95v 239.755n 0.95v 244.745n 0.95v 244.755n 0.95v 249.745n 0.95v 249.755n 0.95v 254.745n 0.95v 254.755n 0.95v 259.745n 0.95v 259.755n 0.95v 264.745n 0.95v 264.755n 0.95v 269.745n 0.95v 269.755n 0.95v 274.745n 0.95v 274.755n 0.95v 279.745n 0.95v 279.755n 0.95v 284.745n 0.95v 284.755n 0.95v 289.745n 0.95v 289.755n 0.0v 294.745n 0.0v 294.755n 0.0v 299.745n 0.0v 299.755n 0.0v 304.745n 0.0v 304.755n 0.0v 309.745n 0.0v 309.755n 0.0v 314.745n 0.0v 314.755n 0.0v 319.745n 0.0v 319.755n 0.0v 324.745n 0.0v 324.755n 0.95v 329.745n 0.95v 329.755n 0.95v 334.745n 0.95v 334.755n 0.95v 339.745n 0.95v 339.755n 0.95v 344.745n 0.95v 344.755n 0.95v 349.745n 0.95v 349.755n 0.95v 354.745n 0.95v 354.755n 0.95v 359.745n 0.95v 359.755n 0.95v 364.745n 0.95v 364.755n 0.95v 369.745n 0.95v 369.755n 0.95v 374.745n 0.95v 374.755n 0.95v 379.745n 0.95v 379.755n 0.95v 384.745n 0.95v 384.755n 0.95v 389.745n 0.95v 389.755n 0.95v 394.745n 0.95v 394.755n 0.95v 399.745n 0.95v 399.755n 0.95v 404.745n 0.95v 404.755n 0.95v 409.745n 0.95v 409.755n 0.0v 414.745n 0.0v 414.755n 0.0v 419.745n 0.0v 419.755n 0.0v 424.745n 0.0v 424.755n 0.95v 429.745n 0.95v 429.755n 0.95v 434.745n 0.95v 434.755n 0.95v 439.745n 0.95v 439.755n 0.95v 444.745n 0.95v 444.755n 0.95v 449.745n 0.95v 449.755n 0.95v 454.745n 0.95v 454.755n 0.95v 459.745n 0.95v 459.755n 0.95v 464.745n 0.95v 464.755n 0.95v 469.745n 0.95v 469.755n 0.95v 474.745n 0.95v 474.755n 0.95v 479.745n 0.95v 479.755n 0.95v 484.745n 0.95v 484.755n 0.95v 489.745n 0.95v 489.755n 0.95v 494.745n 0.95v 494.755n 0.95v 499.745n 0.95v 499.755n 0.95v 504.745n 0.95v 504.755n 0.95v 509.745n 0.95v 509.755n 0.95v 514.745n 0.95v 514.755n 0.95v 519.745n 0.95v 519.755n 0.95v 524.745n 0.95v 524.755n 0.0v 529.745n 0.0v 529.755n 0.0v 534.745n 0.0v 534.755n 0.0v 539.745n 0.0v 539.755n 0.0v 544.745n 0.0v 544.755n 0.0v 549.745n 0.0v 549.755n 0.0v 554.745n 0.0v 554.755n 0.0v 559.745n 0.0v 559.755n 0.0v 564.745n 0.0v 564.755n 0.0v 569.745n 0.0v 569.755n 0.95v 574.745n 0.95v 574.755n 0.95v 579.745n 0.95v 579.755n 0.95v 584.745n 0.95v 584.755n 0.95v 589.745n 0.95v 589.755n 0.0v 594.745n 0.0v 594.755n 0.0v 599.745n 0.0v 599.755n 0.95v 604.745n 0.95v 604.755n 0.95v 609.745n 0.95v 609.755n 0.95v 614.745n 0.95v 614.755n 0.95v 619.745n 0.95v 619.755n 0.95v 624.745n 0.95v 624.755n 0.95v 629.745n 0.95v 629.755n 0.95v 634.745n 0.95v 634.755n 0.95v 639.745n 0.95v 639.755n 0.95v 644.745n 0.95v 644.755n 0.95v 649.745n 0.95v 649.755n 0.95v 654.745n 0.95v 654.755n 0.0v 659.745n 0.0v 659.755n 0.0v 664.745n 0.0v 664.755n 0.0v 669.745n 0.0v 669.755n 0.0v 674.745n 0.0v 674.755n 0.0v 679.745n 0.0v 679.755n 0.0v 684.745n 0.0v 684.755n 0.95v 689.745n 0.95v 689.755n 0.95v 694.745n 0.95v 694.755n 0.95v 699.745n 0.95v 699.755n 0.95v 704.745n 0.95v 704.755n 0.95v 709.745n 0.95v 709.755n 0.95v 714.745n 0.95v 714.755n 0.95v 719.745n 0.95v 719.755n 0.95v 724.745n 0.95v 724.755n 0.95v 729.745n 0.95v 729.755n 0.95v 734.745n 0.95v 734.755n 0.95v 739.745n 0.95v 739.755n 0.95v 744.745n 0.95v 744.755n 0.95v 749.745n 0.95v 749.755n 0.95v 754.745n 0.95v 754.755n 0.95v 759.745n 0.95v 759.755n 0.95v 764.745n 0.95v 764.755n 0.95v 769.745n 0.95v 769.755n 0.95v 774.745n 0.95v 774.755n 0.95v 779.745n 0.95v 779.755n 0.95v 784.745n 0.95v 784.755n 0.95v 789.745n 0.95v 789.755n 0.95v 794.745n 0.95v 794.755n 0.95v 799.745n 0.95v 799.755n 0.95v 804.745n 0.95v 804.755n 0.95v 809.745n 0.95v 809.755n 0.95v 814.745n 0.95v 814.755n 0.95v 819.745n 0.95v 819.755n 0.0v 824.745n 0.0v 824.755n 0.0v 829.745n 0.0v 829.755n 0.0v 834.745n 0.0v 834.755n 0.0v 839.745n 0.0v 839.755n 0.0v 844.745n 0.0v 844.755n 0.0v 849.745n 0.0v 849.755n 0.0v 854.745n 0.0v 854.755n 0.0v 859.745n 0.0v 859.755n 0.95v 864.745n 0.95v 864.755n 0.95v 869.745n 0.95v 869.755n 0.95v 874.745n 0.95v 874.755n 0.0v 879.745n 0.0v 879.755n 0.0v 884.745n 0.0v 884.755n 0.0v 889.745n 0.0v 889.755n 0.0v 894.745n 0.0v 894.755n 0.0v 899.745n 0.0v 899.755n 0.95v 904.745n 0.95v 904.755n 0.95v 909.745n 0.95v 909.755n 0.95v 914.745n 0.95v 914.755n 0.95v 919.745n 0.95v 919.755n 0.95v 924.745n 0.95v 924.755n 0.95v 929.745n 0.95v 929.755n 0.95v 934.745n 0.95v 934.755n 0.0v 939.745n 0.0v 939.755n 0.0v 944.745n 0.0v 944.755n 0.0v 949.745n 0.0v 949.755n 0.0v 954.745n 0.0v 954.755n 0.0v 959.745n 0.0v 959.755n 0.0v 964.745n 0.0v 964.755n 0.0v 969.745n 0.0v 969.755n 0.0v 974.745n 0.0v 974.755n 0.0v 979.745n 0.0v 979.755n 0.0v 984.745n 0.0v 984.755n 0.0v 989.745n 0.0v 989.755n 0.0v 994.745n 0.0v 994.755n 0.0v 999.745n 0.0v 999.755n 0.95v 1004.745n 0.95v 1004.755n 0.95v 1009.745n 0.95v 1009.755n 0.95v 1014.745n 0.95v 1014.755n 0.95v 1019.745n 0.95v 1019.755n 0.95v 1024.745n 0.95v 1024.755n 0.95v )
* (time, data): [(0, 0), (5, 0), (10, 1), (15, 0), (20, 0), (25, 0), (30, 0), (35, 0), (40, 0), (45, 0), (50, 0), (55, 0), (60, 0), (65, 0), (70, 0), (75, 0), (80, 0), (85, 0), (90, 0), (95, 1), (100, 1), (105, 1), (110, 1), (115, 0), (120, 0), (125, 0), (130, 0), (135, 0), (140, 0), (145, 0), (150, 1), (155, 1), (160, 0), (165, 0), (170, 0), (175, 0), (180, 0), (185, 0), (190, 1), (195, 1), (200, 1), (205, 1), (210, 1), (215, 1), (220, 1), (225, 1), (230, 1), (235, 1), (240, 0), (245, 0), (250, 0), (255, 0), (260, 0), (265, 1), (270, 1), (275, 1), (280, 1), (285, 1), (290, 0), (295, 0), (300, 0), (305, 0), (310, 0), (315, 0), (320, 0), (325, 0), (330, 0), (335, 0), (340, 0), (345, 0), (350, 0), (355, 0), (360, 0), (365, 0), (370, 0), (375, 0), (380, 0), (385, 0), (390, 0), (395, 0), (400, 0), (405, 0), (410, 0), (415, 0), (420, 0), (425, 0), (430, 0), (435, 0), (440, 0), (445, 0), (450, 0), (455, 0), (460, 0), (465, 0), (470, 0), (475, 0), (480, 0), (485, 0), (490, 0), (495, 0), (500, 0), (505, 0), (510, 0), (515, 0), (520, 0), (525, 0), (530, 0), (535, 0), (540, 0), (545, 0), (550, 1), (555, 1), (560, 1), (565, 1), (570, 1), (575, 1), (580, 1), (585, 1), (590, 1), (595, 1), (600, 0), (605, 0), (610, 0), (615, 0), (620, 0), (625, 0), (630, 0), (635, 0), (640, 0), (645, 0), (650, 0), (655, 1), (660, 1), (665, 1), (670, 1), (675, 1), (680, 1), (685, 1), (690, 1), (695, 1), (700, 1), (705, 1), (710, 1), (715, 1), (720, 1), (725, 1), (730, 1), (735, 1), (740, 1), (745, 1), (750, 1), (755, 1), (760, 1), (765, 1), (770, 0), (775, 0), (780, 0), (785, 0), (790, 1), (795, 1), (800, 1), (805, 1), (810, 1), (815, 1), (820, 0), (825, 0), (830, 1), (835, 1), (840, 1), (845, 0), (850, 0), (855, 0), (860, 1), (865, 1), (870, 1), (875, 0), (880, 0), (885, 0), (890, 0), (895, 0), (900, 0), (905, 0), (910, 0), (915, 0), (920, 0), (925, 0), (930, 0), (935, 0), (940, 0), (945, 0), (950, 0), (955, 0), (960, 0), (965, 0), (970, 1), (975, 1), (980, 1), (985, 1), (990, 1), (995, 1), (1000, 0), (1005, 0), (1010, 0), (1015, 0), (1020, 0), (1025, 0)]
Vdin0_30  din0_30  0 PWL (0n 0.0v 4.745n 0.0v 4.755n 0.0v 9.745n 0.0v 9.755n 0.95v 14.745n 0.95v 14.755n 0.0v 19.745n 0.0v 19.755n 0.0v 24.745n 0.0v 24.755n 0.0v 29.745n 0.0v 29.755n 0.0v 34.745n 0.0v 34.755n 0.0v 39.745n 0.0v 39.755n 0.0v 44.745n 0.0v 44.755n 0.0v 49.745n 0.0v 49.755n 0.0v 54.745n 0.0v 54.755n 0.0v 59.745n 0.0v 59.755n 0.0v 64.745n 0.0v 64.755n 0.0v 69.745n 0.0v 69.755n 0.0v 74.745n 0.0v 74.755n 0.0v 79.745n 0.0v 79.755n 0.0v 84.745n 0.0v 84.755n 0.0v 89.745n 0.0v 89.755n 0.0v 94.745n 0.0v 94.755n 0.95v 99.745n 0.95v 99.755n 0.95v 104.745n 0.95v 104.755n 0.95v 109.745n 0.95v 109.755n 0.95v 114.745n 0.95v 114.755n 0.0v 119.745n 0.0v 119.755n 0.0v 124.745n 0.0v 124.755n 0.0v 129.745n 0.0v 129.755n 0.0v 134.745n 0.0v 134.755n 0.0v 139.745n 0.0v 139.755n 0.0v 144.745n 0.0v 144.755n 0.0v 149.745n 0.0v 149.755n 0.95v 154.745n 0.95v 154.755n 0.95v 159.745n 0.95v 159.755n 0.0v 164.745n 0.0v 164.755n 0.0v 169.745n 0.0v 169.755n 0.0v 174.745n 0.0v 174.755n 0.0v 179.745n 0.0v 179.755n 0.0v 184.745n 0.0v 184.755n 0.0v 189.745n 0.0v 189.755n 0.95v 194.745n 0.95v 194.755n 0.95v 199.745n 0.95v 199.755n 0.95v 204.745n 0.95v 204.755n 0.95v 209.745n 0.95v 209.755n 0.95v 214.745n 0.95v 214.755n 0.95v 219.745n 0.95v 219.755n 0.95v 224.745n 0.95v 224.755n 0.95v 229.745n 0.95v 229.755n 0.95v 234.745n 0.95v 234.755n 0.95v 239.745n 0.95v 239.755n 0.0v 244.745n 0.0v 244.755n 0.0v 249.745n 0.0v 249.755n 0.0v 254.745n 0.0v 254.755n 0.0v 259.745n 0.0v 259.755n 0.0v 264.745n 0.0v 264.755n 0.95v 269.745n 0.95v 269.755n 0.95v 274.745n 0.95v 274.755n 0.95v 279.745n 0.95v 279.755n 0.95v 284.745n 0.95v 284.755n 0.95v 289.745n 0.95v 289.755n 0.0v 294.745n 0.0v 294.755n 0.0v 299.745n 0.0v 299.755n 0.0v 304.745n 0.0v 304.755n 0.0v 309.745n 0.0v 309.755n 0.0v 314.745n 0.0v 314.755n 0.0v 319.745n 0.0v 319.755n 0.0v 324.745n 0.0v 324.755n 0.0v 329.745n 0.0v 329.755n 0.0v 334.745n 0.0v 334.755n 0.0v 339.745n 0.0v 339.755n 0.0v 344.745n 0.0v 344.755n 0.0v 349.745n 0.0v 349.755n 0.0v 354.745n 0.0v 354.755n 0.0v 359.745n 0.0v 359.755n 0.0v 364.745n 0.0v 364.755n 0.0v 369.745n 0.0v 369.755n 0.0v 374.745n 0.0v 374.755n 0.0v 379.745n 0.0v 379.755n 0.0v 384.745n 0.0v 384.755n 0.0v 389.745n 0.0v 389.755n 0.0v 394.745n 0.0v 394.755n 0.0v 399.745n 0.0v 399.755n 0.0v 404.745n 0.0v 404.755n 0.0v 409.745n 0.0v 409.755n 0.0v 414.745n 0.0v 414.755n 0.0v 419.745n 0.0v 419.755n 0.0v 424.745n 0.0v 424.755n 0.0v 429.745n 0.0v 429.755n 0.0v 434.745n 0.0v 434.755n 0.0v 439.745n 0.0v 439.755n 0.0v 444.745n 0.0v 444.755n 0.0v 449.745n 0.0v 449.755n 0.0v 454.745n 0.0v 454.755n 0.0v 459.745n 0.0v 459.755n 0.0v 464.745n 0.0v 464.755n 0.0v 469.745n 0.0v 469.755n 0.0v 474.745n 0.0v 474.755n 0.0v 479.745n 0.0v 479.755n 0.0v 484.745n 0.0v 484.755n 0.0v 489.745n 0.0v 489.755n 0.0v 494.745n 0.0v 494.755n 0.0v 499.745n 0.0v 499.755n 0.0v 504.745n 0.0v 504.755n 0.0v 509.745n 0.0v 509.755n 0.0v 514.745n 0.0v 514.755n 0.0v 519.745n 0.0v 519.755n 0.0v 524.745n 0.0v 524.755n 0.0v 529.745n 0.0v 529.755n 0.0v 534.745n 0.0v 534.755n 0.0v 539.745n 0.0v 539.755n 0.0v 544.745n 0.0v 544.755n 0.0v 549.745n 0.0v 549.755n 0.95v 554.745n 0.95v 554.755n 0.95v 559.745n 0.95v 559.755n 0.95v 564.745n 0.95v 564.755n 0.95v 569.745n 0.95v 569.755n 0.95v 574.745n 0.95v 574.755n 0.95v 579.745n 0.95v 579.755n 0.95v 584.745n 0.95v 584.755n 0.95v 589.745n 0.95v 589.755n 0.95v 594.745n 0.95v 594.755n 0.95v 599.745n 0.95v 599.755n 0.0v 604.745n 0.0v 604.755n 0.0v 609.745n 0.0v 609.755n 0.0v 614.745n 0.0v 614.755n 0.0v 619.745n 0.0v 619.755n 0.0v 624.745n 0.0v 624.755n 0.0v 629.745n 0.0v 629.755n 0.0v 634.745n 0.0v 634.755n 0.0v 639.745n 0.0v 639.755n 0.0v 644.745n 0.0v 644.755n 0.0v 649.745n 0.0v 649.755n 0.0v 654.745n 0.0v 654.755n 0.95v 659.745n 0.95v 659.755n 0.95v 664.745n 0.95v 664.755n 0.95v 669.745n 0.95v 669.755n 0.95v 674.745n 0.95v 674.755n 0.95v 679.745n 0.95v 679.755n 0.95v 684.745n 0.95v 684.755n 0.95v 689.745n 0.95v 689.755n 0.95v 694.745n 0.95v 694.755n 0.95v 699.745n 0.95v 699.755n 0.95v 704.745n 0.95v 704.755n 0.95v 709.745n 0.95v 709.755n 0.95v 714.745n 0.95v 714.755n 0.95v 719.745n 0.95v 719.755n 0.95v 724.745n 0.95v 724.755n 0.95v 729.745n 0.95v 729.755n 0.95v 734.745n 0.95v 734.755n 0.95v 739.745n 0.95v 739.755n 0.95v 744.745n 0.95v 744.755n 0.95v 749.745n 0.95v 749.755n 0.95v 754.745n 0.95v 754.755n 0.95v 759.745n 0.95v 759.755n 0.95v 764.745n 0.95v 764.755n 0.95v 769.745n 0.95v 769.755n 0.0v 774.745n 0.0v 774.755n 0.0v 779.745n 0.0v 779.755n 0.0v 784.745n 0.0v 784.755n 0.0v 789.745n 0.0v 789.755n 0.95v 794.745n 0.95v 794.755n 0.95v 799.745n 0.95v 799.755n 0.95v 804.745n 0.95v 804.755n 0.95v 809.745n 0.95v 809.755n 0.95v 814.745n 0.95v 814.755n 0.95v 819.745n 0.95v 819.755n 0.0v 824.745n 0.0v 824.755n 0.0v 829.745n 0.0v 829.755n 0.95v 834.745n 0.95v 834.755n 0.95v 839.745n 0.95v 839.755n 0.95v 844.745n 0.95v 844.755n 0.0v 849.745n 0.0v 849.755n 0.0v 854.745n 0.0v 854.755n 0.0v 859.745n 0.0v 859.755n 0.95v 864.745n 0.95v 864.755n 0.95v 869.745n 0.95v 869.755n 0.95v 874.745n 0.95v 874.755n 0.0v 879.745n 0.0v 879.755n 0.0v 884.745n 0.0v 884.755n 0.0v 889.745n 0.0v 889.755n 0.0v 894.745n 0.0v 894.755n 0.0v 899.745n 0.0v 899.755n 0.0v 904.745n 0.0v 904.755n 0.0v 909.745n 0.0v 909.755n 0.0v 914.745n 0.0v 914.755n 0.0v 919.745n 0.0v 919.755n 0.0v 924.745n 0.0v 924.755n 0.0v 929.745n 0.0v 929.755n 0.0v 934.745n 0.0v 934.755n 0.0v 939.745n 0.0v 939.755n 0.0v 944.745n 0.0v 944.755n 0.0v 949.745n 0.0v 949.755n 0.0v 954.745n 0.0v 954.755n 0.0v 959.745n 0.0v 959.755n 0.0v 964.745n 0.0v 964.755n 0.0v 969.745n 0.0v 969.755n 0.95v 974.745n 0.95v 974.755n 0.95v 979.745n 0.95v 979.755n 0.95v 984.745n 0.95v 984.755n 0.95v 989.745n 0.95v 989.755n 0.95v 994.745n 0.95v 994.755n 0.95v 999.745n 0.95v 999.755n 0.0v 1004.745n 0.0v 1004.755n 0.0v 1009.745n 0.0v 1009.755n 0.0v 1014.745n 0.0v 1014.755n 0.0v 1019.745n 0.0v 1019.755n 0.0v 1024.745n 0.0v 1024.755n 0.0v )
* (time, data): [(0, 0), (5, 0), (10, 1), (15, 0), (20, 0), (25, 0), (30, 0), (35, 0), (40, 0), (45, 0), (50, 1), (55, 1), (60, 1), (65, 1), (70, 1), (75, 1), (80, 1), (85, 1), (90, 1), (95, 1), (100, 1), (105, 1), (110, 1), (115, 1), (120, 1), (125, 1), (130, 1), (135, 1), (140, 1), (145, 1), (150, 1), (155, 1), (160, 0), (165, 1), (170, 1), (175, 1), (180, 1), (185, 1), (190, 1), (195, 1), (200, 1), (205, 1), (210, 1), (215, 1), (220, 1), (225, 1), (230, 1), (235, 1), (240, 1), (245, 1), (250, 1), (255, 1), (260, 1), (265, 0), (270, 0), (275, 0), (280, 0), (285, 0), (290, 0), (295, 0), (300, 0), (305, 0), (310, 0), (315, 0), (320, 1), (325, 1), (330, 0), (335, 0), (340, 0), (345, 0), (350, 0), (355, 0), (360, 0), (365, 0), (370, 0), (375, 0), (380, 0), (385, 0), (390, 0), (395, 0), (400, 0), (405, 0), (410, 1), (415, 1), (420, 1), (425, 0), (430, 0), (435, 0), (440, 0), (445, 0), (450, 0), (455, 0), (460, 0), (465, 0), (470, 0), (475, 0), (480, 0), (485, 0), (490, 0), (495, 0), (500, 0), (505, 0), (510, 1), (515, 1), (520, 1), (525, 0), (530, 0), (535, 0), (540, 0), (545, 0), (550, 1), (555, 1), (560, 1), (565, 1), (570, 1), (575, 1), (580, 1), (585, 1), (590, 1), (595, 1), (600, 1), (605, 1), (610, 1), (615, 0), (620, 0), (625, 0), (630, 0), (635, 0), (640, 0), (645, 0), (650, 0), (655, 1), (660, 1), (665, 1), (670, 1), (675, 1), (680, 1), (685, 1), (690, 1), (695, 1), (700, 1), (705, 1), (710, 1), (715, 1), (720, 1), (725, 1), (730, 1), (735, 1), (740, 1), (745, 1), (750, 1), (755, 1), (760, 1), (765, 1), (770, 1), (775, 1), (780, 1), (785, 1), (790, 1), (795, 1), (800, 1), (805, 1), (810, 1), (815, 1), (820, 0), (825, 0), (830, 1), (835, 1), (840, 1), (845, 0), (850, 0), (855, 0), (860, 1), (865, 1), (870, 1), (875, 1), (880, 1), (885, 1), (890, 1), (895, 1), (900, 1), (905, 1), (910, 1), (915, 1), (920, 1), (925, 1), (930, 1), (935, 0), (940, 1), (945, 1), (950, 1), (955, 1), (960, 1), (965, 1), (970, 0), (975, 0), (980, 0), (985, 0), (990, 0), (995, 0), (1000, 0), (1005, 0), (1010, 0), (1015, 0), (1020, 0), (1025, 0)]
Vdin0_31  din0_31  0 PWL (0n 0.0v 4.745n 0.0v 4.755n 0.0v 9.745n 0.0v 9.755n 0.95v 14.745n 0.95v 14.755n 0.0v 19.745n 0.0v 19.755n 0.0v 24.745n 0.0v 24.755n 0.0v 29.745n 0.0v 29.755n 0.0v 34.745n 0.0v 34.755n 0.0v 39.745n 0.0v 39.755n 0.0v 44.745n 0.0v 44.755n 0.0v 49.745n 0.0v 49.755n 0.95v 54.745n 0.95v 54.755n 0.95v 59.745n 0.95v 59.755n 0.95v 64.745n 0.95v 64.755n 0.95v 69.745n 0.95v 69.755n 0.95v 74.745n 0.95v 74.755n 0.95v 79.745n 0.95v 79.755n 0.95v 84.745n 0.95v 84.755n 0.95v 89.745n 0.95v 89.755n 0.95v 94.745n 0.95v 94.755n 0.95v 99.745n 0.95v 99.755n 0.95v 104.745n 0.95v 104.755n 0.95v 109.745n 0.95v 109.755n 0.95v 114.745n 0.95v 114.755n 0.95v 119.745n 0.95v 119.755n 0.95v 124.745n 0.95v 124.755n 0.95v 129.745n 0.95v 129.755n 0.95v 134.745n 0.95v 134.755n 0.95v 139.745n 0.95v 139.755n 0.95v 144.745n 0.95v 144.755n 0.95v 149.745n 0.95v 149.755n 0.95v 154.745n 0.95v 154.755n 0.95v 159.745n 0.95v 159.755n 0.0v 164.745n 0.0v 164.755n 0.95v 169.745n 0.95v 169.755n 0.95v 174.745n 0.95v 174.755n 0.95v 179.745n 0.95v 179.755n 0.95v 184.745n 0.95v 184.755n 0.95v 189.745n 0.95v 189.755n 0.95v 194.745n 0.95v 194.755n 0.95v 199.745n 0.95v 199.755n 0.95v 204.745n 0.95v 204.755n 0.95v 209.745n 0.95v 209.755n 0.95v 214.745n 0.95v 214.755n 0.95v 219.745n 0.95v 219.755n 0.95v 224.745n 0.95v 224.755n 0.95v 229.745n 0.95v 229.755n 0.95v 234.745n 0.95v 234.755n 0.95v 239.745n 0.95v 239.755n 0.95v 244.745n 0.95v 244.755n 0.95v 249.745n 0.95v 249.755n 0.95v 254.745n 0.95v 254.755n 0.95v 259.745n 0.95v 259.755n 0.95v 264.745n 0.95v 264.755n 0.0v 269.745n 0.0v 269.755n 0.0v 274.745n 0.0v 274.755n 0.0v 279.745n 0.0v 279.755n 0.0v 284.745n 0.0v 284.755n 0.0v 289.745n 0.0v 289.755n 0.0v 294.745n 0.0v 294.755n 0.0v 299.745n 0.0v 299.755n 0.0v 304.745n 0.0v 304.755n 0.0v 309.745n 0.0v 309.755n 0.0v 314.745n 0.0v 314.755n 0.0v 319.745n 0.0v 319.755n 0.95v 324.745n 0.95v 324.755n 0.95v 329.745n 0.95v 329.755n 0.0v 334.745n 0.0v 334.755n 0.0v 339.745n 0.0v 339.755n 0.0v 344.745n 0.0v 344.755n 0.0v 349.745n 0.0v 349.755n 0.0v 354.745n 0.0v 354.755n 0.0v 359.745n 0.0v 359.755n 0.0v 364.745n 0.0v 364.755n 0.0v 369.745n 0.0v 369.755n 0.0v 374.745n 0.0v 374.755n 0.0v 379.745n 0.0v 379.755n 0.0v 384.745n 0.0v 384.755n 0.0v 389.745n 0.0v 389.755n 0.0v 394.745n 0.0v 394.755n 0.0v 399.745n 0.0v 399.755n 0.0v 404.745n 0.0v 404.755n 0.0v 409.745n 0.0v 409.755n 0.95v 414.745n 0.95v 414.755n 0.95v 419.745n 0.95v 419.755n 0.95v 424.745n 0.95v 424.755n 0.0v 429.745n 0.0v 429.755n 0.0v 434.745n 0.0v 434.755n 0.0v 439.745n 0.0v 439.755n 0.0v 444.745n 0.0v 444.755n 0.0v 449.745n 0.0v 449.755n 0.0v 454.745n 0.0v 454.755n 0.0v 459.745n 0.0v 459.755n 0.0v 464.745n 0.0v 464.755n 0.0v 469.745n 0.0v 469.755n 0.0v 474.745n 0.0v 474.755n 0.0v 479.745n 0.0v 479.755n 0.0v 484.745n 0.0v 484.755n 0.0v 489.745n 0.0v 489.755n 0.0v 494.745n 0.0v 494.755n 0.0v 499.745n 0.0v 499.755n 0.0v 504.745n 0.0v 504.755n 0.0v 509.745n 0.0v 509.755n 0.95v 514.745n 0.95v 514.755n 0.95v 519.745n 0.95v 519.755n 0.95v 524.745n 0.95v 524.755n 0.0v 529.745n 0.0v 529.755n 0.0v 534.745n 0.0v 534.755n 0.0v 539.745n 0.0v 539.755n 0.0v 544.745n 0.0v 544.755n 0.0v 549.745n 0.0v 549.755n 0.95v 554.745n 0.95v 554.755n 0.95v 559.745n 0.95v 559.755n 0.95v 564.745n 0.95v 564.755n 0.95v 569.745n 0.95v 569.755n 0.95v 574.745n 0.95v 574.755n 0.95v 579.745n 0.95v 579.755n 0.95v 584.745n 0.95v 584.755n 0.95v 589.745n 0.95v 589.755n 0.95v 594.745n 0.95v 594.755n 0.95v 599.745n 0.95v 599.755n 0.95v 604.745n 0.95v 604.755n 0.95v 609.745n 0.95v 609.755n 0.95v 614.745n 0.95v 614.755n 0.0v 619.745n 0.0v 619.755n 0.0v 624.745n 0.0v 624.755n 0.0v 629.745n 0.0v 629.755n 0.0v 634.745n 0.0v 634.755n 0.0v 639.745n 0.0v 639.755n 0.0v 644.745n 0.0v 644.755n 0.0v 649.745n 0.0v 649.755n 0.0v 654.745n 0.0v 654.755n 0.95v 659.745n 0.95v 659.755n 0.95v 664.745n 0.95v 664.755n 0.95v 669.745n 0.95v 669.755n 0.95v 674.745n 0.95v 674.755n 0.95v 679.745n 0.95v 679.755n 0.95v 684.745n 0.95v 684.755n 0.95v 689.745n 0.95v 689.755n 0.95v 694.745n 0.95v 694.755n 0.95v 699.745n 0.95v 699.755n 0.95v 704.745n 0.95v 704.755n 0.95v 709.745n 0.95v 709.755n 0.95v 714.745n 0.95v 714.755n 0.95v 719.745n 0.95v 719.755n 0.95v 724.745n 0.95v 724.755n 0.95v 729.745n 0.95v 729.755n 0.95v 734.745n 0.95v 734.755n 0.95v 739.745n 0.95v 739.755n 0.95v 744.745n 0.95v 744.755n 0.95v 749.745n 0.95v 749.755n 0.95v 754.745n 0.95v 754.755n 0.95v 759.745n 0.95v 759.755n 0.95v 764.745n 0.95v 764.755n 0.95v 769.745n 0.95v 769.755n 0.95v 774.745n 0.95v 774.755n 0.95v 779.745n 0.95v 779.755n 0.95v 784.745n 0.95v 784.755n 0.95v 789.745n 0.95v 789.755n 0.95v 794.745n 0.95v 794.755n 0.95v 799.745n 0.95v 799.755n 0.95v 804.745n 0.95v 804.755n 0.95v 809.745n 0.95v 809.755n 0.95v 814.745n 0.95v 814.755n 0.95v 819.745n 0.95v 819.755n 0.0v 824.745n 0.0v 824.755n 0.0v 829.745n 0.0v 829.755n 0.95v 834.745n 0.95v 834.755n 0.95v 839.745n 0.95v 839.755n 0.95v 844.745n 0.95v 844.755n 0.0v 849.745n 0.0v 849.755n 0.0v 854.745n 0.0v 854.755n 0.0v 859.745n 0.0v 859.755n 0.95v 864.745n 0.95v 864.755n 0.95v 869.745n 0.95v 869.755n 0.95v 874.745n 0.95v 874.755n 0.95v 879.745n 0.95v 879.755n 0.95v 884.745n 0.95v 884.755n 0.95v 889.745n 0.95v 889.755n 0.95v 894.745n 0.95v 894.755n 0.95v 899.745n 0.95v 899.755n 0.95v 904.745n 0.95v 904.755n 0.95v 909.745n 0.95v 909.755n 0.95v 914.745n 0.95v 914.755n 0.95v 919.745n 0.95v 919.755n 0.95v 924.745n 0.95v 924.755n 0.95v 929.745n 0.95v 929.755n 0.95v 934.745n 0.95v 934.755n 0.0v 939.745n 0.0v 939.755n 0.95v 944.745n 0.95v 944.755n 0.95v 949.745n 0.95v 949.755n 0.95v 954.745n 0.95v 954.755n 0.95v 959.745n 0.95v 959.755n 0.95v 964.745n 0.95v 964.755n 0.95v 969.745n 0.95v 969.755n 0.0v 974.745n 0.0v 974.755n 0.0v 979.745n 0.0v 979.755n 0.0v 984.745n 0.0v 984.755n 0.0v 989.745n 0.0v 989.755n 0.0v 994.745n 0.0v 994.755n 0.0v 999.745n 0.0v 999.755n 0.0v 1004.745n 0.0v 1004.755n 0.0v 1009.745n 0.0v 1009.755n 0.0v 1014.745n 0.0v 1014.755n 0.0v 1019.745n 0.0v 1019.755n 0.0v 1024.745n 0.0v 1024.755n 0.0v )
* (time, data): [(0, 0), (5, 1), (10, 1), (15, 0), (20, 1), (25, 0), (30, 0), (35, 0), (40, 0), (45, 0), (50, 1), (55, 1), (60, 0), (65, 0), (70, 0), (75, 1), (80, 1), (85, 0), (90, 0), (95, 1), (100, 1), (105, 1), (110, 1), (115, 1), (120, 1), (125, 1), (130, 1), (135, 1), (140, 1), (145, 1), (150, 0), (155, 0), (160, 1), (165, 0), (170, 0), (175, 0), (180, 1), (185, 1), (190, 1), (195, 1), (200, 1), (205, 1), (210, 0), (215, 0), (220, 0), (225, 0), (230, 1), (235, 0), (240, 0), (245, 0), (250, 0), (255, 0), (260, 0), (265, 1), (270, 1), (275, 0), (280, 0), (285, 0), (290, 1), (295, 0), (300, 1), (305, 0), (310, 0), (315, 0), (320, 0), (325, 0), (330, 1), (335, 1), (340, 1), (345, 0), (350, 0), (355, 0), (360, 1), (365, 0), (370, 0), (375, 1), (380, 1), (385, 0), (390, 0), (395, 1), (400, 0), (405, 0), (410, 0), (415, 0), (420, 1), (425, 1), (430, 1), (435, 0), (440, 0), (445, 0), (450, 0), (455, 0), (460, 1), (465, 0), (470, 0), (475, 1), (480, 0), (485, 1), (490, 1), (495, 1), (500, 1), (505, 1), (510, 0), (515, 0), (520, 0), (525, 0), (530, 0), (535, 1), (540, 1), (545, 0), (550, 0), (555, 0), (560, 0), (565, 1), (570, 1), (575, 1), (580, 0), (585, 0), (590, 1), (595, 1), (600, 0), (605, 1), (610, 1), (615, 1), (620, 1), (625, 1), (630, 1), (635, 1), (640, 1), (645, 1), (650, 1), (655, 0), (660, 0), (665, 0), (670, 1), (675, 1), (680, 1), (685, 1), (690, 1), (695, 0), (700, 0), (705, 0), (710, 1), (715, 1), (720, 1), (725, 0), (730, 0), (735, 1), (740, 1), (745, 1), (750, 0), (755, 0), (760, 1), (765, 1), (770, 1), (775, 0), (780, 0), (785, 0), (790, 0), (795, 1), (800, 0), (805, 0), (810, 0), (815, 1), (820, 1), (825, 1), (830, 1), (835, 0), (840, 0), (845, 0), (850, 0), (855, 0), (860, 1), (865, 0), (870, 0), (875, 0), (880, 1), (885, 0), (890, 0), (895, 0), (900, 0), (905, 1), (910, 0), (915, 0), (920, 1), (925, 0), (930, 1), (935, 0), (940, 0), (945, 0), (950, 0), (955, 0), (960, 1), (965, 1), (970, 1), (975, 1), (980, 0), (985, 1), (990, 1), (995, 0), (1000, 1), (1005, 1), (1010, 1), (1015, 1), (1020, 0), (1025, 0)]
Va0_0  a0_0  0 PWL (0n 0.0v 4.745n 0.0v 4.755n 0.95v 9.745n 0.95v 9.755n 0.95v 14.745n 0.95v 14.755n 0.0v 19.745n 0.0v 19.755n 0.95v 24.745n 0.95v 24.755n 0.0v 29.745n 0.0v 29.755n 0.0v 34.745n 0.0v 34.755n 0.0v 39.745n 0.0v 39.755n 0.0v 44.745n 0.0v 44.755n 0.0v 49.745n 0.0v 49.755n 0.95v 54.745n 0.95v 54.755n 0.95v 59.745n 0.95v 59.755n 0.0v 64.745n 0.0v 64.755n 0.0v 69.745n 0.0v 69.755n 0.0v 74.745n 0.0v 74.755n 0.95v 79.745n 0.95v 79.755n 0.95v 84.745n 0.95v 84.755n 0.0v 89.745n 0.0v 89.755n 0.0v 94.745n 0.0v 94.755n 0.95v 99.745n 0.95v 99.755n 0.95v 104.745n 0.95v 104.755n 0.95v 109.745n 0.95v 109.755n 0.95v 114.745n 0.95v 114.755n 0.95v 119.745n 0.95v 119.755n 0.95v 124.745n 0.95v 124.755n 0.95v 129.745n 0.95v 129.755n 0.95v 134.745n 0.95v 134.755n 0.95v 139.745n 0.95v 139.755n 0.95v 144.745n 0.95v 144.755n 0.95v 149.745n 0.95v 149.755n 0.0v 154.745n 0.0v 154.755n 0.0v 159.745n 0.0v 159.755n 0.95v 164.745n 0.95v 164.755n 0.0v 169.745n 0.0v 169.755n 0.0v 174.745n 0.0v 174.755n 0.0v 179.745n 0.0v 179.755n 0.95v 184.745n 0.95v 184.755n 0.95v 189.745n 0.95v 189.755n 0.95v 194.745n 0.95v 194.755n 0.95v 199.745n 0.95v 199.755n 0.95v 204.745n 0.95v 204.755n 0.95v 209.745n 0.95v 209.755n 0.0v 214.745n 0.0v 214.755n 0.0v 219.745n 0.0v 219.755n 0.0v 224.745n 0.0v 224.755n 0.0v 229.745n 0.0v 229.755n 0.95v 234.745n 0.95v 234.755n 0.0v 239.745n 0.0v 239.755n 0.0v 244.745n 0.0v 244.755n 0.0v 249.745n 0.0v 249.755n 0.0v 254.745n 0.0v 254.755n 0.0v 259.745n 0.0v 259.755n 0.0v 264.745n 0.0v 264.755n 0.95v 269.745n 0.95v 269.755n 0.95v 274.745n 0.95v 274.755n 0.0v 279.745n 0.0v 279.755n 0.0v 284.745n 0.0v 284.755n 0.0v 289.745n 0.0v 289.755n 0.95v 294.745n 0.95v 294.755n 0.0v 299.745n 0.0v 299.755n 0.95v 304.745n 0.95v 304.755n 0.0v 309.745n 0.0v 309.755n 0.0v 314.745n 0.0v 314.755n 0.0v 319.745n 0.0v 319.755n 0.0v 324.745n 0.0v 324.755n 0.0v 329.745n 0.0v 329.755n 0.95v 334.745n 0.95v 334.755n 0.95v 339.745n 0.95v 339.755n 0.95v 344.745n 0.95v 344.755n 0.0v 349.745n 0.0v 349.755n 0.0v 354.745n 0.0v 354.755n 0.0v 359.745n 0.0v 359.755n 0.95v 364.745n 0.95v 364.755n 0.0v 369.745n 0.0v 369.755n 0.0v 374.745n 0.0v 374.755n 0.95v 379.745n 0.95v 379.755n 0.95v 384.745n 0.95v 384.755n 0.0v 389.745n 0.0v 389.755n 0.0v 394.745n 0.0v 394.755n 0.95v 399.745n 0.95v 399.755n 0.0v 404.745n 0.0v 404.755n 0.0v 409.745n 0.0v 409.755n 0.0v 414.745n 0.0v 414.755n 0.0v 419.745n 0.0v 419.755n 0.95v 424.745n 0.95v 424.755n 0.95v 429.745n 0.95v 429.755n 0.95v 434.745n 0.95v 434.755n 0.0v 439.745n 0.0v 439.755n 0.0v 444.745n 0.0v 444.755n 0.0v 449.745n 0.0v 449.755n 0.0v 454.745n 0.0v 454.755n 0.0v 459.745n 0.0v 459.755n 0.95v 464.745n 0.95v 464.755n 0.0v 469.745n 0.0v 469.755n 0.0v 474.745n 0.0v 474.755n 0.95v 479.745n 0.95v 479.755n 0.0v 484.745n 0.0v 484.755n 0.95v 489.745n 0.95v 489.755n 0.95v 494.745n 0.95v 494.755n 0.95v 499.745n 0.95v 499.755n 0.95v 504.745n 0.95v 504.755n 0.95v 509.745n 0.95v 509.755n 0.0v 514.745n 0.0v 514.755n 0.0v 519.745n 0.0v 519.755n 0.0v 524.745n 0.0v 524.755n 0.0v 529.745n 0.0v 529.755n 0.0v 534.745n 0.0v 534.755n 0.95v 539.745n 0.95v 539.755n 0.95v 544.745n 0.95v 544.755n 0.0v 549.745n 0.0v 549.755n 0.0v 554.745n 0.0v 554.755n 0.0v 559.745n 0.0v 559.755n 0.0v 564.745n 0.0v 564.755n 0.95v 569.745n 0.95v 569.755n 0.95v 574.745n 0.95v 574.755n 0.95v 579.745n 0.95v 579.755n 0.0v 584.745n 0.0v 584.755n 0.0v 589.745n 0.0v 589.755n 0.95v 594.745n 0.95v 594.755n 0.95v 599.745n 0.95v 599.755n 0.0v 604.745n 0.0v 604.755n 0.95v 609.745n 0.95v 609.755n 0.95v 614.745n 0.95v 614.755n 0.95v 619.745n 0.95v 619.755n 0.95v 624.745n 0.95v 624.755n 0.95v 629.745n 0.95v 629.755n 0.95v 634.745n 0.95v 634.755n 0.95v 639.745n 0.95v 639.755n 0.95v 644.745n 0.95v 644.755n 0.95v 649.745n 0.95v 649.755n 0.95v 654.745n 0.95v 654.755n 0.0v 659.745n 0.0v 659.755n 0.0v 664.745n 0.0v 664.755n 0.0v 669.745n 0.0v 669.755n 0.95v 674.745n 0.95v 674.755n 0.95v 679.745n 0.95v 679.755n 0.95v 684.745n 0.95v 684.755n 0.95v 689.745n 0.95v 689.755n 0.95v 694.745n 0.95v 694.755n 0.0v 699.745n 0.0v 699.755n 0.0v 704.745n 0.0v 704.755n 0.0v 709.745n 0.0v 709.755n 0.95v 714.745n 0.95v 714.755n 0.95v 719.745n 0.95v 719.755n 0.95v 724.745n 0.95v 724.755n 0.0v 729.745n 0.0v 729.755n 0.0v 734.745n 0.0v 734.755n 0.95v 739.745n 0.95v 739.755n 0.95v 744.745n 0.95v 744.755n 0.95v 749.745n 0.95v 749.755n 0.0v 754.745n 0.0v 754.755n 0.0v 759.745n 0.0v 759.755n 0.95v 764.745n 0.95v 764.755n 0.95v 769.745n 0.95v 769.755n 0.95v 774.745n 0.95v 774.755n 0.0v 779.745n 0.0v 779.755n 0.0v 784.745n 0.0v 784.755n 0.0v 789.745n 0.0v 789.755n 0.0v 794.745n 0.0v 794.755n 0.95v 799.745n 0.95v 799.755n 0.0v 804.745n 0.0v 804.755n 0.0v 809.745n 0.0v 809.755n 0.0v 814.745n 0.0v 814.755n 0.95v 819.745n 0.95v 819.755n 0.95v 824.745n 0.95v 824.755n 0.95v 829.745n 0.95v 829.755n 0.95v 834.745n 0.95v 834.755n 0.0v 839.745n 0.0v 839.755n 0.0v 844.745n 0.0v 844.755n 0.0v 849.745n 0.0v 849.755n 0.0v 854.745n 0.0v 854.755n 0.0v 859.745n 0.0v 859.755n 0.95v 864.745n 0.95v 864.755n 0.0v 869.745n 0.0v 869.755n 0.0v 874.745n 0.0v 874.755n 0.0v 879.745n 0.0v 879.755n 0.95v 884.745n 0.95v 884.755n 0.0v 889.745n 0.0v 889.755n 0.0v 894.745n 0.0v 894.755n 0.0v 899.745n 0.0v 899.755n 0.0v 904.745n 0.0v 904.755n 0.95v 909.745n 0.95v 909.755n 0.0v 914.745n 0.0v 914.755n 0.0v 919.745n 0.0v 919.755n 0.95v 924.745n 0.95v 924.755n 0.0v 929.745n 0.0v 929.755n 0.95v 934.745n 0.95v 934.755n 0.0v 939.745n 0.0v 939.755n 0.0v 944.745n 0.0v 944.755n 0.0v 949.745n 0.0v 949.755n 0.0v 954.745n 0.0v 954.755n 0.0v 959.745n 0.0v 959.755n 0.95v 964.745n 0.95v 964.755n 0.95v 969.745n 0.95v 969.755n 0.95v 974.745n 0.95v 974.755n 0.95v 979.745n 0.95v 979.755n 0.0v 984.745n 0.0v 984.755n 0.95v 989.745n 0.95v 989.755n 0.95v 994.745n 0.95v 994.755n 0.0v 999.745n 0.0v 999.755n 0.95v 1004.745n 0.95v 1004.755n 0.95v 1009.745n 0.95v 1009.755n 0.95v 1014.745n 0.95v 1014.755n 0.95v 1019.745n 0.95v 1019.755n 0.0v 1024.745n 0.0v 1024.755n 0.0v )
* (time, data): [(0, 0), (5, 0), (10, 0), (15, 0), (20, 0), (25, 0), (30, 0), (35, 0), (40, 0), (45, 0), (50, 1), (55, 1), (60, 0), (65, 0), (70, 0), (75, 1), (80, 0), (85, 0), (90, 0), (95, 1), (100, 1), (105, 1), (110, 1), (115, 0), (120, 1), (125, 1), (130, 0), (135, 0), (140, 0), (145, 0), (150, 1), (155, 0), (160, 1), (165, 1), (170, 0), (175, 0), (180, 1), (185, 0), (190, 0), (195, 0), (200, 1), (205, 0), (210, 1), (215, 1), (220, 1), (225, 1), (230, 0), (235, 1), (240, 0), (245, 1), (250, 1), (255, 1), (260, 1), (265, 0), (270, 1), (275, 0), (280, 1), (285, 1), (290, 1), (295, 1), (300, 0), (305, 0), (310, 0), (315, 0), (320, 1), (325, 1), (330, 0), (335, 0), (340, 0), (345, 1), (350, 1), (355, 1), (360, 1), (365, 1), (370, 1), (375, 1), (380, 1), (385, 0), (390, 0), (395, 1), (400, 1), (405, 1), (410, 1), (415, 1), (420, 0), (425, 0), (430, 0), (435, 0), (440, 0), (445, 0), (450, 1), (455, 1), (460, 1), (465, 0), (470, 1), (475, 0), (480, 1), (485, 1), (490, 1), (495, 1), (500, 1), (505, 1), (510, 1), (515, 1), (520, 0), (525, 1), (530, 1), (535, 0), (540, 0), (545, 1), (550, 1), (555, 1), (560, 1), (565, 0), (570, 1), (575, 1), (580, 1), (585, 1), (590, 0), (595, 0), (600, 0), (605, 1), (610, 1), (615, 1), (620, 1), (625, 0), (630, 1), (635, 1), (640, 0), (645, 1), (650, 1), (655, 1), (660, 1), (665, 0), (670, 0), (675, 0), (680, 0), (685, 0), (690, 0), (695, 0), (700, 1), (705, 1), (710, 0), (715, 0), (720, 0), (725, 1), (730, 1), (735, 0), (740, 1), (745, 1), (750, 0), (755, 0), (760, 0), (765, 1), (770, 0), (775, 0), (780, 1), (785, 1), (790, 0), (795, 1), (800, 1), (805, 1), (810, 0), (815, 1), (820, 0), (825, 1), (830, 1), (835, 0), (840, 1), (845, 0), (850, 0), (855, 0), (860, 0), (865, 1), (870, 1), (875, 0), (880, 1), (885, 0), (890, 1), (895, 1), (900, 0), (905, 0), (910, 0), (915, 0), (920, 0), (925, 1), (930, 0), (935, 1), (940, 0), (945, 0), (950, 0), (955, 0), (960, 0), (965, 0), (970, 0), (975, 1), (980, 1), (985, 0), (990, 0), (995, 0), (1000, 0), (1005, 0), (1010, 0), (1015, 0), (1020, 1), (1025, 1)]
Va0_1  a0_1  0 PWL (0n 0.0v 4.745n 0.0v 4.755n 0.0v 9.745n 0.0v 9.755n 0.0v 14.745n 0.0v 14.755n 0.0v 19.745n 0.0v 19.755n 0.0v 24.745n 0.0v 24.755n 0.0v 29.745n 0.0v 29.755n 0.0v 34.745n 0.0v 34.755n 0.0v 39.745n 0.0v 39.755n 0.0v 44.745n 0.0v 44.755n 0.0v 49.745n 0.0v 49.755n 0.95v 54.745n 0.95v 54.755n 0.95v 59.745n 0.95v 59.755n 0.0v 64.745n 0.0v 64.755n 0.0v 69.745n 0.0v 69.755n 0.0v 74.745n 0.0v 74.755n 0.95v 79.745n 0.95v 79.755n 0.0v 84.745n 0.0v 84.755n 0.0v 89.745n 0.0v 89.755n 0.0v 94.745n 0.0v 94.755n 0.95v 99.745n 0.95v 99.755n 0.95v 104.745n 0.95v 104.755n 0.95v 109.745n 0.95v 109.755n 0.95v 114.745n 0.95v 114.755n 0.0v 119.745n 0.0v 119.755n 0.95v 124.745n 0.95v 124.755n 0.95v 129.745n 0.95v 129.755n 0.0v 134.745n 0.0v 134.755n 0.0v 139.745n 0.0v 139.755n 0.0v 144.745n 0.0v 144.755n 0.0v 149.745n 0.0v 149.755n 0.95v 154.745n 0.95v 154.755n 0.0v 159.745n 0.0v 159.755n 0.95v 164.745n 0.95v 164.755n 0.95v 169.745n 0.95v 169.755n 0.0v 174.745n 0.0v 174.755n 0.0v 179.745n 0.0v 179.755n 0.95v 184.745n 0.95v 184.755n 0.0v 189.745n 0.0v 189.755n 0.0v 194.745n 0.0v 194.755n 0.0v 199.745n 0.0v 199.755n 0.95v 204.745n 0.95v 204.755n 0.0v 209.745n 0.0v 209.755n 0.95v 214.745n 0.95v 214.755n 0.95v 219.745n 0.95v 219.755n 0.95v 224.745n 0.95v 224.755n 0.95v 229.745n 0.95v 229.755n 0.0v 234.745n 0.0v 234.755n 0.95v 239.745n 0.95v 239.755n 0.0v 244.745n 0.0v 244.755n 0.95v 249.745n 0.95v 249.755n 0.95v 254.745n 0.95v 254.755n 0.95v 259.745n 0.95v 259.755n 0.95v 264.745n 0.95v 264.755n 0.0v 269.745n 0.0v 269.755n 0.95v 274.745n 0.95v 274.755n 0.0v 279.745n 0.0v 279.755n 0.95v 284.745n 0.95v 284.755n 0.95v 289.745n 0.95v 289.755n 0.95v 294.745n 0.95v 294.755n 0.95v 299.745n 0.95v 299.755n 0.0v 304.745n 0.0v 304.755n 0.0v 309.745n 0.0v 309.755n 0.0v 314.745n 0.0v 314.755n 0.0v 319.745n 0.0v 319.755n 0.95v 324.745n 0.95v 324.755n 0.95v 329.745n 0.95v 329.755n 0.0v 334.745n 0.0v 334.755n 0.0v 339.745n 0.0v 339.755n 0.0v 344.745n 0.0v 344.755n 0.95v 349.745n 0.95v 349.755n 0.95v 354.745n 0.95v 354.755n 0.95v 359.745n 0.95v 359.755n 0.95v 364.745n 0.95v 364.755n 0.95v 369.745n 0.95v 369.755n 0.95v 374.745n 0.95v 374.755n 0.95v 379.745n 0.95v 379.755n 0.95v 384.745n 0.95v 384.755n 0.0v 389.745n 0.0v 389.755n 0.0v 394.745n 0.0v 394.755n 0.95v 399.745n 0.95v 399.755n 0.95v 404.745n 0.95v 404.755n 0.95v 409.745n 0.95v 409.755n 0.95v 414.745n 0.95v 414.755n 0.95v 419.745n 0.95v 419.755n 0.0v 424.745n 0.0v 424.755n 0.0v 429.745n 0.0v 429.755n 0.0v 434.745n 0.0v 434.755n 0.0v 439.745n 0.0v 439.755n 0.0v 444.745n 0.0v 444.755n 0.0v 449.745n 0.0v 449.755n 0.95v 454.745n 0.95v 454.755n 0.95v 459.745n 0.95v 459.755n 0.95v 464.745n 0.95v 464.755n 0.0v 469.745n 0.0v 469.755n 0.95v 474.745n 0.95v 474.755n 0.0v 479.745n 0.0v 479.755n 0.95v 484.745n 0.95v 484.755n 0.95v 489.745n 0.95v 489.755n 0.95v 494.745n 0.95v 494.755n 0.95v 499.745n 0.95v 499.755n 0.95v 504.745n 0.95v 504.755n 0.95v 509.745n 0.95v 509.755n 0.95v 514.745n 0.95v 514.755n 0.95v 519.745n 0.95v 519.755n 0.0v 524.745n 0.0v 524.755n 0.95v 529.745n 0.95v 529.755n 0.95v 534.745n 0.95v 534.755n 0.0v 539.745n 0.0v 539.755n 0.0v 544.745n 0.0v 544.755n 0.95v 549.745n 0.95v 549.755n 0.95v 554.745n 0.95v 554.755n 0.95v 559.745n 0.95v 559.755n 0.95v 564.745n 0.95v 564.755n 0.0v 569.745n 0.0v 569.755n 0.95v 574.745n 0.95v 574.755n 0.95v 579.745n 0.95v 579.755n 0.95v 584.745n 0.95v 584.755n 0.95v 589.745n 0.95v 589.755n 0.0v 594.745n 0.0v 594.755n 0.0v 599.745n 0.0v 599.755n 0.0v 604.745n 0.0v 604.755n 0.95v 609.745n 0.95v 609.755n 0.95v 614.745n 0.95v 614.755n 0.95v 619.745n 0.95v 619.755n 0.95v 624.745n 0.95v 624.755n 0.0v 629.745n 0.0v 629.755n 0.95v 634.745n 0.95v 634.755n 0.95v 639.745n 0.95v 639.755n 0.0v 644.745n 0.0v 644.755n 0.95v 649.745n 0.95v 649.755n 0.95v 654.745n 0.95v 654.755n 0.95v 659.745n 0.95v 659.755n 0.95v 664.745n 0.95v 664.755n 0.0v 669.745n 0.0v 669.755n 0.0v 674.745n 0.0v 674.755n 0.0v 679.745n 0.0v 679.755n 0.0v 684.745n 0.0v 684.755n 0.0v 689.745n 0.0v 689.755n 0.0v 694.745n 0.0v 694.755n 0.0v 699.745n 0.0v 699.755n 0.95v 704.745n 0.95v 704.755n 0.95v 709.745n 0.95v 709.755n 0.0v 714.745n 0.0v 714.755n 0.0v 719.745n 0.0v 719.755n 0.0v 724.745n 0.0v 724.755n 0.95v 729.745n 0.95v 729.755n 0.95v 734.745n 0.95v 734.755n 0.0v 739.745n 0.0v 739.755n 0.95v 744.745n 0.95v 744.755n 0.95v 749.745n 0.95v 749.755n 0.0v 754.745n 0.0v 754.755n 0.0v 759.745n 0.0v 759.755n 0.0v 764.745n 0.0v 764.755n 0.95v 769.745n 0.95v 769.755n 0.0v 774.745n 0.0v 774.755n 0.0v 779.745n 0.0v 779.755n 0.95v 784.745n 0.95v 784.755n 0.95v 789.745n 0.95v 789.755n 0.0v 794.745n 0.0v 794.755n 0.95v 799.745n 0.95v 799.755n 0.95v 804.745n 0.95v 804.755n 0.95v 809.745n 0.95v 809.755n 0.0v 814.745n 0.0v 814.755n 0.95v 819.745n 0.95v 819.755n 0.0v 824.745n 0.0v 824.755n 0.95v 829.745n 0.95v 829.755n 0.95v 834.745n 0.95v 834.755n 0.0v 839.745n 0.0v 839.755n 0.95v 844.745n 0.95v 844.755n 0.0v 849.745n 0.0v 849.755n 0.0v 854.745n 0.0v 854.755n 0.0v 859.745n 0.0v 859.755n 0.0v 864.745n 0.0v 864.755n 0.95v 869.745n 0.95v 869.755n 0.95v 874.745n 0.95v 874.755n 0.0v 879.745n 0.0v 879.755n 0.95v 884.745n 0.95v 884.755n 0.0v 889.745n 0.0v 889.755n 0.95v 894.745n 0.95v 894.755n 0.95v 899.745n 0.95v 899.755n 0.0v 904.745n 0.0v 904.755n 0.0v 909.745n 0.0v 909.755n 0.0v 914.745n 0.0v 914.755n 0.0v 919.745n 0.0v 919.755n 0.0v 924.745n 0.0v 924.755n 0.95v 929.745n 0.95v 929.755n 0.0v 934.745n 0.0v 934.755n 0.95v 939.745n 0.95v 939.755n 0.0v 944.745n 0.0v 944.755n 0.0v 949.745n 0.0v 949.755n 0.0v 954.745n 0.0v 954.755n 0.0v 959.745n 0.0v 959.755n 0.0v 964.745n 0.0v 964.755n 0.0v 969.745n 0.0v 969.755n 0.0v 974.745n 0.0v 974.755n 0.95v 979.745n 0.95v 979.755n 0.95v 984.745n 0.95v 984.755n 0.0v 989.745n 0.0v 989.755n 0.0v 994.745n 0.0v 994.755n 0.0v 999.745n 0.0v 999.755n 0.0v 1004.745n 0.0v 1004.755n 0.0v 1009.745n 0.0v 1009.755n 0.0v 1014.745n 0.0v 1014.755n 0.0v 1019.745n 0.0v 1019.755n 0.95v 1024.745n 0.95v 1024.755n 0.95v )
* (time, data): [(0, 0), (5, 1), (10, 1), (15, 1), (20, 1), (25, 1), (30, 1), (35, 1), (40, 1), (45, 1), (50, 0), (55, 0), (60, 1), (65, 1), (70, 1), (75, 0), (80, 1), (85, 1), (90, 1), (95, 0), (100, 0), (105, 0), (110, 0), (115, 1), (120, 0), (125, 0), (130, 1), (135, 1), (140, 1), (145, 1), (150, 1), (155, 1), (160, 1), (165, 1), (170, 1), (175, 1), (180, 0), (185, 1), (190, 1), (195, 1), (200, 1), (205, 1), (210, 1), (215, 1), (220, 1), (225, 1), (230, 1), (235, 1), (240, 0), (245, 1), (250, 1), (255, 1), (260, 1), (265, 1), (270, 1), (275, 1), (280, 1), (285, 1), (290, 0), (295, 1), (300, 1), (305, 1), (310, 1), (315, 1), (320, 0), (325, 1), (330, 1), (335, 1), (340, 1), (345, 0), (350, 0), (355, 0), (360, 1), (365, 1), (370, 1), (375, 0), (380, 0), (385, 1), (390, 1), (395, 0), (400, 0), (405, 0), (410, 0), (415, 0), (420, 1), (425, 0), (430, 0), (435, 0), (440, 0), (445, 0), (450, 1), (455, 1), (460, 0), (465, 0), (470, 1), (475, 1), (480, 1), (485, 0), (490, 0), (495, 0), (500, 0), (505, 0), (510, 0), (515, 0), (520, 1), (525, 0), (530, 1), (535, 1), (540, 1), (545, 1), (550, 1), (555, 1), (560, 0), (565, 0), (570, 1), (575, 1), (580, 1), (585, 0), (590, 0), (595, 1), (600, 1), (605, 0), (610, 0), (615, 1), (620, 1), (625, 0), (630, 1), (635, 1), (640, 0), (645, 0), (650, 0), (655, 0), (660, 0), (665, 1), (670, 1), (675, 0), (680, 0), (685, 0), (690, 0), (695, 1), (700, 1), (705, 1), (710, 1), (715, 1), (720, 1), (725, 0), (730, 0), (735, 1), (740, 1), (745, 1), (750, 1), (755, 1), (760, 0), (765, 1), (770, 0), (775, 0), (780, 1), (785, 0), (790, 1), (795, 1), (800, 1), (805, 1), (810, 1), (815, 0), (820, 1), (825, 0), (830, 0), (835, 1), (840, 1), (845, 0), (850, 0), (855, 0), (860, 0), (865, 0), (870, 0), (875, 0), (880, 1), (885, 1), (890, 1), (895, 0), (900, 1), (905, 0), (910, 0), (915, 0), (920, 1), (925, 0), (930, 0), (935, 1), (940, 0), (945, 1), (950, 0), (955, 0), (960, 0), (965, 1), (970, 1), (975, 0), (980, 1), (985, 1), (990, 1), (995, 0), (1000, 0), (1005, 0), (1010, 0), (1015, 0), (1020, 1), (1025, 1)]
Va0_2  a0_2  0 PWL (0n 0.0v 4.745n 0.0v 4.755n 0.95v 9.745n 0.95v 9.755n 0.95v 14.745n 0.95v 14.755n 0.95v 19.745n 0.95v 19.755n 0.95v 24.745n 0.95v 24.755n 0.95v 29.745n 0.95v 29.755n 0.95v 34.745n 0.95v 34.755n 0.95v 39.745n 0.95v 39.755n 0.95v 44.745n 0.95v 44.755n 0.95v 49.745n 0.95v 49.755n 0.0v 54.745n 0.0v 54.755n 0.0v 59.745n 0.0v 59.755n 0.95v 64.745n 0.95v 64.755n 0.95v 69.745n 0.95v 69.755n 0.95v 74.745n 0.95v 74.755n 0.0v 79.745n 0.0v 79.755n 0.95v 84.745n 0.95v 84.755n 0.95v 89.745n 0.95v 89.755n 0.95v 94.745n 0.95v 94.755n 0.0v 99.745n 0.0v 99.755n 0.0v 104.745n 0.0v 104.755n 0.0v 109.745n 0.0v 109.755n 0.0v 114.745n 0.0v 114.755n 0.95v 119.745n 0.95v 119.755n 0.0v 124.745n 0.0v 124.755n 0.0v 129.745n 0.0v 129.755n 0.95v 134.745n 0.95v 134.755n 0.95v 139.745n 0.95v 139.755n 0.95v 144.745n 0.95v 144.755n 0.95v 149.745n 0.95v 149.755n 0.95v 154.745n 0.95v 154.755n 0.95v 159.745n 0.95v 159.755n 0.95v 164.745n 0.95v 164.755n 0.95v 169.745n 0.95v 169.755n 0.95v 174.745n 0.95v 174.755n 0.95v 179.745n 0.95v 179.755n 0.0v 184.745n 0.0v 184.755n 0.95v 189.745n 0.95v 189.755n 0.95v 194.745n 0.95v 194.755n 0.95v 199.745n 0.95v 199.755n 0.95v 204.745n 0.95v 204.755n 0.95v 209.745n 0.95v 209.755n 0.95v 214.745n 0.95v 214.755n 0.95v 219.745n 0.95v 219.755n 0.95v 224.745n 0.95v 224.755n 0.95v 229.745n 0.95v 229.755n 0.95v 234.745n 0.95v 234.755n 0.95v 239.745n 0.95v 239.755n 0.0v 244.745n 0.0v 244.755n 0.95v 249.745n 0.95v 249.755n 0.95v 254.745n 0.95v 254.755n 0.95v 259.745n 0.95v 259.755n 0.95v 264.745n 0.95v 264.755n 0.95v 269.745n 0.95v 269.755n 0.95v 274.745n 0.95v 274.755n 0.95v 279.745n 0.95v 279.755n 0.95v 284.745n 0.95v 284.755n 0.95v 289.745n 0.95v 289.755n 0.0v 294.745n 0.0v 294.755n 0.95v 299.745n 0.95v 299.755n 0.95v 304.745n 0.95v 304.755n 0.95v 309.745n 0.95v 309.755n 0.95v 314.745n 0.95v 314.755n 0.95v 319.745n 0.95v 319.755n 0.0v 324.745n 0.0v 324.755n 0.95v 329.745n 0.95v 329.755n 0.95v 334.745n 0.95v 334.755n 0.95v 339.745n 0.95v 339.755n 0.95v 344.745n 0.95v 344.755n 0.0v 349.745n 0.0v 349.755n 0.0v 354.745n 0.0v 354.755n 0.0v 359.745n 0.0v 359.755n 0.95v 364.745n 0.95v 364.755n 0.95v 369.745n 0.95v 369.755n 0.95v 374.745n 0.95v 374.755n 0.0v 379.745n 0.0v 379.755n 0.0v 384.745n 0.0v 384.755n 0.95v 389.745n 0.95v 389.755n 0.95v 394.745n 0.95v 394.755n 0.0v 399.745n 0.0v 399.755n 0.0v 404.745n 0.0v 404.755n 0.0v 409.745n 0.0v 409.755n 0.0v 414.745n 0.0v 414.755n 0.0v 419.745n 0.0v 419.755n 0.95v 424.745n 0.95v 424.755n 0.0v 429.745n 0.0v 429.755n 0.0v 434.745n 0.0v 434.755n 0.0v 439.745n 0.0v 439.755n 0.0v 444.745n 0.0v 444.755n 0.0v 449.745n 0.0v 449.755n 0.95v 454.745n 0.95v 454.755n 0.95v 459.745n 0.95v 459.755n 0.0v 464.745n 0.0v 464.755n 0.0v 469.745n 0.0v 469.755n 0.95v 474.745n 0.95v 474.755n 0.95v 479.745n 0.95v 479.755n 0.95v 484.745n 0.95v 484.755n 0.0v 489.745n 0.0v 489.755n 0.0v 494.745n 0.0v 494.755n 0.0v 499.745n 0.0v 499.755n 0.0v 504.745n 0.0v 504.755n 0.0v 509.745n 0.0v 509.755n 0.0v 514.745n 0.0v 514.755n 0.0v 519.745n 0.0v 519.755n 0.95v 524.745n 0.95v 524.755n 0.0v 529.745n 0.0v 529.755n 0.95v 534.745n 0.95v 534.755n 0.95v 539.745n 0.95v 539.755n 0.95v 544.745n 0.95v 544.755n 0.95v 549.745n 0.95v 549.755n 0.95v 554.745n 0.95v 554.755n 0.95v 559.745n 0.95v 559.755n 0.0v 564.745n 0.0v 564.755n 0.0v 569.745n 0.0v 569.755n 0.95v 574.745n 0.95v 574.755n 0.95v 579.745n 0.95v 579.755n 0.95v 584.745n 0.95v 584.755n 0.0v 589.745n 0.0v 589.755n 0.0v 594.745n 0.0v 594.755n 0.95v 599.745n 0.95v 599.755n 0.95v 604.745n 0.95v 604.755n 0.0v 609.745n 0.0v 609.755n 0.0v 614.745n 0.0v 614.755n 0.95v 619.745n 0.95v 619.755n 0.95v 624.745n 0.95v 624.755n 0.0v 629.745n 0.0v 629.755n 0.95v 634.745n 0.95v 634.755n 0.95v 639.745n 0.95v 639.755n 0.0v 644.745n 0.0v 644.755n 0.0v 649.745n 0.0v 649.755n 0.0v 654.745n 0.0v 654.755n 0.0v 659.745n 0.0v 659.755n 0.0v 664.745n 0.0v 664.755n 0.95v 669.745n 0.95v 669.755n 0.95v 674.745n 0.95v 674.755n 0.0v 679.745n 0.0v 679.755n 0.0v 684.745n 0.0v 684.755n 0.0v 689.745n 0.0v 689.755n 0.0v 694.745n 0.0v 694.755n 0.95v 699.745n 0.95v 699.755n 0.95v 704.745n 0.95v 704.755n 0.95v 709.745n 0.95v 709.755n 0.95v 714.745n 0.95v 714.755n 0.95v 719.745n 0.95v 719.755n 0.95v 724.745n 0.95v 724.755n 0.0v 729.745n 0.0v 729.755n 0.0v 734.745n 0.0v 734.755n 0.95v 739.745n 0.95v 739.755n 0.95v 744.745n 0.95v 744.755n 0.95v 749.745n 0.95v 749.755n 0.95v 754.745n 0.95v 754.755n 0.95v 759.745n 0.95v 759.755n 0.0v 764.745n 0.0v 764.755n 0.95v 769.745n 0.95v 769.755n 0.0v 774.745n 0.0v 774.755n 0.0v 779.745n 0.0v 779.755n 0.95v 784.745n 0.95v 784.755n 0.0v 789.745n 0.0v 789.755n 0.95v 794.745n 0.95v 794.755n 0.95v 799.745n 0.95v 799.755n 0.95v 804.745n 0.95v 804.755n 0.95v 809.745n 0.95v 809.755n 0.95v 814.745n 0.95v 814.755n 0.0v 819.745n 0.0v 819.755n 0.95v 824.745n 0.95v 824.755n 0.0v 829.745n 0.0v 829.755n 0.0v 834.745n 0.0v 834.755n 0.95v 839.745n 0.95v 839.755n 0.95v 844.745n 0.95v 844.755n 0.0v 849.745n 0.0v 849.755n 0.0v 854.745n 0.0v 854.755n 0.0v 859.745n 0.0v 859.755n 0.0v 864.745n 0.0v 864.755n 0.0v 869.745n 0.0v 869.755n 0.0v 874.745n 0.0v 874.755n 0.0v 879.745n 0.0v 879.755n 0.95v 884.745n 0.95v 884.755n 0.95v 889.745n 0.95v 889.755n 0.95v 894.745n 0.95v 894.755n 0.0v 899.745n 0.0v 899.755n 0.95v 904.745n 0.95v 904.755n 0.0v 909.745n 0.0v 909.755n 0.0v 914.745n 0.0v 914.755n 0.0v 919.745n 0.0v 919.755n 0.95v 924.745n 0.95v 924.755n 0.0v 929.745n 0.0v 929.755n 0.0v 934.745n 0.0v 934.755n 0.95v 939.745n 0.95v 939.755n 0.0v 944.745n 0.0v 944.755n 0.95v 949.745n 0.95v 949.755n 0.0v 954.745n 0.0v 954.755n 0.0v 959.745n 0.0v 959.755n 0.0v 964.745n 0.0v 964.755n 0.95v 969.745n 0.95v 969.755n 0.95v 974.745n 0.95v 974.755n 0.0v 979.745n 0.0v 979.755n 0.95v 984.745n 0.95v 984.755n 0.95v 989.745n 0.95v 989.755n 0.95v 994.745n 0.95v 994.755n 0.0v 999.745n 0.0v 999.755n 0.0v 1004.745n 0.0v 1004.755n 0.0v 1009.745n 0.0v 1009.755n 0.0v 1014.745n 0.0v 1014.755n 0.0v 1019.745n 0.0v 1019.755n 0.95v 1024.745n 0.95v 1024.755n 0.95v )
* (time, data): [(0, 0), (5, 1), (10, 1), (15, 1), (20, 1), (25, 1), (30, 1), (35, 1), (40, 1), (45, 1), (50, 0), (55, 0), (60, 1), (65, 1), (70, 1), (75, 0), (80, 1), (85, 1), (90, 1), (95, 1), (100, 1), (105, 1), (110, 1), (115, 1), (120, 0), (125, 0), (130, 1), (135, 1), (140, 1), (145, 1), (150, 0), (155, 1), (160, 0), (165, 1), (170, 1), (175, 1), (180, 1), (185, 1), (190, 1), (195, 1), (200, 0), (205, 1), (210, 1), (215, 1), (220, 0), (225, 0), (230, 1), (235, 1), (240, 0), (245, 1), (250, 1), (255, 1), (260, 1), (265, 1), (270, 0), (275, 1), (280, 1), (285, 1), (290, 1), (295, 1), (300, 1), (305, 1), (310, 1), (315, 1), (320, 1), (325, 1), (330, 0), (335, 0), (340, 0), (345, 1), (350, 1), (355, 1), (360, 0), (365, 0), (370, 0), (375, 1), (380, 1), (385, 1), (390, 1), (395, 0), (400, 1), (405, 1), (410, 0), (415, 1), (420, 0), (425, 0), (430, 0), (435, 0), (440, 0), (445, 0), (450, 0), (455, 0), (460, 0), (465, 0), (470, 0), (475, 1), (480, 1), (485, 0), (490, 1), (495, 1), (500, 1), (505, 1), (510, 0), (515, 0), (520, 1), (525, 1), (530, 1), (535, 0), (540, 0), (545, 0), (550, 0), (555, 0), (560, 0), (565, 0), (570, 0), (575, 0), (580, 1), (585, 0), (590, 1), (595, 1), (600, 0), (605, 0), (610, 1), (615, 0), (620, 0), (625, 0), (630, 0), (635, 0), (640, 0), (645, 1), (650, 1), (655, 0), (660, 0), (665, 0), (670, 1), (675, 0), (680, 0), (685, 0), (690, 0), (695, 1), (700, 1), (705, 1), (710, 0), (715, 0), (720, 1), (725, 0), (730, 0), (735, 0), (740, 0), (745, 0), (750, 0), (755, 0), (760, 0), (765, 0), (770, 1), (775, 0), (780, 0), (785, 1), (790, 1), (795, 0), (800, 1), (805, 1), (810, 1), (815, 1), (820, 1), (825, 1), (830, 0), (835, 1), (840, 0), (845, 1), (850, 0), (855, 0), (860, 1), (865, 0), (870, 0), (875, 1), (880, 0), (885, 1), (890, 0), (895, 0), (900, 1), (905, 1), (910, 0), (915, 0), (920, 0), (925, 1), (930, 0), (935, 0), (940, 1), (945, 0), (950, 1), (955, 1), (960, 1), (965, 0), (970, 0), (975, 1), (980, 0), (985, 0), (990, 0), (995, 1), (1000, 1), (1005, 1), (1010, 1), (1015, 1), (1020, 1), (1025, 1)]
Va0_3  a0_3  0 PWL (0n 0.0v 4.745n 0.0v 4.755n 0.95v 9.745n 0.95v 9.755n 0.95v 14.745n 0.95v 14.755n 0.95v 19.745n 0.95v 19.755n 0.95v 24.745n 0.95v 24.755n 0.95v 29.745n 0.95v 29.755n 0.95v 34.745n 0.95v 34.755n 0.95v 39.745n 0.95v 39.755n 0.95v 44.745n 0.95v 44.755n 0.95v 49.745n 0.95v 49.755n 0.0v 54.745n 0.0v 54.755n 0.0v 59.745n 0.0v 59.755n 0.95v 64.745n 0.95v 64.755n 0.95v 69.745n 0.95v 69.755n 0.95v 74.745n 0.95v 74.755n 0.0v 79.745n 0.0v 79.755n 0.95v 84.745n 0.95v 84.755n 0.95v 89.745n 0.95v 89.755n 0.95v 94.745n 0.95v 94.755n 0.95v 99.745n 0.95v 99.755n 0.95v 104.745n 0.95v 104.755n 0.95v 109.745n 0.95v 109.755n 0.95v 114.745n 0.95v 114.755n 0.95v 119.745n 0.95v 119.755n 0.0v 124.745n 0.0v 124.755n 0.0v 129.745n 0.0v 129.755n 0.95v 134.745n 0.95v 134.755n 0.95v 139.745n 0.95v 139.755n 0.95v 144.745n 0.95v 144.755n 0.95v 149.745n 0.95v 149.755n 0.0v 154.745n 0.0v 154.755n 0.95v 159.745n 0.95v 159.755n 0.0v 164.745n 0.0v 164.755n 0.95v 169.745n 0.95v 169.755n 0.95v 174.745n 0.95v 174.755n 0.95v 179.745n 0.95v 179.755n 0.95v 184.745n 0.95v 184.755n 0.95v 189.745n 0.95v 189.755n 0.95v 194.745n 0.95v 194.755n 0.95v 199.745n 0.95v 199.755n 0.0v 204.745n 0.0v 204.755n 0.95v 209.745n 0.95v 209.755n 0.95v 214.745n 0.95v 214.755n 0.95v 219.745n 0.95v 219.755n 0.0v 224.745n 0.0v 224.755n 0.0v 229.745n 0.0v 229.755n 0.95v 234.745n 0.95v 234.755n 0.95v 239.745n 0.95v 239.755n 0.0v 244.745n 0.0v 244.755n 0.95v 249.745n 0.95v 249.755n 0.95v 254.745n 0.95v 254.755n 0.95v 259.745n 0.95v 259.755n 0.95v 264.745n 0.95v 264.755n 0.95v 269.745n 0.95v 269.755n 0.0v 274.745n 0.0v 274.755n 0.95v 279.745n 0.95v 279.755n 0.95v 284.745n 0.95v 284.755n 0.95v 289.745n 0.95v 289.755n 0.95v 294.745n 0.95v 294.755n 0.95v 299.745n 0.95v 299.755n 0.95v 304.745n 0.95v 304.755n 0.95v 309.745n 0.95v 309.755n 0.95v 314.745n 0.95v 314.755n 0.95v 319.745n 0.95v 319.755n 0.95v 324.745n 0.95v 324.755n 0.95v 329.745n 0.95v 329.755n 0.0v 334.745n 0.0v 334.755n 0.0v 339.745n 0.0v 339.755n 0.0v 344.745n 0.0v 344.755n 0.95v 349.745n 0.95v 349.755n 0.95v 354.745n 0.95v 354.755n 0.95v 359.745n 0.95v 359.755n 0.0v 364.745n 0.0v 364.755n 0.0v 369.745n 0.0v 369.755n 0.0v 374.745n 0.0v 374.755n 0.95v 379.745n 0.95v 379.755n 0.95v 384.745n 0.95v 384.755n 0.95v 389.745n 0.95v 389.755n 0.95v 394.745n 0.95v 394.755n 0.0v 399.745n 0.0v 399.755n 0.95v 404.745n 0.95v 404.755n 0.95v 409.745n 0.95v 409.755n 0.0v 414.745n 0.0v 414.755n 0.95v 419.745n 0.95v 419.755n 0.0v 424.745n 0.0v 424.755n 0.0v 429.745n 0.0v 429.755n 0.0v 434.745n 0.0v 434.755n 0.0v 439.745n 0.0v 439.755n 0.0v 444.745n 0.0v 444.755n 0.0v 449.745n 0.0v 449.755n 0.0v 454.745n 0.0v 454.755n 0.0v 459.745n 0.0v 459.755n 0.0v 464.745n 0.0v 464.755n 0.0v 469.745n 0.0v 469.755n 0.0v 474.745n 0.0v 474.755n 0.95v 479.745n 0.95v 479.755n 0.95v 484.745n 0.95v 484.755n 0.0v 489.745n 0.0v 489.755n 0.95v 494.745n 0.95v 494.755n 0.95v 499.745n 0.95v 499.755n 0.95v 504.745n 0.95v 504.755n 0.95v 509.745n 0.95v 509.755n 0.0v 514.745n 0.0v 514.755n 0.0v 519.745n 0.0v 519.755n 0.95v 524.745n 0.95v 524.755n 0.95v 529.745n 0.95v 529.755n 0.95v 534.745n 0.95v 534.755n 0.0v 539.745n 0.0v 539.755n 0.0v 544.745n 0.0v 544.755n 0.0v 549.745n 0.0v 549.755n 0.0v 554.745n 0.0v 554.755n 0.0v 559.745n 0.0v 559.755n 0.0v 564.745n 0.0v 564.755n 0.0v 569.745n 0.0v 569.755n 0.0v 574.745n 0.0v 574.755n 0.0v 579.745n 0.0v 579.755n 0.95v 584.745n 0.95v 584.755n 0.0v 589.745n 0.0v 589.755n 0.95v 594.745n 0.95v 594.755n 0.95v 599.745n 0.95v 599.755n 0.0v 604.745n 0.0v 604.755n 0.0v 609.745n 0.0v 609.755n 0.95v 614.745n 0.95v 614.755n 0.0v 619.745n 0.0v 619.755n 0.0v 624.745n 0.0v 624.755n 0.0v 629.745n 0.0v 629.755n 0.0v 634.745n 0.0v 634.755n 0.0v 639.745n 0.0v 639.755n 0.0v 644.745n 0.0v 644.755n 0.95v 649.745n 0.95v 649.755n 0.95v 654.745n 0.95v 654.755n 0.0v 659.745n 0.0v 659.755n 0.0v 664.745n 0.0v 664.755n 0.0v 669.745n 0.0v 669.755n 0.95v 674.745n 0.95v 674.755n 0.0v 679.745n 0.0v 679.755n 0.0v 684.745n 0.0v 684.755n 0.0v 689.745n 0.0v 689.755n 0.0v 694.745n 0.0v 694.755n 0.95v 699.745n 0.95v 699.755n 0.95v 704.745n 0.95v 704.755n 0.95v 709.745n 0.95v 709.755n 0.0v 714.745n 0.0v 714.755n 0.0v 719.745n 0.0v 719.755n 0.95v 724.745n 0.95v 724.755n 0.0v 729.745n 0.0v 729.755n 0.0v 734.745n 0.0v 734.755n 0.0v 739.745n 0.0v 739.755n 0.0v 744.745n 0.0v 744.755n 0.0v 749.745n 0.0v 749.755n 0.0v 754.745n 0.0v 754.755n 0.0v 759.745n 0.0v 759.755n 0.0v 764.745n 0.0v 764.755n 0.0v 769.745n 0.0v 769.755n 0.95v 774.745n 0.95v 774.755n 0.0v 779.745n 0.0v 779.755n 0.0v 784.745n 0.0v 784.755n 0.95v 789.745n 0.95v 789.755n 0.95v 794.745n 0.95v 794.755n 0.0v 799.745n 0.0v 799.755n 0.95v 804.745n 0.95v 804.755n 0.95v 809.745n 0.95v 809.755n 0.95v 814.745n 0.95v 814.755n 0.95v 819.745n 0.95v 819.755n 0.95v 824.745n 0.95v 824.755n 0.95v 829.745n 0.95v 829.755n 0.0v 834.745n 0.0v 834.755n 0.95v 839.745n 0.95v 839.755n 0.0v 844.745n 0.0v 844.755n 0.95v 849.745n 0.95v 849.755n 0.0v 854.745n 0.0v 854.755n 0.0v 859.745n 0.0v 859.755n 0.95v 864.745n 0.95v 864.755n 0.0v 869.745n 0.0v 869.755n 0.0v 874.745n 0.0v 874.755n 0.95v 879.745n 0.95v 879.755n 0.0v 884.745n 0.0v 884.755n 0.95v 889.745n 0.95v 889.755n 0.0v 894.745n 0.0v 894.755n 0.0v 899.745n 0.0v 899.755n 0.95v 904.745n 0.95v 904.755n 0.95v 909.745n 0.95v 909.755n 0.0v 914.745n 0.0v 914.755n 0.0v 919.745n 0.0v 919.755n 0.0v 924.745n 0.0v 924.755n 0.95v 929.745n 0.95v 929.755n 0.0v 934.745n 0.0v 934.755n 0.0v 939.745n 0.0v 939.755n 0.95v 944.745n 0.95v 944.755n 0.0v 949.745n 0.0v 949.755n 0.95v 954.745n 0.95v 954.755n 0.95v 959.745n 0.95v 959.755n 0.95v 964.745n 0.95v 964.755n 0.0v 969.745n 0.0v 969.755n 0.0v 974.745n 0.0v 974.755n 0.95v 979.745n 0.95v 979.755n 0.0v 984.745n 0.0v 984.755n 0.0v 989.745n 0.0v 989.755n 0.0v 994.745n 0.0v 994.755n 0.95v 999.745n 0.95v 999.755n 0.95v 1004.745n 0.95v 1004.755n 0.95v 1009.745n 0.95v 1009.755n 0.95v 1014.745n 0.95v 1014.755n 0.95v 1019.745n 0.95v 1019.755n 0.95v 1024.745n 0.95v 1024.755n 0.95v )
* (time, data): [(0, 0), (5, 1), (10, 1), (15, 1), (20, 1), (25, 1), (30, 1), (35, 1), (40, 1), (45, 1), (50, 0), (55, 0), (60, 1), (65, 1), (70, 1), (75, 0), (80, 1), (85, 1), (90, 1), (95, 1), (100, 1), (105, 1), (110, 1), (115, 1), (120, 0), (125, 0), (130, 1), (135, 1), (140, 1), (145, 1), (150, 0), (155, 1), (160, 1), (165, 1), (170, 1), (175, 1), (180, 1), (185, 1), (190, 1), (195, 1), (200, 1), (205, 1), (210, 1), (215, 1), (220, 0), (225, 0), (230, 1), (235, 1), (240, 0), (245, 1), (250, 1), (255, 1), (260, 1), (265, 1), (270, 1), (275, 1), (280, 1), (285, 1), (290, 1), (295, 1), (300, 1), (305, 1), (310, 1), (315, 1), (320, 1), (325, 1), (330, 0), (335, 0), (340, 0), (345, 1), (350, 1), (355, 1), (360, 1), (365, 0), (370, 0), (375, 1), (380, 1), (385, 1), (390, 1), (395, 0), (400, 1), (405, 1), (410, 0), (415, 1), (420, 0), (425, 0), (430, 0), (435, 0), (440, 0), (445, 0), (450, 0), (455, 0), (460, 0), (465, 0), (470, 0), (475, 1), (480, 1), (485, 0), (490, 1), (495, 1), (500, 1), (505, 1), (510, 0), (515, 0), (520, 1), (525, 1), (530, 1), (535, 0), (540, 0), (545, 0), (550, 0), (555, 0), (560, 0), (565, 0), (570, 1), (575, 1), (580, 1), (585, 0), (590, 1), (595, 1), (600, 0), (605, 0), (610, 1), (615, 1), (620, 1), (625, 0), (630, 1), (635, 1), (640, 0), (645, 1), (650, 1), (655, 0), (660, 0), (665, 0), (670, 1), (675, 0), (680, 0), (685, 0), (690, 0), (695, 1), (700, 1), (705, 1), (710, 0), (715, 0), (720, 1), (725, 0), (730, 0), (735, 0), (740, 1), (745, 1), (750, 0), (755, 0), (760, 0), (765, 1), (770, 1), (775, 0), (780, 0), (785, 1), (790, 1), (795, 1), (800, 1), (805, 1), (810, 1), (815, 1), (820, 1), (825, 1), (830, 0), (835, 1), (840, 0), (845, 1), (850, 0), (855, 0), (860, 1), (865, 0), (870, 0), (875, 1), (880, 1), (885, 1), (890, 0), (895, 0), (900, 1), (905, 1), (910, 0), (915, 0), (920, 0), (925, 1), (930, 0), (935, 0), (940, 1), (945, 0), (950, 1), (955, 1), (960, 1), (965, 0), (970, 0), (975, 1), (980, 0), (985, 0), (990, 0), (995, 1), (1000, 1), (1005, 1), (1010, 1), (1015, 1), (1020, 1), (1025, 1)]
Va0_4  a0_4  0 PWL (0n 0.0v 4.745n 0.0v 4.755n 0.95v 9.745n 0.95v 9.755n 0.95v 14.745n 0.95v 14.755n 0.95v 19.745n 0.95v 19.755n 0.95v 24.745n 0.95v 24.755n 0.95v 29.745n 0.95v 29.755n 0.95v 34.745n 0.95v 34.755n 0.95v 39.745n 0.95v 39.755n 0.95v 44.745n 0.95v 44.755n 0.95v 49.745n 0.95v 49.755n 0.0v 54.745n 0.0v 54.755n 0.0v 59.745n 0.0v 59.755n 0.95v 64.745n 0.95v 64.755n 0.95v 69.745n 0.95v 69.755n 0.95v 74.745n 0.95v 74.755n 0.0v 79.745n 0.0v 79.755n 0.95v 84.745n 0.95v 84.755n 0.95v 89.745n 0.95v 89.755n 0.95v 94.745n 0.95v 94.755n 0.95v 99.745n 0.95v 99.755n 0.95v 104.745n 0.95v 104.755n 0.95v 109.745n 0.95v 109.755n 0.95v 114.745n 0.95v 114.755n 0.95v 119.745n 0.95v 119.755n 0.0v 124.745n 0.0v 124.755n 0.0v 129.745n 0.0v 129.755n 0.95v 134.745n 0.95v 134.755n 0.95v 139.745n 0.95v 139.755n 0.95v 144.745n 0.95v 144.755n 0.95v 149.745n 0.95v 149.755n 0.0v 154.745n 0.0v 154.755n 0.95v 159.745n 0.95v 159.755n 0.95v 164.745n 0.95v 164.755n 0.95v 169.745n 0.95v 169.755n 0.95v 174.745n 0.95v 174.755n 0.95v 179.745n 0.95v 179.755n 0.95v 184.745n 0.95v 184.755n 0.95v 189.745n 0.95v 189.755n 0.95v 194.745n 0.95v 194.755n 0.95v 199.745n 0.95v 199.755n 0.95v 204.745n 0.95v 204.755n 0.95v 209.745n 0.95v 209.755n 0.95v 214.745n 0.95v 214.755n 0.95v 219.745n 0.95v 219.755n 0.0v 224.745n 0.0v 224.755n 0.0v 229.745n 0.0v 229.755n 0.95v 234.745n 0.95v 234.755n 0.95v 239.745n 0.95v 239.755n 0.0v 244.745n 0.0v 244.755n 0.95v 249.745n 0.95v 249.755n 0.95v 254.745n 0.95v 254.755n 0.95v 259.745n 0.95v 259.755n 0.95v 264.745n 0.95v 264.755n 0.95v 269.745n 0.95v 269.755n 0.95v 274.745n 0.95v 274.755n 0.95v 279.745n 0.95v 279.755n 0.95v 284.745n 0.95v 284.755n 0.95v 289.745n 0.95v 289.755n 0.95v 294.745n 0.95v 294.755n 0.95v 299.745n 0.95v 299.755n 0.95v 304.745n 0.95v 304.755n 0.95v 309.745n 0.95v 309.755n 0.95v 314.745n 0.95v 314.755n 0.95v 319.745n 0.95v 319.755n 0.95v 324.745n 0.95v 324.755n 0.95v 329.745n 0.95v 329.755n 0.0v 334.745n 0.0v 334.755n 0.0v 339.745n 0.0v 339.755n 0.0v 344.745n 0.0v 344.755n 0.95v 349.745n 0.95v 349.755n 0.95v 354.745n 0.95v 354.755n 0.95v 359.745n 0.95v 359.755n 0.95v 364.745n 0.95v 364.755n 0.0v 369.745n 0.0v 369.755n 0.0v 374.745n 0.0v 374.755n 0.95v 379.745n 0.95v 379.755n 0.95v 384.745n 0.95v 384.755n 0.95v 389.745n 0.95v 389.755n 0.95v 394.745n 0.95v 394.755n 0.0v 399.745n 0.0v 399.755n 0.95v 404.745n 0.95v 404.755n 0.95v 409.745n 0.95v 409.755n 0.0v 414.745n 0.0v 414.755n 0.95v 419.745n 0.95v 419.755n 0.0v 424.745n 0.0v 424.755n 0.0v 429.745n 0.0v 429.755n 0.0v 434.745n 0.0v 434.755n 0.0v 439.745n 0.0v 439.755n 0.0v 444.745n 0.0v 444.755n 0.0v 449.745n 0.0v 449.755n 0.0v 454.745n 0.0v 454.755n 0.0v 459.745n 0.0v 459.755n 0.0v 464.745n 0.0v 464.755n 0.0v 469.745n 0.0v 469.755n 0.0v 474.745n 0.0v 474.755n 0.95v 479.745n 0.95v 479.755n 0.95v 484.745n 0.95v 484.755n 0.0v 489.745n 0.0v 489.755n 0.95v 494.745n 0.95v 494.755n 0.95v 499.745n 0.95v 499.755n 0.95v 504.745n 0.95v 504.755n 0.95v 509.745n 0.95v 509.755n 0.0v 514.745n 0.0v 514.755n 0.0v 519.745n 0.0v 519.755n 0.95v 524.745n 0.95v 524.755n 0.95v 529.745n 0.95v 529.755n 0.95v 534.745n 0.95v 534.755n 0.0v 539.745n 0.0v 539.755n 0.0v 544.745n 0.0v 544.755n 0.0v 549.745n 0.0v 549.755n 0.0v 554.745n 0.0v 554.755n 0.0v 559.745n 0.0v 559.755n 0.0v 564.745n 0.0v 564.755n 0.0v 569.745n 0.0v 569.755n 0.95v 574.745n 0.95v 574.755n 0.95v 579.745n 0.95v 579.755n 0.95v 584.745n 0.95v 584.755n 0.0v 589.745n 0.0v 589.755n 0.95v 594.745n 0.95v 594.755n 0.95v 599.745n 0.95v 599.755n 0.0v 604.745n 0.0v 604.755n 0.0v 609.745n 0.0v 609.755n 0.95v 614.745n 0.95v 614.755n 0.95v 619.745n 0.95v 619.755n 0.95v 624.745n 0.95v 624.755n 0.0v 629.745n 0.0v 629.755n 0.95v 634.745n 0.95v 634.755n 0.95v 639.745n 0.95v 639.755n 0.0v 644.745n 0.0v 644.755n 0.95v 649.745n 0.95v 649.755n 0.95v 654.745n 0.95v 654.755n 0.0v 659.745n 0.0v 659.755n 0.0v 664.745n 0.0v 664.755n 0.0v 669.745n 0.0v 669.755n 0.95v 674.745n 0.95v 674.755n 0.0v 679.745n 0.0v 679.755n 0.0v 684.745n 0.0v 684.755n 0.0v 689.745n 0.0v 689.755n 0.0v 694.745n 0.0v 694.755n 0.95v 699.745n 0.95v 699.755n 0.95v 704.745n 0.95v 704.755n 0.95v 709.745n 0.95v 709.755n 0.0v 714.745n 0.0v 714.755n 0.0v 719.745n 0.0v 719.755n 0.95v 724.745n 0.95v 724.755n 0.0v 729.745n 0.0v 729.755n 0.0v 734.745n 0.0v 734.755n 0.0v 739.745n 0.0v 739.755n 0.95v 744.745n 0.95v 744.755n 0.95v 749.745n 0.95v 749.755n 0.0v 754.745n 0.0v 754.755n 0.0v 759.745n 0.0v 759.755n 0.0v 764.745n 0.0v 764.755n 0.95v 769.745n 0.95v 769.755n 0.95v 774.745n 0.95v 774.755n 0.0v 779.745n 0.0v 779.755n 0.0v 784.745n 0.0v 784.755n 0.95v 789.745n 0.95v 789.755n 0.95v 794.745n 0.95v 794.755n 0.95v 799.745n 0.95v 799.755n 0.95v 804.745n 0.95v 804.755n 0.95v 809.745n 0.95v 809.755n 0.95v 814.745n 0.95v 814.755n 0.95v 819.745n 0.95v 819.755n 0.95v 824.745n 0.95v 824.755n 0.95v 829.745n 0.95v 829.755n 0.0v 834.745n 0.0v 834.755n 0.95v 839.745n 0.95v 839.755n 0.0v 844.745n 0.0v 844.755n 0.95v 849.745n 0.95v 849.755n 0.0v 854.745n 0.0v 854.755n 0.0v 859.745n 0.0v 859.755n 0.95v 864.745n 0.95v 864.755n 0.0v 869.745n 0.0v 869.755n 0.0v 874.745n 0.0v 874.755n 0.95v 879.745n 0.95v 879.755n 0.95v 884.745n 0.95v 884.755n 0.95v 889.745n 0.95v 889.755n 0.0v 894.745n 0.0v 894.755n 0.0v 899.745n 0.0v 899.755n 0.95v 904.745n 0.95v 904.755n 0.95v 909.745n 0.95v 909.755n 0.0v 914.745n 0.0v 914.755n 0.0v 919.745n 0.0v 919.755n 0.0v 924.745n 0.0v 924.755n 0.95v 929.745n 0.95v 929.755n 0.0v 934.745n 0.0v 934.755n 0.0v 939.745n 0.0v 939.755n 0.95v 944.745n 0.95v 944.755n 0.0v 949.745n 0.0v 949.755n 0.95v 954.745n 0.95v 954.755n 0.95v 959.745n 0.95v 959.755n 0.95v 964.745n 0.95v 964.755n 0.0v 969.745n 0.0v 969.755n 0.0v 974.745n 0.0v 974.755n 0.95v 979.745n 0.95v 979.755n 0.0v 984.745n 0.0v 984.755n 0.0v 989.745n 0.0v 989.755n 0.0v 994.745n 0.0v 994.755n 0.95v 999.745n 0.95v 999.755n 0.95v 1004.745n 0.95v 1004.755n 0.95v 1009.745n 0.95v 1009.755n 0.95v 1014.745n 0.95v 1014.755n 0.95v 1019.745n 0.95v 1019.755n 0.95v 1024.745n 0.95v 1024.755n 0.95v )
* (time, data): [(0, 0), (5, 1), (10, 1), (15, 1), (20, 1), (25, 1), (30, 1), (35, 1), (40, 1), (45, 1), (50, 0), (55, 0), (60, 1), (65, 1), (70, 1), (75, 0), (80, 1), (85, 1), (90, 1), (95, 1), (100, 1), (105, 1), (110, 1), (115, 1), (120, 0), (125, 0), (130, 1), (135, 1), (140, 1), (145, 1), (150, 0), (155, 1), (160, 1), (165, 1), (170, 1), (175, 1), (180, 1), (185, 1), (190, 1), (195, 1), (200, 1), (205, 1), (210, 1), (215, 1), (220, 0), (225, 0), (230, 1), (235, 1), (240, 0), (245, 1), (250, 1), (255, 1), (260, 1), (265, 1), (270, 1), (275, 1), (280, 1), (285, 1), (290, 1), (295, 1), (300, 1), (305, 1), (310, 1), (315, 1), (320, 1), (325, 1), (330, 0), (335, 0), (340, 0), (345, 1), (350, 1), (355, 1), (360, 1), (365, 0), (370, 0), (375, 1), (380, 1), (385, 1), (390, 1), (395, 0), (400, 1), (405, 1), (410, 0), (415, 1), (420, 0), (425, 0), (430, 0), (435, 0), (440, 0), (445, 0), (450, 0), (455, 0), (460, 0), (465, 0), (470, 0), (475, 1), (480, 1), (485, 0), (490, 1), (495, 1), (500, 1), (505, 1), (510, 0), (515, 0), (520, 1), (525, 1), (530, 1), (535, 0), (540, 0), (545, 0), (550, 0), (555, 0), (560, 0), (565, 0), (570, 1), (575, 1), (580, 1), (585, 0), (590, 1), (595, 1), (600, 0), (605, 0), (610, 1), (615, 1), (620, 1), (625, 0), (630, 1), (635, 1), (640, 0), (645, 1), (650, 1), (655, 0), (660, 0), (665, 0), (670, 1), (675, 0), (680, 0), (685, 0), (690, 0), (695, 1), (700, 1), (705, 1), (710, 0), (715, 0), (720, 1), (725, 0), (730, 0), (735, 0), (740, 1), (745, 1), (750, 0), (755, 0), (760, 0), (765, 1), (770, 1), (775, 0), (780, 0), (785, 1), (790, 1), (795, 1), (800, 1), (805, 1), (810, 1), (815, 1), (820, 1), (825, 1), (830, 0), (835, 1), (840, 0), (845, 1), (850, 0), (855, 0), (860, 1), (865, 0), (870, 0), (875, 1), (880, 1), (885, 1), (890, 0), (895, 0), (900, 1), (905, 1), (910, 0), (915, 0), (920, 0), (925, 1), (930, 0), (935, 0), (940, 1), (945, 0), (950, 1), (955, 1), (960, 1), (965, 0), (970, 0), (975, 1), (980, 0), (985, 0), (990, 0), (995, 1), (1000, 1), (1005, 1), (1010, 1), (1015, 1), (1020, 1), (1025, 1)]
Va0_5  a0_5  0 PWL (0n 0.0v 4.745n 0.0v 4.755n 0.95v 9.745n 0.95v 9.755n 0.95v 14.745n 0.95v 14.755n 0.95v 19.745n 0.95v 19.755n 0.95v 24.745n 0.95v 24.755n 0.95v 29.745n 0.95v 29.755n 0.95v 34.745n 0.95v 34.755n 0.95v 39.745n 0.95v 39.755n 0.95v 44.745n 0.95v 44.755n 0.95v 49.745n 0.95v 49.755n 0.0v 54.745n 0.0v 54.755n 0.0v 59.745n 0.0v 59.755n 0.95v 64.745n 0.95v 64.755n 0.95v 69.745n 0.95v 69.755n 0.95v 74.745n 0.95v 74.755n 0.0v 79.745n 0.0v 79.755n 0.95v 84.745n 0.95v 84.755n 0.95v 89.745n 0.95v 89.755n 0.95v 94.745n 0.95v 94.755n 0.95v 99.745n 0.95v 99.755n 0.95v 104.745n 0.95v 104.755n 0.95v 109.745n 0.95v 109.755n 0.95v 114.745n 0.95v 114.755n 0.95v 119.745n 0.95v 119.755n 0.0v 124.745n 0.0v 124.755n 0.0v 129.745n 0.0v 129.755n 0.95v 134.745n 0.95v 134.755n 0.95v 139.745n 0.95v 139.755n 0.95v 144.745n 0.95v 144.755n 0.95v 149.745n 0.95v 149.755n 0.0v 154.745n 0.0v 154.755n 0.95v 159.745n 0.95v 159.755n 0.95v 164.745n 0.95v 164.755n 0.95v 169.745n 0.95v 169.755n 0.95v 174.745n 0.95v 174.755n 0.95v 179.745n 0.95v 179.755n 0.95v 184.745n 0.95v 184.755n 0.95v 189.745n 0.95v 189.755n 0.95v 194.745n 0.95v 194.755n 0.95v 199.745n 0.95v 199.755n 0.95v 204.745n 0.95v 204.755n 0.95v 209.745n 0.95v 209.755n 0.95v 214.745n 0.95v 214.755n 0.95v 219.745n 0.95v 219.755n 0.0v 224.745n 0.0v 224.755n 0.0v 229.745n 0.0v 229.755n 0.95v 234.745n 0.95v 234.755n 0.95v 239.745n 0.95v 239.755n 0.0v 244.745n 0.0v 244.755n 0.95v 249.745n 0.95v 249.755n 0.95v 254.745n 0.95v 254.755n 0.95v 259.745n 0.95v 259.755n 0.95v 264.745n 0.95v 264.755n 0.95v 269.745n 0.95v 269.755n 0.95v 274.745n 0.95v 274.755n 0.95v 279.745n 0.95v 279.755n 0.95v 284.745n 0.95v 284.755n 0.95v 289.745n 0.95v 289.755n 0.95v 294.745n 0.95v 294.755n 0.95v 299.745n 0.95v 299.755n 0.95v 304.745n 0.95v 304.755n 0.95v 309.745n 0.95v 309.755n 0.95v 314.745n 0.95v 314.755n 0.95v 319.745n 0.95v 319.755n 0.95v 324.745n 0.95v 324.755n 0.95v 329.745n 0.95v 329.755n 0.0v 334.745n 0.0v 334.755n 0.0v 339.745n 0.0v 339.755n 0.0v 344.745n 0.0v 344.755n 0.95v 349.745n 0.95v 349.755n 0.95v 354.745n 0.95v 354.755n 0.95v 359.745n 0.95v 359.755n 0.95v 364.745n 0.95v 364.755n 0.0v 369.745n 0.0v 369.755n 0.0v 374.745n 0.0v 374.755n 0.95v 379.745n 0.95v 379.755n 0.95v 384.745n 0.95v 384.755n 0.95v 389.745n 0.95v 389.755n 0.95v 394.745n 0.95v 394.755n 0.0v 399.745n 0.0v 399.755n 0.95v 404.745n 0.95v 404.755n 0.95v 409.745n 0.95v 409.755n 0.0v 414.745n 0.0v 414.755n 0.95v 419.745n 0.95v 419.755n 0.0v 424.745n 0.0v 424.755n 0.0v 429.745n 0.0v 429.755n 0.0v 434.745n 0.0v 434.755n 0.0v 439.745n 0.0v 439.755n 0.0v 444.745n 0.0v 444.755n 0.0v 449.745n 0.0v 449.755n 0.0v 454.745n 0.0v 454.755n 0.0v 459.745n 0.0v 459.755n 0.0v 464.745n 0.0v 464.755n 0.0v 469.745n 0.0v 469.755n 0.0v 474.745n 0.0v 474.755n 0.95v 479.745n 0.95v 479.755n 0.95v 484.745n 0.95v 484.755n 0.0v 489.745n 0.0v 489.755n 0.95v 494.745n 0.95v 494.755n 0.95v 499.745n 0.95v 499.755n 0.95v 504.745n 0.95v 504.755n 0.95v 509.745n 0.95v 509.755n 0.0v 514.745n 0.0v 514.755n 0.0v 519.745n 0.0v 519.755n 0.95v 524.745n 0.95v 524.755n 0.95v 529.745n 0.95v 529.755n 0.95v 534.745n 0.95v 534.755n 0.0v 539.745n 0.0v 539.755n 0.0v 544.745n 0.0v 544.755n 0.0v 549.745n 0.0v 549.755n 0.0v 554.745n 0.0v 554.755n 0.0v 559.745n 0.0v 559.755n 0.0v 564.745n 0.0v 564.755n 0.0v 569.745n 0.0v 569.755n 0.95v 574.745n 0.95v 574.755n 0.95v 579.745n 0.95v 579.755n 0.95v 584.745n 0.95v 584.755n 0.0v 589.745n 0.0v 589.755n 0.95v 594.745n 0.95v 594.755n 0.95v 599.745n 0.95v 599.755n 0.0v 604.745n 0.0v 604.755n 0.0v 609.745n 0.0v 609.755n 0.95v 614.745n 0.95v 614.755n 0.95v 619.745n 0.95v 619.755n 0.95v 624.745n 0.95v 624.755n 0.0v 629.745n 0.0v 629.755n 0.95v 634.745n 0.95v 634.755n 0.95v 639.745n 0.95v 639.755n 0.0v 644.745n 0.0v 644.755n 0.95v 649.745n 0.95v 649.755n 0.95v 654.745n 0.95v 654.755n 0.0v 659.745n 0.0v 659.755n 0.0v 664.745n 0.0v 664.755n 0.0v 669.745n 0.0v 669.755n 0.95v 674.745n 0.95v 674.755n 0.0v 679.745n 0.0v 679.755n 0.0v 684.745n 0.0v 684.755n 0.0v 689.745n 0.0v 689.755n 0.0v 694.745n 0.0v 694.755n 0.95v 699.745n 0.95v 699.755n 0.95v 704.745n 0.95v 704.755n 0.95v 709.745n 0.95v 709.755n 0.0v 714.745n 0.0v 714.755n 0.0v 719.745n 0.0v 719.755n 0.95v 724.745n 0.95v 724.755n 0.0v 729.745n 0.0v 729.755n 0.0v 734.745n 0.0v 734.755n 0.0v 739.745n 0.0v 739.755n 0.95v 744.745n 0.95v 744.755n 0.95v 749.745n 0.95v 749.755n 0.0v 754.745n 0.0v 754.755n 0.0v 759.745n 0.0v 759.755n 0.0v 764.745n 0.0v 764.755n 0.95v 769.745n 0.95v 769.755n 0.95v 774.745n 0.95v 774.755n 0.0v 779.745n 0.0v 779.755n 0.0v 784.745n 0.0v 784.755n 0.95v 789.745n 0.95v 789.755n 0.95v 794.745n 0.95v 794.755n 0.95v 799.745n 0.95v 799.755n 0.95v 804.745n 0.95v 804.755n 0.95v 809.745n 0.95v 809.755n 0.95v 814.745n 0.95v 814.755n 0.95v 819.745n 0.95v 819.755n 0.95v 824.745n 0.95v 824.755n 0.95v 829.745n 0.95v 829.755n 0.0v 834.745n 0.0v 834.755n 0.95v 839.745n 0.95v 839.755n 0.0v 844.745n 0.0v 844.755n 0.95v 849.745n 0.95v 849.755n 0.0v 854.745n 0.0v 854.755n 0.0v 859.745n 0.0v 859.755n 0.95v 864.745n 0.95v 864.755n 0.0v 869.745n 0.0v 869.755n 0.0v 874.745n 0.0v 874.755n 0.95v 879.745n 0.95v 879.755n 0.95v 884.745n 0.95v 884.755n 0.95v 889.745n 0.95v 889.755n 0.0v 894.745n 0.0v 894.755n 0.0v 899.745n 0.0v 899.755n 0.95v 904.745n 0.95v 904.755n 0.95v 909.745n 0.95v 909.755n 0.0v 914.745n 0.0v 914.755n 0.0v 919.745n 0.0v 919.755n 0.0v 924.745n 0.0v 924.755n 0.95v 929.745n 0.95v 929.755n 0.0v 934.745n 0.0v 934.755n 0.0v 939.745n 0.0v 939.755n 0.95v 944.745n 0.95v 944.755n 0.0v 949.745n 0.0v 949.755n 0.95v 954.745n 0.95v 954.755n 0.95v 959.745n 0.95v 959.755n 0.95v 964.745n 0.95v 964.755n 0.0v 969.745n 0.0v 969.755n 0.0v 974.745n 0.0v 974.755n 0.95v 979.745n 0.95v 979.755n 0.0v 984.745n 0.0v 984.755n 0.0v 989.745n 0.0v 989.755n 0.0v 994.745n 0.0v 994.755n 0.95v 999.745n 0.95v 999.755n 0.95v 1004.745n 0.95v 1004.755n 0.95v 1009.745n 0.95v 1009.755n 0.95v 1014.745n 0.95v 1014.755n 0.95v 1019.745n 0.95v 1019.755n 0.95v 1024.745n 0.95v 1024.755n 0.95v )
* (time, data): [(0, 0), (5, 1), (10, 1), (15, 1), (20, 1), (25, 1), (30, 1), (35, 1), (40, 1), (45, 1), (50, 0), (55, 0), (60, 1), (65, 1), (70, 1), (75, 0), (80, 1), (85, 1), (90, 1), (95, 1), (100, 1), (105, 1), (110, 1), (115, 1), (120, 0), (125, 0), (130, 1), (135, 1), (140, 1), (145, 1), (150, 0), (155, 1), (160, 1), (165, 1), (170, 1), (175, 1), (180, 1), (185, 1), (190, 1), (195, 1), (200, 1), (205, 1), (210, 1), (215, 1), (220, 0), (225, 0), (230, 1), (235, 1), (240, 0), (245, 1), (250, 1), (255, 1), (260, 1), (265, 1), (270, 1), (275, 1), (280, 1), (285, 1), (290, 1), (295, 1), (300, 1), (305, 1), (310, 1), (315, 1), (320, 1), (325, 1), (330, 0), (335, 0), (340, 0), (345, 1), (350, 1), (355, 1), (360, 1), (365, 0), (370, 0), (375, 1), (380, 1), (385, 1), (390, 1), (395, 0), (400, 1), (405, 1), (410, 0), (415, 1), (420, 0), (425, 0), (430, 0), (435, 0), (440, 0), (445, 0), (450, 0), (455, 0), (460, 0), (465, 0), (470, 0), (475, 1), (480, 1), (485, 0), (490, 1), (495, 1), (500, 1), (505, 1), (510, 0), (515, 0), (520, 1), (525, 1), (530, 1), (535, 0), (540, 0), (545, 0), (550, 0), (555, 0), (560, 0), (565, 0), (570, 1), (575, 1), (580, 1), (585, 0), (590, 1), (595, 1), (600, 0), (605, 0), (610, 1), (615, 1), (620, 1), (625, 0), (630, 1), (635, 1), (640, 0), (645, 1), (650, 1), (655, 0), (660, 0), (665, 0), (670, 1), (675, 0), (680, 0), (685, 0), (690, 0), (695, 1), (700, 1), (705, 1), (710, 0), (715, 0), (720, 1), (725, 0), (730, 0), (735, 0), (740, 1), (745, 1), (750, 0), (755, 0), (760, 0), (765, 1), (770, 1), (775, 0), (780, 0), (785, 1), (790, 1), (795, 1), (800, 1), (805, 1), (810, 1), (815, 1), (820, 1), (825, 1), (830, 0), (835, 1), (840, 0), (845, 1), (850, 0), (855, 0), (860, 1), (865, 0), (870, 0), (875, 1), (880, 1), (885, 1), (890, 0), (895, 0), (900, 1), (905, 1), (910, 0), (915, 0), (920, 0), (925, 1), (930, 0), (935, 0), (940, 1), (945, 0), (950, 1), (955, 1), (960, 1), (965, 0), (970, 0), (975, 1), (980, 0), (985, 0), (990, 0), (995, 1), (1000, 1), (1005, 1), (1010, 1), (1015, 1), (1020, 1), (1025, 1)]
Va0_6  a0_6  0 PWL (0n 0.0v 4.745n 0.0v 4.755n 0.95v 9.745n 0.95v 9.755n 0.95v 14.745n 0.95v 14.755n 0.95v 19.745n 0.95v 19.755n 0.95v 24.745n 0.95v 24.755n 0.95v 29.745n 0.95v 29.755n 0.95v 34.745n 0.95v 34.755n 0.95v 39.745n 0.95v 39.755n 0.95v 44.745n 0.95v 44.755n 0.95v 49.745n 0.95v 49.755n 0.0v 54.745n 0.0v 54.755n 0.0v 59.745n 0.0v 59.755n 0.95v 64.745n 0.95v 64.755n 0.95v 69.745n 0.95v 69.755n 0.95v 74.745n 0.95v 74.755n 0.0v 79.745n 0.0v 79.755n 0.95v 84.745n 0.95v 84.755n 0.95v 89.745n 0.95v 89.755n 0.95v 94.745n 0.95v 94.755n 0.95v 99.745n 0.95v 99.755n 0.95v 104.745n 0.95v 104.755n 0.95v 109.745n 0.95v 109.755n 0.95v 114.745n 0.95v 114.755n 0.95v 119.745n 0.95v 119.755n 0.0v 124.745n 0.0v 124.755n 0.0v 129.745n 0.0v 129.755n 0.95v 134.745n 0.95v 134.755n 0.95v 139.745n 0.95v 139.755n 0.95v 144.745n 0.95v 144.755n 0.95v 149.745n 0.95v 149.755n 0.0v 154.745n 0.0v 154.755n 0.95v 159.745n 0.95v 159.755n 0.95v 164.745n 0.95v 164.755n 0.95v 169.745n 0.95v 169.755n 0.95v 174.745n 0.95v 174.755n 0.95v 179.745n 0.95v 179.755n 0.95v 184.745n 0.95v 184.755n 0.95v 189.745n 0.95v 189.755n 0.95v 194.745n 0.95v 194.755n 0.95v 199.745n 0.95v 199.755n 0.95v 204.745n 0.95v 204.755n 0.95v 209.745n 0.95v 209.755n 0.95v 214.745n 0.95v 214.755n 0.95v 219.745n 0.95v 219.755n 0.0v 224.745n 0.0v 224.755n 0.0v 229.745n 0.0v 229.755n 0.95v 234.745n 0.95v 234.755n 0.95v 239.745n 0.95v 239.755n 0.0v 244.745n 0.0v 244.755n 0.95v 249.745n 0.95v 249.755n 0.95v 254.745n 0.95v 254.755n 0.95v 259.745n 0.95v 259.755n 0.95v 264.745n 0.95v 264.755n 0.95v 269.745n 0.95v 269.755n 0.95v 274.745n 0.95v 274.755n 0.95v 279.745n 0.95v 279.755n 0.95v 284.745n 0.95v 284.755n 0.95v 289.745n 0.95v 289.755n 0.95v 294.745n 0.95v 294.755n 0.95v 299.745n 0.95v 299.755n 0.95v 304.745n 0.95v 304.755n 0.95v 309.745n 0.95v 309.755n 0.95v 314.745n 0.95v 314.755n 0.95v 319.745n 0.95v 319.755n 0.95v 324.745n 0.95v 324.755n 0.95v 329.745n 0.95v 329.755n 0.0v 334.745n 0.0v 334.755n 0.0v 339.745n 0.0v 339.755n 0.0v 344.745n 0.0v 344.755n 0.95v 349.745n 0.95v 349.755n 0.95v 354.745n 0.95v 354.755n 0.95v 359.745n 0.95v 359.755n 0.95v 364.745n 0.95v 364.755n 0.0v 369.745n 0.0v 369.755n 0.0v 374.745n 0.0v 374.755n 0.95v 379.745n 0.95v 379.755n 0.95v 384.745n 0.95v 384.755n 0.95v 389.745n 0.95v 389.755n 0.95v 394.745n 0.95v 394.755n 0.0v 399.745n 0.0v 399.755n 0.95v 404.745n 0.95v 404.755n 0.95v 409.745n 0.95v 409.755n 0.0v 414.745n 0.0v 414.755n 0.95v 419.745n 0.95v 419.755n 0.0v 424.745n 0.0v 424.755n 0.0v 429.745n 0.0v 429.755n 0.0v 434.745n 0.0v 434.755n 0.0v 439.745n 0.0v 439.755n 0.0v 444.745n 0.0v 444.755n 0.0v 449.745n 0.0v 449.755n 0.0v 454.745n 0.0v 454.755n 0.0v 459.745n 0.0v 459.755n 0.0v 464.745n 0.0v 464.755n 0.0v 469.745n 0.0v 469.755n 0.0v 474.745n 0.0v 474.755n 0.95v 479.745n 0.95v 479.755n 0.95v 484.745n 0.95v 484.755n 0.0v 489.745n 0.0v 489.755n 0.95v 494.745n 0.95v 494.755n 0.95v 499.745n 0.95v 499.755n 0.95v 504.745n 0.95v 504.755n 0.95v 509.745n 0.95v 509.755n 0.0v 514.745n 0.0v 514.755n 0.0v 519.745n 0.0v 519.755n 0.95v 524.745n 0.95v 524.755n 0.95v 529.745n 0.95v 529.755n 0.95v 534.745n 0.95v 534.755n 0.0v 539.745n 0.0v 539.755n 0.0v 544.745n 0.0v 544.755n 0.0v 549.745n 0.0v 549.755n 0.0v 554.745n 0.0v 554.755n 0.0v 559.745n 0.0v 559.755n 0.0v 564.745n 0.0v 564.755n 0.0v 569.745n 0.0v 569.755n 0.95v 574.745n 0.95v 574.755n 0.95v 579.745n 0.95v 579.755n 0.95v 584.745n 0.95v 584.755n 0.0v 589.745n 0.0v 589.755n 0.95v 594.745n 0.95v 594.755n 0.95v 599.745n 0.95v 599.755n 0.0v 604.745n 0.0v 604.755n 0.0v 609.745n 0.0v 609.755n 0.95v 614.745n 0.95v 614.755n 0.95v 619.745n 0.95v 619.755n 0.95v 624.745n 0.95v 624.755n 0.0v 629.745n 0.0v 629.755n 0.95v 634.745n 0.95v 634.755n 0.95v 639.745n 0.95v 639.755n 0.0v 644.745n 0.0v 644.755n 0.95v 649.745n 0.95v 649.755n 0.95v 654.745n 0.95v 654.755n 0.0v 659.745n 0.0v 659.755n 0.0v 664.745n 0.0v 664.755n 0.0v 669.745n 0.0v 669.755n 0.95v 674.745n 0.95v 674.755n 0.0v 679.745n 0.0v 679.755n 0.0v 684.745n 0.0v 684.755n 0.0v 689.745n 0.0v 689.755n 0.0v 694.745n 0.0v 694.755n 0.95v 699.745n 0.95v 699.755n 0.95v 704.745n 0.95v 704.755n 0.95v 709.745n 0.95v 709.755n 0.0v 714.745n 0.0v 714.755n 0.0v 719.745n 0.0v 719.755n 0.95v 724.745n 0.95v 724.755n 0.0v 729.745n 0.0v 729.755n 0.0v 734.745n 0.0v 734.755n 0.0v 739.745n 0.0v 739.755n 0.95v 744.745n 0.95v 744.755n 0.95v 749.745n 0.95v 749.755n 0.0v 754.745n 0.0v 754.755n 0.0v 759.745n 0.0v 759.755n 0.0v 764.745n 0.0v 764.755n 0.95v 769.745n 0.95v 769.755n 0.95v 774.745n 0.95v 774.755n 0.0v 779.745n 0.0v 779.755n 0.0v 784.745n 0.0v 784.755n 0.95v 789.745n 0.95v 789.755n 0.95v 794.745n 0.95v 794.755n 0.95v 799.745n 0.95v 799.755n 0.95v 804.745n 0.95v 804.755n 0.95v 809.745n 0.95v 809.755n 0.95v 814.745n 0.95v 814.755n 0.95v 819.745n 0.95v 819.755n 0.95v 824.745n 0.95v 824.755n 0.95v 829.745n 0.95v 829.755n 0.0v 834.745n 0.0v 834.755n 0.95v 839.745n 0.95v 839.755n 0.0v 844.745n 0.0v 844.755n 0.95v 849.745n 0.95v 849.755n 0.0v 854.745n 0.0v 854.755n 0.0v 859.745n 0.0v 859.755n 0.95v 864.745n 0.95v 864.755n 0.0v 869.745n 0.0v 869.755n 0.0v 874.745n 0.0v 874.755n 0.95v 879.745n 0.95v 879.755n 0.95v 884.745n 0.95v 884.755n 0.95v 889.745n 0.95v 889.755n 0.0v 894.745n 0.0v 894.755n 0.0v 899.745n 0.0v 899.755n 0.95v 904.745n 0.95v 904.755n 0.95v 909.745n 0.95v 909.755n 0.0v 914.745n 0.0v 914.755n 0.0v 919.745n 0.0v 919.755n 0.0v 924.745n 0.0v 924.755n 0.95v 929.745n 0.95v 929.755n 0.0v 934.745n 0.0v 934.755n 0.0v 939.745n 0.0v 939.755n 0.95v 944.745n 0.95v 944.755n 0.0v 949.745n 0.0v 949.755n 0.95v 954.745n 0.95v 954.755n 0.95v 959.745n 0.95v 959.755n 0.95v 964.745n 0.95v 964.755n 0.0v 969.745n 0.0v 969.755n 0.0v 974.745n 0.0v 974.755n 0.95v 979.745n 0.95v 979.755n 0.0v 984.745n 0.0v 984.755n 0.0v 989.745n 0.0v 989.755n 0.0v 994.745n 0.0v 994.755n 0.95v 999.745n 0.95v 999.755n 0.95v 1004.745n 0.95v 1004.755n 0.95v 1009.745n 0.95v 1009.755n 0.95v 1014.745n 0.95v 1014.755n 0.95v 1019.745n 0.95v 1019.755n 0.95v 1024.745n 0.95v 1024.755n 0.95v )
* (time, data): [(0, 0), (5, 1), (10, 1), (15, 1), (20, 1), (25, 1), (30, 1), (35, 1), (40, 1), (45, 1), (50, 0), (55, 0), (60, 1), (65, 1), (70, 1), (75, 0), (80, 1), (85, 1), (90, 1), (95, 1), (100, 1), (105, 1), (110, 1), (115, 1), (120, 0), (125, 0), (130, 1), (135, 1), (140, 1), (145, 1), (150, 0), (155, 1), (160, 1), (165, 1), (170, 1), (175, 1), (180, 1), (185, 1), (190, 1), (195, 1), (200, 1), (205, 1), (210, 1), (215, 1), (220, 0), (225, 0), (230, 1), (235, 1), (240, 0), (245, 1), (250, 1), (255, 1), (260, 1), (265, 1), (270, 1), (275, 1), (280, 1), (285, 1), (290, 1), (295, 1), (300, 1), (305, 1), (310, 1), (315, 1), (320, 1), (325, 1), (330, 0), (335, 0), (340, 0), (345, 1), (350, 1), (355, 1), (360, 1), (365, 0), (370, 0), (375, 1), (380, 1), (385, 1), (390, 1), (395, 0), (400, 1), (405, 1), (410, 0), (415, 1), (420, 0), (425, 0), (430, 0), (435, 0), (440, 0), (445, 0), (450, 0), (455, 0), (460, 0), (465, 0), (470, 0), (475, 1), (480, 1), (485, 0), (490, 1), (495, 1), (500, 1), (505, 1), (510, 0), (515, 0), (520, 1), (525, 1), (530, 1), (535, 0), (540, 0), (545, 0), (550, 0), (555, 0), (560, 0), (565, 0), (570, 1), (575, 1), (580, 1), (585, 0), (590, 1), (595, 1), (600, 0), (605, 0), (610, 1), (615, 1), (620, 1), (625, 0), (630, 1), (635, 1), (640, 0), (645, 1), (650, 1), (655, 0), (660, 0), (665, 0), (670, 1), (675, 0), (680, 0), (685, 0), (690, 0), (695, 1), (700, 1), (705, 1), (710, 0), (715, 0), (720, 1), (725, 0), (730, 0), (735, 0), (740, 1), (745, 1), (750, 0), (755, 0), (760, 0), (765, 1), (770, 1), (775, 0), (780, 0), (785, 1), (790, 1), (795, 1), (800, 1), (805, 1), (810, 1), (815, 1), (820, 1), (825, 1), (830, 0), (835, 1), (840, 0), (845, 1), (850, 0), (855, 0), (860, 1), (865, 0), (870, 0), (875, 1), (880, 1), (885, 1), (890, 0), (895, 0), (900, 1), (905, 1), (910, 0), (915, 0), (920, 0), (925, 1), (930, 0), (935, 0), (940, 1), (945, 0), (950, 1), (955, 1), (960, 1), (965, 0), (970, 0), (975, 1), (980, 0), (985, 0), (990, 0), (995, 1), (1000, 1), (1005, 1), (1010, 1), (1015, 1), (1020, 1), (1025, 1)]
Va0_7  a0_7  0 PWL (0n 0.0v 4.745n 0.0v 4.755n 0.95v 9.745n 0.95v 9.755n 0.95v 14.745n 0.95v 14.755n 0.95v 19.745n 0.95v 19.755n 0.95v 24.745n 0.95v 24.755n 0.95v 29.745n 0.95v 29.755n 0.95v 34.745n 0.95v 34.755n 0.95v 39.745n 0.95v 39.755n 0.95v 44.745n 0.95v 44.755n 0.95v 49.745n 0.95v 49.755n 0.0v 54.745n 0.0v 54.755n 0.0v 59.745n 0.0v 59.755n 0.95v 64.745n 0.95v 64.755n 0.95v 69.745n 0.95v 69.755n 0.95v 74.745n 0.95v 74.755n 0.0v 79.745n 0.0v 79.755n 0.95v 84.745n 0.95v 84.755n 0.95v 89.745n 0.95v 89.755n 0.95v 94.745n 0.95v 94.755n 0.95v 99.745n 0.95v 99.755n 0.95v 104.745n 0.95v 104.755n 0.95v 109.745n 0.95v 109.755n 0.95v 114.745n 0.95v 114.755n 0.95v 119.745n 0.95v 119.755n 0.0v 124.745n 0.0v 124.755n 0.0v 129.745n 0.0v 129.755n 0.95v 134.745n 0.95v 134.755n 0.95v 139.745n 0.95v 139.755n 0.95v 144.745n 0.95v 144.755n 0.95v 149.745n 0.95v 149.755n 0.0v 154.745n 0.0v 154.755n 0.95v 159.745n 0.95v 159.755n 0.95v 164.745n 0.95v 164.755n 0.95v 169.745n 0.95v 169.755n 0.95v 174.745n 0.95v 174.755n 0.95v 179.745n 0.95v 179.755n 0.95v 184.745n 0.95v 184.755n 0.95v 189.745n 0.95v 189.755n 0.95v 194.745n 0.95v 194.755n 0.95v 199.745n 0.95v 199.755n 0.95v 204.745n 0.95v 204.755n 0.95v 209.745n 0.95v 209.755n 0.95v 214.745n 0.95v 214.755n 0.95v 219.745n 0.95v 219.755n 0.0v 224.745n 0.0v 224.755n 0.0v 229.745n 0.0v 229.755n 0.95v 234.745n 0.95v 234.755n 0.95v 239.745n 0.95v 239.755n 0.0v 244.745n 0.0v 244.755n 0.95v 249.745n 0.95v 249.755n 0.95v 254.745n 0.95v 254.755n 0.95v 259.745n 0.95v 259.755n 0.95v 264.745n 0.95v 264.755n 0.95v 269.745n 0.95v 269.755n 0.95v 274.745n 0.95v 274.755n 0.95v 279.745n 0.95v 279.755n 0.95v 284.745n 0.95v 284.755n 0.95v 289.745n 0.95v 289.755n 0.95v 294.745n 0.95v 294.755n 0.95v 299.745n 0.95v 299.755n 0.95v 304.745n 0.95v 304.755n 0.95v 309.745n 0.95v 309.755n 0.95v 314.745n 0.95v 314.755n 0.95v 319.745n 0.95v 319.755n 0.95v 324.745n 0.95v 324.755n 0.95v 329.745n 0.95v 329.755n 0.0v 334.745n 0.0v 334.755n 0.0v 339.745n 0.0v 339.755n 0.0v 344.745n 0.0v 344.755n 0.95v 349.745n 0.95v 349.755n 0.95v 354.745n 0.95v 354.755n 0.95v 359.745n 0.95v 359.755n 0.95v 364.745n 0.95v 364.755n 0.0v 369.745n 0.0v 369.755n 0.0v 374.745n 0.0v 374.755n 0.95v 379.745n 0.95v 379.755n 0.95v 384.745n 0.95v 384.755n 0.95v 389.745n 0.95v 389.755n 0.95v 394.745n 0.95v 394.755n 0.0v 399.745n 0.0v 399.755n 0.95v 404.745n 0.95v 404.755n 0.95v 409.745n 0.95v 409.755n 0.0v 414.745n 0.0v 414.755n 0.95v 419.745n 0.95v 419.755n 0.0v 424.745n 0.0v 424.755n 0.0v 429.745n 0.0v 429.755n 0.0v 434.745n 0.0v 434.755n 0.0v 439.745n 0.0v 439.755n 0.0v 444.745n 0.0v 444.755n 0.0v 449.745n 0.0v 449.755n 0.0v 454.745n 0.0v 454.755n 0.0v 459.745n 0.0v 459.755n 0.0v 464.745n 0.0v 464.755n 0.0v 469.745n 0.0v 469.755n 0.0v 474.745n 0.0v 474.755n 0.95v 479.745n 0.95v 479.755n 0.95v 484.745n 0.95v 484.755n 0.0v 489.745n 0.0v 489.755n 0.95v 494.745n 0.95v 494.755n 0.95v 499.745n 0.95v 499.755n 0.95v 504.745n 0.95v 504.755n 0.95v 509.745n 0.95v 509.755n 0.0v 514.745n 0.0v 514.755n 0.0v 519.745n 0.0v 519.755n 0.95v 524.745n 0.95v 524.755n 0.95v 529.745n 0.95v 529.755n 0.95v 534.745n 0.95v 534.755n 0.0v 539.745n 0.0v 539.755n 0.0v 544.745n 0.0v 544.755n 0.0v 549.745n 0.0v 549.755n 0.0v 554.745n 0.0v 554.755n 0.0v 559.745n 0.0v 559.755n 0.0v 564.745n 0.0v 564.755n 0.0v 569.745n 0.0v 569.755n 0.95v 574.745n 0.95v 574.755n 0.95v 579.745n 0.95v 579.755n 0.95v 584.745n 0.95v 584.755n 0.0v 589.745n 0.0v 589.755n 0.95v 594.745n 0.95v 594.755n 0.95v 599.745n 0.95v 599.755n 0.0v 604.745n 0.0v 604.755n 0.0v 609.745n 0.0v 609.755n 0.95v 614.745n 0.95v 614.755n 0.95v 619.745n 0.95v 619.755n 0.95v 624.745n 0.95v 624.755n 0.0v 629.745n 0.0v 629.755n 0.95v 634.745n 0.95v 634.755n 0.95v 639.745n 0.95v 639.755n 0.0v 644.745n 0.0v 644.755n 0.95v 649.745n 0.95v 649.755n 0.95v 654.745n 0.95v 654.755n 0.0v 659.745n 0.0v 659.755n 0.0v 664.745n 0.0v 664.755n 0.0v 669.745n 0.0v 669.755n 0.95v 674.745n 0.95v 674.755n 0.0v 679.745n 0.0v 679.755n 0.0v 684.745n 0.0v 684.755n 0.0v 689.745n 0.0v 689.755n 0.0v 694.745n 0.0v 694.755n 0.95v 699.745n 0.95v 699.755n 0.95v 704.745n 0.95v 704.755n 0.95v 709.745n 0.95v 709.755n 0.0v 714.745n 0.0v 714.755n 0.0v 719.745n 0.0v 719.755n 0.95v 724.745n 0.95v 724.755n 0.0v 729.745n 0.0v 729.755n 0.0v 734.745n 0.0v 734.755n 0.0v 739.745n 0.0v 739.755n 0.95v 744.745n 0.95v 744.755n 0.95v 749.745n 0.95v 749.755n 0.0v 754.745n 0.0v 754.755n 0.0v 759.745n 0.0v 759.755n 0.0v 764.745n 0.0v 764.755n 0.95v 769.745n 0.95v 769.755n 0.95v 774.745n 0.95v 774.755n 0.0v 779.745n 0.0v 779.755n 0.0v 784.745n 0.0v 784.755n 0.95v 789.745n 0.95v 789.755n 0.95v 794.745n 0.95v 794.755n 0.95v 799.745n 0.95v 799.755n 0.95v 804.745n 0.95v 804.755n 0.95v 809.745n 0.95v 809.755n 0.95v 814.745n 0.95v 814.755n 0.95v 819.745n 0.95v 819.755n 0.95v 824.745n 0.95v 824.755n 0.95v 829.745n 0.95v 829.755n 0.0v 834.745n 0.0v 834.755n 0.95v 839.745n 0.95v 839.755n 0.0v 844.745n 0.0v 844.755n 0.95v 849.745n 0.95v 849.755n 0.0v 854.745n 0.0v 854.755n 0.0v 859.745n 0.0v 859.755n 0.95v 864.745n 0.95v 864.755n 0.0v 869.745n 0.0v 869.755n 0.0v 874.745n 0.0v 874.755n 0.95v 879.745n 0.95v 879.755n 0.95v 884.745n 0.95v 884.755n 0.95v 889.745n 0.95v 889.755n 0.0v 894.745n 0.0v 894.755n 0.0v 899.745n 0.0v 899.755n 0.95v 904.745n 0.95v 904.755n 0.95v 909.745n 0.95v 909.755n 0.0v 914.745n 0.0v 914.755n 0.0v 919.745n 0.0v 919.755n 0.0v 924.745n 0.0v 924.755n 0.95v 929.745n 0.95v 929.755n 0.0v 934.745n 0.0v 934.755n 0.0v 939.745n 0.0v 939.755n 0.95v 944.745n 0.95v 944.755n 0.0v 949.745n 0.0v 949.755n 0.95v 954.745n 0.95v 954.755n 0.95v 959.745n 0.95v 959.755n 0.95v 964.745n 0.95v 964.755n 0.0v 969.745n 0.0v 969.755n 0.0v 974.745n 0.0v 974.755n 0.95v 979.745n 0.95v 979.755n 0.0v 984.745n 0.0v 984.755n 0.0v 989.745n 0.0v 989.755n 0.0v 994.745n 0.0v 994.755n 0.95v 999.745n 0.95v 999.755n 0.95v 1004.745n 0.95v 1004.755n 0.95v 1009.745n 0.95v 1009.755n 0.95v 1014.745n 0.95v 1014.755n 0.95v 1019.745n 0.95v 1019.755n 0.95v 1024.745n 0.95v 1024.755n 0.95v )
* (time, data): [(0, 0), (5, 1), (10, 1), (15, 1), (20, 1), (25, 1), (30, 1), (35, 1), (40, 1), (45, 1), (50, 0), (55, 0), (60, 1), (65, 1), (70, 1), (75, 0), (80, 1), (85, 1), (90, 1), (95, 1), (100, 1), (105, 1), (110, 1), (115, 1), (120, 0), (125, 0), (130, 1), (135, 1), (140, 1), (145, 1), (150, 0), (155, 1), (160, 1), (165, 1), (170, 1), (175, 1), (180, 1), (185, 1), (190, 1), (195, 1), (200, 1), (205, 1), (210, 1), (215, 1), (220, 0), (225, 0), (230, 1), (235, 1), (240, 0), (245, 1), (250, 1), (255, 1), (260, 1), (265, 1), (270, 1), (275, 1), (280, 1), (285, 1), (290, 1), (295, 1), (300, 1), (305, 1), (310, 1), (315, 1), (320, 1), (325, 1), (330, 0), (335, 0), (340, 0), (345, 1), (350, 1), (355, 1), (360, 1), (365, 0), (370, 0), (375, 1), (380, 1), (385, 1), (390, 1), (395, 0), (400, 1), (405, 1), (410, 0), (415, 1), (420, 0), (425, 0), (430, 0), (435, 0), (440, 0), (445, 0), (450, 0), (455, 0), (460, 0), (465, 0), (470, 0), (475, 1), (480, 1), (485, 0), (490, 1), (495, 1), (500, 1), (505, 1), (510, 0), (515, 0), (520, 1), (525, 1), (530, 1), (535, 0), (540, 0), (545, 0), (550, 0), (555, 0), (560, 0), (565, 0), (570, 1), (575, 1), (580, 1), (585, 0), (590, 1), (595, 1), (600, 0), (605, 0), (610, 1), (615, 1), (620, 1), (625, 0), (630, 1), (635, 1), (640, 0), (645, 1), (650, 1), (655, 0), (660, 0), (665, 0), (670, 1), (675, 0), (680, 0), (685, 0), (690, 0), (695, 1), (700, 1), (705, 1), (710, 0), (715, 0), (720, 1), (725, 0), (730, 0), (735, 0), (740, 1), (745, 1), (750, 0), (755, 0), (760, 0), (765, 1), (770, 1), (775, 0), (780, 0), (785, 1), (790, 1), (795, 1), (800, 1), (805, 1), (810, 1), (815, 1), (820, 1), (825, 1), (830, 0), (835, 1), (840, 0), (845, 1), (850, 0), (855, 0), (860, 1), (865, 0), (870, 0), (875, 1), (880, 1), (885, 1), (890, 0), (895, 0), (900, 1), (905, 1), (910, 0), (915, 0), (920, 0), (925, 1), (930, 0), (935, 0), (940, 1), (945, 0), (950, 1), (955, 1), (960, 1), (965, 0), (970, 0), (975, 1), (980, 0), (985, 0), (990, 0), (995, 1), (1000, 1), (1005, 1), (1010, 1), (1015, 1), (1020, 1), (1025, 1)]
Va0_8  a0_8  0 PWL (0n 0.0v 4.745n 0.0v 4.755n 0.95v 9.745n 0.95v 9.755n 0.95v 14.745n 0.95v 14.755n 0.95v 19.745n 0.95v 19.755n 0.95v 24.745n 0.95v 24.755n 0.95v 29.745n 0.95v 29.755n 0.95v 34.745n 0.95v 34.755n 0.95v 39.745n 0.95v 39.755n 0.95v 44.745n 0.95v 44.755n 0.95v 49.745n 0.95v 49.755n 0.0v 54.745n 0.0v 54.755n 0.0v 59.745n 0.0v 59.755n 0.95v 64.745n 0.95v 64.755n 0.95v 69.745n 0.95v 69.755n 0.95v 74.745n 0.95v 74.755n 0.0v 79.745n 0.0v 79.755n 0.95v 84.745n 0.95v 84.755n 0.95v 89.745n 0.95v 89.755n 0.95v 94.745n 0.95v 94.755n 0.95v 99.745n 0.95v 99.755n 0.95v 104.745n 0.95v 104.755n 0.95v 109.745n 0.95v 109.755n 0.95v 114.745n 0.95v 114.755n 0.95v 119.745n 0.95v 119.755n 0.0v 124.745n 0.0v 124.755n 0.0v 129.745n 0.0v 129.755n 0.95v 134.745n 0.95v 134.755n 0.95v 139.745n 0.95v 139.755n 0.95v 144.745n 0.95v 144.755n 0.95v 149.745n 0.95v 149.755n 0.0v 154.745n 0.0v 154.755n 0.95v 159.745n 0.95v 159.755n 0.95v 164.745n 0.95v 164.755n 0.95v 169.745n 0.95v 169.755n 0.95v 174.745n 0.95v 174.755n 0.95v 179.745n 0.95v 179.755n 0.95v 184.745n 0.95v 184.755n 0.95v 189.745n 0.95v 189.755n 0.95v 194.745n 0.95v 194.755n 0.95v 199.745n 0.95v 199.755n 0.95v 204.745n 0.95v 204.755n 0.95v 209.745n 0.95v 209.755n 0.95v 214.745n 0.95v 214.755n 0.95v 219.745n 0.95v 219.755n 0.0v 224.745n 0.0v 224.755n 0.0v 229.745n 0.0v 229.755n 0.95v 234.745n 0.95v 234.755n 0.95v 239.745n 0.95v 239.755n 0.0v 244.745n 0.0v 244.755n 0.95v 249.745n 0.95v 249.755n 0.95v 254.745n 0.95v 254.755n 0.95v 259.745n 0.95v 259.755n 0.95v 264.745n 0.95v 264.755n 0.95v 269.745n 0.95v 269.755n 0.95v 274.745n 0.95v 274.755n 0.95v 279.745n 0.95v 279.755n 0.95v 284.745n 0.95v 284.755n 0.95v 289.745n 0.95v 289.755n 0.95v 294.745n 0.95v 294.755n 0.95v 299.745n 0.95v 299.755n 0.95v 304.745n 0.95v 304.755n 0.95v 309.745n 0.95v 309.755n 0.95v 314.745n 0.95v 314.755n 0.95v 319.745n 0.95v 319.755n 0.95v 324.745n 0.95v 324.755n 0.95v 329.745n 0.95v 329.755n 0.0v 334.745n 0.0v 334.755n 0.0v 339.745n 0.0v 339.755n 0.0v 344.745n 0.0v 344.755n 0.95v 349.745n 0.95v 349.755n 0.95v 354.745n 0.95v 354.755n 0.95v 359.745n 0.95v 359.755n 0.95v 364.745n 0.95v 364.755n 0.0v 369.745n 0.0v 369.755n 0.0v 374.745n 0.0v 374.755n 0.95v 379.745n 0.95v 379.755n 0.95v 384.745n 0.95v 384.755n 0.95v 389.745n 0.95v 389.755n 0.95v 394.745n 0.95v 394.755n 0.0v 399.745n 0.0v 399.755n 0.95v 404.745n 0.95v 404.755n 0.95v 409.745n 0.95v 409.755n 0.0v 414.745n 0.0v 414.755n 0.95v 419.745n 0.95v 419.755n 0.0v 424.745n 0.0v 424.755n 0.0v 429.745n 0.0v 429.755n 0.0v 434.745n 0.0v 434.755n 0.0v 439.745n 0.0v 439.755n 0.0v 444.745n 0.0v 444.755n 0.0v 449.745n 0.0v 449.755n 0.0v 454.745n 0.0v 454.755n 0.0v 459.745n 0.0v 459.755n 0.0v 464.745n 0.0v 464.755n 0.0v 469.745n 0.0v 469.755n 0.0v 474.745n 0.0v 474.755n 0.95v 479.745n 0.95v 479.755n 0.95v 484.745n 0.95v 484.755n 0.0v 489.745n 0.0v 489.755n 0.95v 494.745n 0.95v 494.755n 0.95v 499.745n 0.95v 499.755n 0.95v 504.745n 0.95v 504.755n 0.95v 509.745n 0.95v 509.755n 0.0v 514.745n 0.0v 514.755n 0.0v 519.745n 0.0v 519.755n 0.95v 524.745n 0.95v 524.755n 0.95v 529.745n 0.95v 529.755n 0.95v 534.745n 0.95v 534.755n 0.0v 539.745n 0.0v 539.755n 0.0v 544.745n 0.0v 544.755n 0.0v 549.745n 0.0v 549.755n 0.0v 554.745n 0.0v 554.755n 0.0v 559.745n 0.0v 559.755n 0.0v 564.745n 0.0v 564.755n 0.0v 569.745n 0.0v 569.755n 0.95v 574.745n 0.95v 574.755n 0.95v 579.745n 0.95v 579.755n 0.95v 584.745n 0.95v 584.755n 0.0v 589.745n 0.0v 589.755n 0.95v 594.745n 0.95v 594.755n 0.95v 599.745n 0.95v 599.755n 0.0v 604.745n 0.0v 604.755n 0.0v 609.745n 0.0v 609.755n 0.95v 614.745n 0.95v 614.755n 0.95v 619.745n 0.95v 619.755n 0.95v 624.745n 0.95v 624.755n 0.0v 629.745n 0.0v 629.755n 0.95v 634.745n 0.95v 634.755n 0.95v 639.745n 0.95v 639.755n 0.0v 644.745n 0.0v 644.755n 0.95v 649.745n 0.95v 649.755n 0.95v 654.745n 0.95v 654.755n 0.0v 659.745n 0.0v 659.755n 0.0v 664.745n 0.0v 664.755n 0.0v 669.745n 0.0v 669.755n 0.95v 674.745n 0.95v 674.755n 0.0v 679.745n 0.0v 679.755n 0.0v 684.745n 0.0v 684.755n 0.0v 689.745n 0.0v 689.755n 0.0v 694.745n 0.0v 694.755n 0.95v 699.745n 0.95v 699.755n 0.95v 704.745n 0.95v 704.755n 0.95v 709.745n 0.95v 709.755n 0.0v 714.745n 0.0v 714.755n 0.0v 719.745n 0.0v 719.755n 0.95v 724.745n 0.95v 724.755n 0.0v 729.745n 0.0v 729.755n 0.0v 734.745n 0.0v 734.755n 0.0v 739.745n 0.0v 739.755n 0.95v 744.745n 0.95v 744.755n 0.95v 749.745n 0.95v 749.755n 0.0v 754.745n 0.0v 754.755n 0.0v 759.745n 0.0v 759.755n 0.0v 764.745n 0.0v 764.755n 0.95v 769.745n 0.95v 769.755n 0.95v 774.745n 0.95v 774.755n 0.0v 779.745n 0.0v 779.755n 0.0v 784.745n 0.0v 784.755n 0.95v 789.745n 0.95v 789.755n 0.95v 794.745n 0.95v 794.755n 0.95v 799.745n 0.95v 799.755n 0.95v 804.745n 0.95v 804.755n 0.95v 809.745n 0.95v 809.755n 0.95v 814.745n 0.95v 814.755n 0.95v 819.745n 0.95v 819.755n 0.95v 824.745n 0.95v 824.755n 0.95v 829.745n 0.95v 829.755n 0.0v 834.745n 0.0v 834.755n 0.95v 839.745n 0.95v 839.755n 0.0v 844.745n 0.0v 844.755n 0.95v 849.745n 0.95v 849.755n 0.0v 854.745n 0.0v 854.755n 0.0v 859.745n 0.0v 859.755n 0.95v 864.745n 0.95v 864.755n 0.0v 869.745n 0.0v 869.755n 0.0v 874.745n 0.0v 874.755n 0.95v 879.745n 0.95v 879.755n 0.95v 884.745n 0.95v 884.755n 0.95v 889.745n 0.95v 889.755n 0.0v 894.745n 0.0v 894.755n 0.0v 899.745n 0.0v 899.755n 0.95v 904.745n 0.95v 904.755n 0.95v 909.745n 0.95v 909.755n 0.0v 914.745n 0.0v 914.755n 0.0v 919.745n 0.0v 919.755n 0.0v 924.745n 0.0v 924.755n 0.95v 929.745n 0.95v 929.755n 0.0v 934.745n 0.0v 934.755n 0.0v 939.745n 0.0v 939.755n 0.95v 944.745n 0.95v 944.755n 0.0v 949.745n 0.0v 949.755n 0.95v 954.745n 0.95v 954.755n 0.95v 959.745n 0.95v 959.755n 0.95v 964.745n 0.95v 964.755n 0.0v 969.745n 0.0v 969.755n 0.0v 974.745n 0.0v 974.755n 0.95v 979.745n 0.95v 979.755n 0.0v 984.745n 0.0v 984.755n 0.0v 989.745n 0.0v 989.755n 0.0v 994.745n 0.0v 994.755n 0.95v 999.745n 0.95v 999.755n 0.95v 1004.745n 0.95v 1004.755n 0.95v 1009.745n 0.95v 1009.755n 0.95v 1014.745n 0.95v 1014.755n 0.95v 1019.745n 0.95v 1019.755n 0.95v 1024.745n 0.95v 1024.755n 0.95v )
* (time, data): [(0, 0), (5, 1), (10, 1), (15, 1), (20, 1), (25, 1), (30, 1), (35, 1), (40, 1), (45, 1), (50, 0), (55, 0), (60, 1), (65, 1), (70, 1), (75, 0), (80, 1), (85, 1), (90, 1), (95, 1), (100, 1), (105, 1), (110, 1), (115, 1), (120, 0), (125, 0), (130, 1), (135, 1), (140, 1), (145, 1), (150, 0), (155, 1), (160, 1), (165, 1), (170, 1), (175, 1), (180, 1), (185, 1), (190, 1), (195, 1), (200, 1), (205, 1), (210, 1), (215, 1), (220, 0), (225, 0), (230, 1), (235, 1), (240, 0), (245, 1), (250, 1), (255, 1), (260, 1), (265, 1), (270, 1), (275, 1), (280, 1), (285, 1), (290, 1), (295, 1), (300, 1), (305, 1), (310, 1), (315, 1), (320, 1), (325, 1), (330, 0), (335, 0), (340, 0), (345, 1), (350, 1), (355, 1), (360, 1), (365, 0), (370, 0), (375, 1), (380, 1), (385, 1), (390, 1), (395, 0), (400, 1), (405, 1), (410, 0), (415, 1), (420, 0), (425, 0), (430, 0), (435, 0), (440, 0), (445, 0), (450, 0), (455, 0), (460, 0), (465, 0), (470, 0), (475, 1), (480, 1), (485, 0), (490, 1), (495, 1), (500, 1), (505, 1), (510, 0), (515, 0), (520, 1), (525, 1), (530, 1), (535, 0), (540, 0), (545, 0), (550, 0), (555, 0), (560, 0), (565, 0), (570, 1), (575, 1), (580, 1), (585, 0), (590, 1), (595, 1), (600, 0), (605, 0), (610, 1), (615, 1), (620, 1), (625, 0), (630, 1), (635, 1), (640, 0), (645, 1), (650, 1), (655, 0), (660, 0), (665, 0), (670, 1), (675, 0), (680, 0), (685, 0), (690, 0), (695, 1), (700, 1), (705, 1), (710, 0), (715, 0), (720, 1), (725, 0), (730, 0), (735, 0), (740, 1), (745, 1), (750, 0), (755, 0), (760, 0), (765, 1), (770, 1), (775, 0), (780, 0), (785, 1), (790, 1), (795, 1), (800, 1), (805, 1), (810, 1), (815, 1), (820, 1), (825, 1), (830, 0), (835, 1), (840, 0), (845, 1), (850, 0), (855, 0), (860, 1), (865, 0), (870, 0), (875, 1), (880, 1), (885, 1), (890, 0), (895, 0), (900, 1), (905, 1), (910, 0), (915, 0), (920, 0), (925, 1), (930, 0), (935, 0), (940, 1), (945, 0), (950, 1), (955, 1), (960, 1), (965, 0), (970, 0), (975, 1), (980, 0), (985, 0), (990, 0), (995, 1), (1000, 1), (1005, 1), (1010, 1), (1015, 1), (1020, 1), (1025, 1)]
Va0_9  a0_9  0 PWL (0n 0.0v 4.745n 0.0v 4.755n 0.95v 9.745n 0.95v 9.755n 0.95v 14.745n 0.95v 14.755n 0.95v 19.745n 0.95v 19.755n 0.95v 24.745n 0.95v 24.755n 0.95v 29.745n 0.95v 29.755n 0.95v 34.745n 0.95v 34.755n 0.95v 39.745n 0.95v 39.755n 0.95v 44.745n 0.95v 44.755n 0.95v 49.745n 0.95v 49.755n 0.0v 54.745n 0.0v 54.755n 0.0v 59.745n 0.0v 59.755n 0.95v 64.745n 0.95v 64.755n 0.95v 69.745n 0.95v 69.755n 0.95v 74.745n 0.95v 74.755n 0.0v 79.745n 0.0v 79.755n 0.95v 84.745n 0.95v 84.755n 0.95v 89.745n 0.95v 89.755n 0.95v 94.745n 0.95v 94.755n 0.95v 99.745n 0.95v 99.755n 0.95v 104.745n 0.95v 104.755n 0.95v 109.745n 0.95v 109.755n 0.95v 114.745n 0.95v 114.755n 0.95v 119.745n 0.95v 119.755n 0.0v 124.745n 0.0v 124.755n 0.0v 129.745n 0.0v 129.755n 0.95v 134.745n 0.95v 134.755n 0.95v 139.745n 0.95v 139.755n 0.95v 144.745n 0.95v 144.755n 0.95v 149.745n 0.95v 149.755n 0.0v 154.745n 0.0v 154.755n 0.95v 159.745n 0.95v 159.755n 0.95v 164.745n 0.95v 164.755n 0.95v 169.745n 0.95v 169.755n 0.95v 174.745n 0.95v 174.755n 0.95v 179.745n 0.95v 179.755n 0.95v 184.745n 0.95v 184.755n 0.95v 189.745n 0.95v 189.755n 0.95v 194.745n 0.95v 194.755n 0.95v 199.745n 0.95v 199.755n 0.95v 204.745n 0.95v 204.755n 0.95v 209.745n 0.95v 209.755n 0.95v 214.745n 0.95v 214.755n 0.95v 219.745n 0.95v 219.755n 0.0v 224.745n 0.0v 224.755n 0.0v 229.745n 0.0v 229.755n 0.95v 234.745n 0.95v 234.755n 0.95v 239.745n 0.95v 239.755n 0.0v 244.745n 0.0v 244.755n 0.95v 249.745n 0.95v 249.755n 0.95v 254.745n 0.95v 254.755n 0.95v 259.745n 0.95v 259.755n 0.95v 264.745n 0.95v 264.755n 0.95v 269.745n 0.95v 269.755n 0.95v 274.745n 0.95v 274.755n 0.95v 279.745n 0.95v 279.755n 0.95v 284.745n 0.95v 284.755n 0.95v 289.745n 0.95v 289.755n 0.95v 294.745n 0.95v 294.755n 0.95v 299.745n 0.95v 299.755n 0.95v 304.745n 0.95v 304.755n 0.95v 309.745n 0.95v 309.755n 0.95v 314.745n 0.95v 314.755n 0.95v 319.745n 0.95v 319.755n 0.95v 324.745n 0.95v 324.755n 0.95v 329.745n 0.95v 329.755n 0.0v 334.745n 0.0v 334.755n 0.0v 339.745n 0.0v 339.755n 0.0v 344.745n 0.0v 344.755n 0.95v 349.745n 0.95v 349.755n 0.95v 354.745n 0.95v 354.755n 0.95v 359.745n 0.95v 359.755n 0.95v 364.745n 0.95v 364.755n 0.0v 369.745n 0.0v 369.755n 0.0v 374.745n 0.0v 374.755n 0.95v 379.745n 0.95v 379.755n 0.95v 384.745n 0.95v 384.755n 0.95v 389.745n 0.95v 389.755n 0.95v 394.745n 0.95v 394.755n 0.0v 399.745n 0.0v 399.755n 0.95v 404.745n 0.95v 404.755n 0.95v 409.745n 0.95v 409.755n 0.0v 414.745n 0.0v 414.755n 0.95v 419.745n 0.95v 419.755n 0.0v 424.745n 0.0v 424.755n 0.0v 429.745n 0.0v 429.755n 0.0v 434.745n 0.0v 434.755n 0.0v 439.745n 0.0v 439.755n 0.0v 444.745n 0.0v 444.755n 0.0v 449.745n 0.0v 449.755n 0.0v 454.745n 0.0v 454.755n 0.0v 459.745n 0.0v 459.755n 0.0v 464.745n 0.0v 464.755n 0.0v 469.745n 0.0v 469.755n 0.0v 474.745n 0.0v 474.755n 0.95v 479.745n 0.95v 479.755n 0.95v 484.745n 0.95v 484.755n 0.0v 489.745n 0.0v 489.755n 0.95v 494.745n 0.95v 494.755n 0.95v 499.745n 0.95v 499.755n 0.95v 504.745n 0.95v 504.755n 0.95v 509.745n 0.95v 509.755n 0.0v 514.745n 0.0v 514.755n 0.0v 519.745n 0.0v 519.755n 0.95v 524.745n 0.95v 524.755n 0.95v 529.745n 0.95v 529.755n 0.95v 534.745n 0.95v 534.755n 0.0v 539.745n 0.0v 539.755n 0.0v 544.745n 0.0v 544.755n 0.0v 549.745n 0.0v 549.755n 0.0v 554.745n 0.0v 554.755n 0.0v 559.745n 0.0v 559.755n 0.0v 564.745n 0.0v 564.755n 0.0v 569.745n 0.0v 569.755n 0.95v 574.745n 0.95v 574.755n 0.95v 579.745n 0.95v 579.755n 0.95v 584.745n 0.95v 584.755n 0.0v 589.745n 0.0v 589.755n 0.95v 594.745n 0.95v 594.755n 0.95v 599.745n 0.95v 599.755n 0.0v 604.745n 0.0v 604.755n 0.0v 609.745n 0.0v 609.755n 0.95v 614.745n 0.95v 614.755n 0.95v 619.745n 0.95v 619.755n 0.95v 624.745n 0.95v 624.755n 0.0v 629.745n 0.0v 629.755n 0.95v 634.745n 0.95v 634.755n 0.95v 639.745n 0.95v 639.755n 0.0v 644.745n 0.0v 644.755n 0.95v 649.745n 0.95v 649.755n 0.95v 654.745n 0.95v 654.755n 0.0v 659.745n 0.0v 659.755n 0.0v 664.745n 0.0v 664.755n 0.0v 669.745n 0.0v 669.755n 0.95v 674.745n 0.95v 674.755n 0.0v 679.745n 0.0v 679.755n 0.0v 684.745n 0.0v 684.755n 0.0v 689.745n 0.0v 689.755n 0.0v 694.745n 0.0v 694.755n 0.95v 699.745n 0.95v 699.755n 0.95v 704.745n 0.95v 704.755n 0.95v 709.745n 0.95v 709.755n 0.0v 714.745n 0.0v 714.755n 0.0v 719.745n 0.0v 719.755n 0.95v 724.745n 0.95v 724.755n 0.0v 729.745n 0.0v 729.755n 0.0v 734.745n 0.0v 734.755n 0.0v 739.745n 0.0v 739.755n 0.95v 744.745n 0.95v 744.755n 0.95v 749.745n 0.95v 749.755n 0.0v 754.745n 0.0v 754.755n 0.0v 759.745n 0.0v 759.755n 0.0v 764.745n 0.0v 764.755n 0.95v 769.745n 0.95v 769.755n 0.95v 774.745n 0.95v 774.755n 0.0v 779.745n 0.0v 779.755n 0.0v 784.745n 0.0v 784.755n 0.95v 789.745n 0.95v 789.755n 0.95v 794.745n 0.95v 794.755n 0.95v 799.745n 0.95v 799.755n 0.95v 804.745n 0.95v 804.755n 0.95v 809.745n 0.95v 809.755n 0.95v 814.745n 0.95v 814.755n 0.95v 819.745n 0.95v 819.755n 0.95v 824.745n 0.95v 824.755n 0.95v 829.745n 0.95v 829.755n 0.0v 834.745n 0.0v 834.755n 0.95v 839.745n 0.95v 839.755n 0.0v 844.745n 0.0v 844.755n 0.95v 849.745n 0.95v 849.755n 0.0v 854.745n 0.0v 854.755n 0.0v 859.745n 0.0v 859.755n 0.95v 864.745n 0.95v 864.755n 0.0v 869.745n 0.0v 869.755n 0.0v 874.745n 0.0v 874.755n 0.95v 879.745n 0.95v 879.755n 0.95v 884.745n 0.95v 884.755n 0.95v 889.745n 0.95v 889.755n 0.0v 894.745n 0.0v 894.755n 0.0v 899.745n 0.0v 899.755n 0.95v 904.745n 0.95v 904.755n 0.95v 909.745n 0.95v 909.755n 0.0v 914.745n 0.0v 914.755n 0.0v 919.745n 0.0v 919.755n 0.0v 924.745n 0.0v 924.755n 0.95v 929.745n 0.95v 929.755n 0.0v 934.745n 0.0v 934.755n 0.0v 939.745n 0.0v 939.755n 0.95v 944.745n 0.95v 944.755n 0.0v 949.745n 0.0v 949.755n 0.95v 954.745n 0.95v 954.755n 0.95v 959.745n 0.95v 959.755n 0.95v 964.745n 0.95v 964.755n 0.0v 969.745n 0.0v 969.755n 0.0v 974.745n 0.0v 974.755n 0.95v 979.745n 0.95v 979.755n 0.0v 984.745n 0.0v 984.755n 0.0v 989.745n 0.0v 989.755n 0.0v 994.745n 0.0v 994.755n 0.95v 999.745n 0.95v 999.755n 0.95v 1004.745n 0.95v 1004.755n 0.95v 1009.745n 0.95v 1009.755n 0.95v 1014.745n 0.95v 1014.755n 0.95v 1019.745n 0.95v 1019.755n 0.95v 1024.745n 0.95v 1024.755n 0.95v )

 * Generation of control signals
* (time, data): [(0, 1), (5, 0), (10, 0), (15, 0), (20, 0), (25, 0), (30, 1), (35, 0), (40, 0), (45, 1), (50, 0), (55, 0), (60, 0), (65, 1), (70, 1), (75, 0), (80, 0), (85, 0), (90, 1), (95, 0), (100, 0), (105, 0), (110, 1), (115, 0), (120, 0), (125, 1), (130, 0), (135, 1), (140, 1), (145, 1), (150, 0), (155, 0), (160, 0), (165, 0), (170, 0), (175, 1), (180, 0), (185, 0), (190, 0), (195, 1), (200, 0), (205, 0), (210, 0), (215, 1), (220, 0), (225, 0), (230, 0), (235, 0), (240, 0), (245, 0), (250, 1), (255, 1), (260, 1), (265, 0), (270, 0), (275, 0), (280, 0), (285, 1), (290, 0), (295, 0), (300, 0), (305, 0), (310, 0), (315, 1), (320, 0), (325, 0), (330, 0), (335, 1), (340, 1), (345, 0), (350, 1), (355, 0), (360, 0), (365, 0), (370, 0), (375, 0), (380, 1), (385, 0), (390, 1), (395, 0), (400, 0), (405, 1), (410, 0), (415, 0), (420, 0), (425, 0), (430, 1), (435, 0), (440, 1), (445, 1), (450, 0), (455, 1), (460, 0), (465, 0), (470, 0), (475, 0), (480, 0), (485, 0), (490, 0), (495, 0), (500, 1), (505, 0), (510, 0), (515, 1), (520, 0), (525, 0), (530, 0), (535, 0), (540, 1), (545, 0), (550, 0), (555, 1), (560, 0), (565, 0), (570, 0), (575, 1), (580, 0), (585, 0), (590, 0), (595, 0), (600, 0), (605, 0), (610, 0), (615, 0), (620, 1), (625, 0), (630, 0), (635, 0), (640, 0), (645, 0), (650, 1), (655, 0), (660, 0), (665, 0), (670, 0), (675, 0), (680, 0), (685, 0), (690, 1), (695, 0), (700, 0), (705, 1), (710, 0), (715, 1), (720, 0), (725, 0), (730, 1), (735, 0), (740, 0), (745, 1), (750, 0), (755, 1), (760, 0), (765, 0), (770, 0), (775, 0), (780, 0), (785, 0), (790, 0), (795, 0), (800, 0), (805, 1), (810, 0), (815, 0), (820, 0), (825, 0), (830, 0), (835, 0), (840, 0), (845, 0), (850, 0), (855, 1), (860, 0), (865, 0), (870, 1), (875, 0), (880, 0), (885, 0), (890, 0), (895, 0), (900, 0), (905, 0), (910, 0), (915, 1), (920, 0), (925, 0), (930, 0), (935, 0), (940, 0), (945, 0), (950, 0), (955, 1), (960, 0), (965, 0), (970, 0), (975, 0), (980, 0), (985, 0), (990, 0), (995, 0), (1000, 0), (1005, 1), (1010, 1), (1015, 0), (1020, 0), (1025, 1)]
VCSB0 CSB0 0 PWL (0n 0.95v 4.745n 0.95v 4.755n 0.0v 9.745n 0.0v 9.755n 0.0v 14.745n 0.0v 14.755n 0.0v 19.745n 0.0v 19.755n 0.0v 24.745n 0.0v 24.755n 0.0v 29.745n 0.0v 29.755n 0.95v 34.745n 0.95v 34.755n 0.0v 39.745n 0.0v 39.755n 0.0v 44.745n 0.0v 44.755n 0.95v 49.745n 0.95v 49.755n 0.0v 54.745n 0.0v 54.755n 0.0v 59.745n 0.0v 59.755n 0.0v 64.745n 0.0v 64.755n 0.95v 69.745n 0.95v 69.755n 0.95v 74.745n 0.95v 74.755n 0.0v 79.745n 0.0v 79.755n 0.0v 84.745n 0.0v 84.755n 0.0v 89.745n 0.0v 89.755n 0.95v 94.745n 0.95v 94.755n 0.0v 99.745n 0.0v 99.755n 0.0v 104.745n 0.0v 104.755n 0.0v 109.745n 0.0v 109.755n 0.95v 114.745n 0.95v 114.755n 0.0v 119.745n 0.0v 119.755n 0.0v 124.745n 0.0v 124.755n 0.95v 129.745n 0.95v 129.755n 0.0v 134.745n 0.0v 134.755n 0.95v 139.745n 0.95v 139.755n 0.95v 144.745n 0.95v 144.755n 0.95v 149.745n 0.95v 149.755n 0.0v 154.745n 0.0v 154.755n 0.0v 159.745n 0.0v 159.755n 0.0v 164.745n 0.0v 164.755n 0.0v 169.745n 0.0v 169.755n 0.0v 174.745n 0.0v 174.755n 0.95v 179.745n 0.95v 179.755n 0.0v 184.745n 0.0v 184.755n 0.0v 189.745n 0.0v 189.755n 0.0v 194.745n 0.0v 194.755n 0.95v 199.745n 0.95v 199.755n 0.0v 204.745n 0.0v 204.755n 0.0v 209.745n 0.0v 209.755n 0.0v 214.745n 0.0v 214.755n 0.95v 219.745n 0.95v 219.755n 0.0v 224.745n 0.0v 224.755n 0.0v 229.745n 0.0v 229.755n 0.0v 234.745n 0.0v 234.755n 0.0v 239.745n 0.0v 239.755n 0.0v 244.745n 0.0v 244.755n 0.0v 249.745n 0.0v 249.755n 0.95v 254.745n 0.95v 254.755n 0.95v 259.745n 0.95v 259.755n 0.95v 264.745n 0.95v 264.755n 0.0v 269.745n 0.0v 269.755n 0.0v 274.745n 0.0v 274.755n 0.0v 279.745n 0.0v 279.755n 0.0v 284.745n 0.0v 284.755n 0.95v 289.745n 0.95v 289.755n 0.0v 294.745n 0.0v 294.755n 0.0v 299.745n 0.0v 299.755n 0.0v 304.745n 0.0v 304.755n 0.0v 309.745n 0.0v 309.755n 0.0v 314.745n 0.0v 314.755n 0.95v 319.745n 0.95v 319.755n 0.0v 324.745n 0.0v 324.755n 0.0v 329.745n 0.0v 329.755n 0.0v 334.745n 0.0v 334.755n 0.95v 339.745n 0.95v 339.755n 0.95v 344.745n 0.95v 344.755n 0.0v 349.745n 0.0v 349.755n 0.95v 354.745n 0.95v 354.755n 0.0v 359.745n 0.0v 359.755n 0.0v 364.745n 0.0v 364.755n 0.0v 369.745n 0.0v 369.755n 0.0v 374.745n 0.0v 374.755n 0.0v 379.745n 0.0v 379.755n 0.95v 384.745n 0.95v 384.755n 0.0v 389.745n 0.0v 389.755n 0.95v 394.745n 0.95v 394.755n 0.0v 399.745n 0.0v 399.755n 0.0v 404.745n 0.0v 404.755n 0.95v 409.745n 0.95v 409.755n 0.0v 414.745n 0.0v 414.755n 0.0v 419.745n 0.0v 419.755n 0.0v 424.745n 0.0v 424.755n 0.0v 429.745n 0.0v 429.755n 0.95v 434.745n 0.95v 434.755n 0.0v 439.745n 0.0v 439.755n 0.95v 444.745n 0.95v 444.755n 0.95v 449.745n 0.95v 449.755n 0.0v 454.745n 0.0v 454.755n 0.95v 459.745n 0.95v 459.755n 0.0v 464.745n 0.0v 464.755n 0.0v 469.745n 0.0v 469.755n 0.0v 474.745n 0.0v 474.755n 0.0v 479.745n 0.0v 479.755n 0.0v 484.745n 0.0v 484.755n 0.0v 489.745n 0.0v 489.755n 0.0v 494.745n 0.0v 494.755n 0.0v 499.745n 0.0v 499.755n 0.95v 504.745n 0.95v 504.755n 0.0v 509.745n 0.0v 509.755n 0.0v 514.745n 0.0v 514.755n 0.95v 519.745n 0.95v 519.755n 0.0v 524.745n 0.0v 524.755n 0.0v 529.745n 0.0v 529.755n 0.0v 534.745n 0.0v 534.755n 0.0v 539.745n 0.0v 539.755n 0.95v 544.745n 0.95v 544.755n 0.0v 549.745n 0.0v 549.755n 0.0v 554.745n 0.0v 554.755n 0.95v 559.745n 0.95v 559.755n 0.0v 564.745n 0.0v 564.755n 0.0v 569.745n 0.0v 569.755n 0.0v 574.745n 0.0v 574.755n 0.95v 579.745n 0.95v 579.755n 0.0v 584.745n 0.0v 584.755n 0.0v 589.745n 0.0v 589.755n 0.0v 594.745n 0.0v 594.755n 0.0v 599.745n 0.0v 599.755n 0.0v 604.745n 0.0v 604.755n 0.0v 609.745n 0.0v 609.755n 0.0v 614.745n 0.0v 614.755n 0.0v 619.745n 0.0v 619.755n 0.95v 624.745n 0.95v 624.755n 0.0v 629.745n 0.0v 629.755n 0.0v 634.745n 0.0v 634.755n 0.0v 639.745n 0.0v 639.755n 0.0v 644.745n 0.0v 644.755n 0.0v 649.745n 0.0v 649.755n 0.95v 654.745n 0.95v 654.755n 0.0v 659.745n 0.0v 659.755n 0.0v 664.745n 0.0v 664.755n 0.0v 669.745n 0.0v 669.755n 0.0v 674.745n 0.0v 674.755n 0.0v 679.745n 0.0v 679.755n 0.0v 684.745n 0.0v 684.755n 0.0v 689.745n 0.0v 689.755n 0.95v 694.745n 0.95v 694.755n 0.0v 699.745n 0.0v 699.755n 0.0v 704.745n 0.0v 704.755n 0.95v 709.745n 0.95v 709.755n 0.0v 714.745n 0.0v 714.755n 0.95v 719.745n 0.95v 719.755n 0.0v 724.745n 0.0v 724.755n 0.0v 729.745n 0.0v 729.755n 0.95v 734.745n 0.95v 734.755n 0.0v 739.745n 0.0v 739.755n 0.0v 744.745n 0.0v 744.755n 0.95v 749.745n 0.95v 749.755n 0.0v 754.745n 0.0v 754.755n 0.95v 759.745n 0.95v 759.755n 0.0v 764.745n 0.0v 764.755n 0.0v 769.745n 0.0v 769.755n 0.0v 774.745n 0.0v 774.755n 0.0v 779.745n 0.0v 779.755n 0.0v 784.745n 0.0v 784.755n 0.0v 789.745n 0.0v 789.755n 0.0v 794.745n 0.0v 794.755n 0.0v 799.745n 0.0v 799.755n 0.0v 804.745n 0.0v 804.755n 0.95v 809.745n 0.95v 809.755n 0.0v 814.745n 0.0v 814.755n 0.0v 819.745n 0.0v 819.755n 0.0v 824.745n 0.0v 824.755n 0.0v 829.745n 0.0v 829.755n 0.0v 834.745n 0.0v 834.755n 0.0v 839.745n 0.0v 839.755n 0.0v 844.745n 0.0v 844.755n 0.0v 849.745n 0.0v 849.755n 0.0v 854.745n 0.0v 854.755n 0.95v 859.745n 0.95v 859.755n 0.0v 864.745n 0.0v 864.755n 0.0v 869.745n 0.0v 869.755n 0.95v 874.745n 0.95v 874.755n 0.0v 879.745n 0.0v 879.755n 0.0v 884.745n 0.0v 884.755n 0.0v 889.745n 0.0v 889.755n 0.0v 894.745n 0.0v 894.755n 0.0v 899.745n 0.0v 899.755n 0.0v 904.745n 0.0v 904.755n 0.0v 909.745n 0.0v 909.755n 0.0v 914.745n 0.0v 914.755n 0.95v 919.745n 0.95v 919.755n 0.0v 924.745n 0.0v 924.755n 0.0v 929.745n 0.0v 929.755n 0.0v 934.745n 0.0v 934.755n 0.0v 939.745n 0.0v 939.755n 0.0v 944.745n 0.0v 944.755n 0.0v 949.745n 0.0v 949.755n 0.0v 954.745n 0.0v 954.755n 0.95v 959.745n 0.95v 959.755n 0.0v 964.745n 0.0v 964.755n 0.0v 969.745n 0.0v 969.755n 0.0v 974.745n 0.0v 974.755n 0.0v 979.745n 0.0v 979.755n 0.0v 984.745n 0.0v 984.755n 0.0v 989.745n 0.0v 989.755n 0.0v 994.745n 0.0v 994.755n 0.0v 999.745n 0.0v 999.755n 0.0v 1004.745n 0.0v 1004.755n 0.95v 1009.745n 0.95v 1009.755n 0.95v 1014.745n 0.95v 1014.755n 0.0v 1019.745n 0.0v 1019.755n 0.0v 1024.745n 0.0v 1024.755n 0.95v )
* (time, data): [(0, 1), (5, 0), (10, 0), (15, 0), (20, 1), (25, 1), (30, 1), (35, 1), (40, 1), (45, 1), (50, 0), (55, 1), (60, 1), (65, 1), (70, 1), (75, 0), (80, 1), (85, 1), (90, 1), (95, 0), (100, 1), (105, 1), (110, 1), (115, 0), (120, 1), (125, 1), (130, 1), (135, 1), (140, 1), (145, 1), (150, 0), (155, 1), (160, 0), (165, 0), (170, 1), (175, 1), (180, 1), (185, 1), (190, 0), (195, 1), (200, 1), (205, 1), (210, 1), (215, 1), (220, 1), (225, 1), (230, 1), (235, 1), (240, 0), (245, 1), (250, 1), (255, 1), (260, 1), (265, 0), (270, 1), (275, 1), (280, 1), (285, 1), (290, 0), (295, 1), (300, 1), (305, 1), (310, 1), (315, 1), (320, 0), (325, 0), (330, 0), (335, 1), (340, 1), (345, 1), (350, 1), (355, 1), (360, 1), (365, 1), (370, 1), (375, 1), (380, 1), (385, 1), (390, 1), (395, 1), (400, 1), (405, 1), (410, 0), (415, 1), (420, 1), (425, 0), (430, 1), (435, 1), (440, 1), (445, 1), (450, 1), (455, 1), (460, 1), (465, 1), (470, 1), (475, 1), (480, 1), (485, 1), (490, 1), (495, 1), (500, 1), (505, 1), (510, 0), (515, 1), (520, 1), (525, 0), (530, 0), (535, 1), (540, 1), (545, 1), (550, 0), (555, 1), (560, 1), (565, 1), (570, 0), (575, 1), (580, 1), (585, 1), (590, 0), (595, 1), (600, 0), (605, 1), (610, 1), (615, 0), (620, 1), (625, 1), (630, 1), (635, 1), (640, 1), (645, 1), (650, 1), (655, 0), (660, 1), (665, 1), (670, 1), (675, 1), (680, 1), (685, 0), (690, 1), (695, 1), (700, 1), (705, 1), (710, 1), (715, 1), (720, 0), (725, 1), (730, 1), (735, 1), (740, 1), (745, 1), (750, 1), (755, 1), (760, 1), (765, 1), (770, 0), (775, 1), (780, 1), (785, 1), (790, 0), (795, 1), (800, 1), (805, 1), (810, 1), (815, 1), (820, 0), (825, 1), (830, 0), (835, 1), (840, 1), (845, 0), (850, 1), (855, 1), (860, 0), (865, 1), (870, 1), (875, 0), (880, 1), (885, 1), (890, 1), (895, 1), (900, 0), (905, 0), (910, 1), (915, 1), (920, 1), (925, 1), (930, 1), (935, 0), (940, 0), (945, 1), (950, 1), (955, 1), (960, 1), (965, 1), (970, 0), (975, 1), (980, 1), (985, 1), (990, 1), (995, 1), (1000, 0), (1005, 1), (1010, 1), (1015, 1), (1020, 1), (1025, 1)]
VWEB0 WEB0 0 PWL (0n 0.95v 4.745n 0.95v 4.755n 0.0v 9.745n 0.0v 9.755n 0.0v 14.745n 0.0v 14.755n 0.0v 19.745n 0.0v 19.755n 0.95v 24.745n 0.95v 24.755n 0.95v 29.745n 0.95v 29.755n 0.95v 34.745n 0.95v 34.755n 0.95v 39.745n 0.95v 39.755n 0.95v 44.745n 0.95v 44.755n 0.95v 49.745n 0.95v 49.755n 0.0v 54.745n 0.0v 54.755n 0.95v 59.745n 0.95v 59.755n 0.95v 64.745n 0.95v 64.755n 0.95v 69.745n 0.95v 69.755n 0.95v 74.745n 0.95v 74.755n 0.0v 79.745n 0.0v 79.755n 0.95v 84.745n 0.95v 84.755n 0.95v 89.745n 0.95v 89.755n 0.95v 94.745n 0.95v 94.755n 0.0v 99.745n 0.0v 99.755n 0.95v 104.745n 0.95v 104.755n 0.95v 109.745n 0.95v 109.755n 0.95v 114.745n 0.95v 114.755n 0.0v 119.745n 0.0v 119.755n 0.95v 124.745n 0.95v 124.755n 0.95v 129.745n 0.95v 129.755n 0.95v 134.745n 0.95v 134.755n 0.95v 139.745n 0.95v 139.755n 0.95v 144.745n 0.95v 144.755n 0.95v 149.745n 0.95v 149.755n 0.0v 154.745n 0.0v 154.755n 0.95v 159.745n 0.95v 159.755n 0.0v 164.745n 0.0v 164.755n 0.0v 169.745n 0.0v 169.755n 0.95v 174.745n 0.95v 174.755n 0.95v 179.745n 0.95v 179.755n 0.95v 184.745n 0.95v 184.755n 0.95v 189.745n 0.95v 189.755n 0.0v 194.745n 0.0v 194.755n 0.95v 199.745n 0.95v 199.755n 0.95v 204.745n 0.95v 204.755n 0.95v 209.745n 0.95v 209.755n 0.95v 214.745n 0.95v 214.755n 0.95v 219.745n 0.95v 219.755n 0.95v 224.745n 0.95v 224.755n 0.95v 229.745n 0.95v 229.755n 0.95v 234.745n 0.95v 234.755n 0.95v 239.745n 0.95v 239.755n 0.0v 244.745n 0.0v 244.755n 0.95v 249.745n 0.95v 249.755n 0.95v 254.745n 0.95v 254.755n 0.95v 259.745n 0.95v 259.755n 0.95v 264.745n 0.95v 264.755n 0.0v 269.745n 0.0v 269.755n 0.95v 274.745n 0.95v 274.755n 0.95v 279.745n 0.95v 279.755n 0.95v 284.745n 0.95v 284.755n 0.95v 289.745n 0.95v 289.755n 0.0v 294.745n 0.0v 294.755n 0.95v 299.745n 0.95v 299.755n 0.95v 304.745n 0.95v 304.755n 0.95v 309.745n 0.95v 309.755n 0.95v 314.745n 0.95v 314.755n 0.95v 319.745n 0.95v 319.755n 0.0v 324.745n 0.0v 324.755n 0.0v 329.745n 0.0v 329.755n 0.0v 334.745n 0.0v 334.755n 0.95v 339.745n 0.95v 339.755n 0.95v 344.745n 0.95v 344.755n 0.95v 349.745n 0.95v 349.755n 0.95v 354.745n 0.95v 354.755n 0.95v 359.745n 0.95v 359.755n 0.95v 364.745n 0.95v 364.755n 0.95v 369.745n 0.95v 369.755n 0.95v 374.745n 0.95v 374.755n 0.95v 379.745n 0.95v 379.755n 0.95v 384.745n 0.95v 384.755n 0.95v 389.745n 0.95v 389.755n 0.95v 394.745n 0.95v 394.755n 0.95v 399.745n 0.95v 399.755n 0.95v 404.745n 0.95v 404.755n 0.95v 409.745n 0.95v 409.755n 0.0v 414.745n 0.0v 414.755n 0.95v 419.745n 0.95v 419.755n 0.95v 424.745n 0.95v 424.755n 0.0v 429.745n 0.0v 429.755n 0.95v 434.745n 0.95v 434.755n 0.95v 439.745n 0.95v 439.755n 0.95v 444.745n 0.95v 444.755n 0.95v 449.745n 0.95v 449.755n 0.95v 454.745n 0.95v 454.755n 0.95v 459.745n 0.95v 459.755n 0.95v 464.745n 0.95v 464.755n 0.95v 469.745n 0.95v 469.755n 0.95v 474.745n 0.95v 474.755n 0.95v 479.745n 0.95v 479.755n 0.95v 484.745n 0.95v 484.755n 0.95v 489.745n 0.95v 489.755n 0.95v 494.745n 0.95v 494.755n 0.95v 499.745n 0.95v 499.755n 0.95v 504.745n 0.95v 504.755n 0.95v 509.745n 0.95v 509.755n 0.0v 514.745n 0.0v 514.755n 0.95v 519.745n 0.95v 519.755n 0.95v 524.745n 0.95v 524.755n 0.0v 529.745n 0.0v 529.755n 0.0v 534.745n 0.0v 534.755n 0.95v 539.745n 0.95v 539.755n 0.95v 544.745n 0.95v 544.755n 0.95v 549.745n 0.95v 549.755n 0.0v 554.745n 0.0v 554.755n 0.95v 559.745n 0.95v 559.755n 0.95v 564.745n 0.95v 564.755n 0.95v 569.745n 0.95v 569.755n 0.0v 574.745n 0.0v 574.755n 0.95v 579.745n 0.95v 579.755n 0.95v 584.745n 0.95v 584.755n 0.95v 589.745n 0.95v 589.755n 0.0v 594.745n 0.0v 594.755n 0.95v 599.745n 0.95v 599.755n 0.0v 604.745n 0.0v 604.755n 0.95v 609.745n 0.95v 609.755n 0.95v 614.745n 0.95v 614.755n 0.0v 619.745n 0.0v 619.755n 0.95v 624.745n 0.95v 624.755n 0.95v 629.745n 0.95v 629.755n 0.95v 634.745n 0.95v 634.755n 0.95v 639.745n 0.95v 639.755n 0.95v 644.745n 0.95v 644.755n 0.95v 649.745n 0.95v 649.755n 0.95v 654.745n 0.95v 654.755n 0.0v 659.745n 0.0v 659.755n 0.95v 664.745n 0.95v 664.755n 0.95v 669.745n 0.95v 669.755n 0.95v 674.745n 0.95v 674.755n 0.95v 679.745n 0.95v 679.755n 0.95v 684.745n 0.95v 684.755n 0.0v 689.745n 0.0v 689.755n 0.95v 694.745n 0.95v 694.755n 0.95v 699.745n 0.95v 699.755n 0.95v 704.745n 0.95v 704.755n 0.95v 709.745n 0.95v 709.755n 0.95v 714.745n 0.95v 714.755n 0.95v 719.745n 0.95v 719.755n 0.0v 724.745n 0.0v 724.755n 0.95v 729.745n 0.95v 729.755n 0.95v 734.745n 0.95v 734.755n 0.95v 739.745n 0.95v 739.755n 0.95v 744.745n 0.95v 744.755n 0.95v 749.745n 0.95v 749.755n 0.95v 754.745n 0.95v 754.755n 0.95v 759.745n 0.95v 759.755n 0.95v 764.745n 0.95v 764.755n 0.95v 769.745n 0.95v 769.755n 0.0v 774.745n 0.0v 774.755n 0.95v 779.745n 0.95v 779.755n 0.95v 784.745n 0.95v 784.755n 0.95v 789.745n 0.95v 789.755n 0.0v 794.745n 0.0v 794.755n 0.95v 799.745n 0.95v 799.755n 0.95v 804.745n 0.95v 804.755n 0.95v 809.745n 0.95v 809.755n 0.95v 814.745n 0.95v 814.755n 0.95v 819.745n 0.95v 819.755n 0.0v 824.745n 0.0v 824.755n 0.95v 829.745n 0.95v 829.755n 0.0v 834.745n 0.0v 834.755n 0.95v 839.745n 0.95v 839.755n 0.95v 844.745n 0.95v 844.755n 0.0v 849.745n 0.0v 849.755n 0.95v 854.745n 0.95v 854.755n 0.95v 859.745n 0.95v 859.755n 0.0v 864.745n 0.0v 864.755n 0.95v 869.745n 0.95v 869.755n 0.95v 874.745n 0.95v 874.755n 0.0v 879.745n 0.0v 879.755n 0.95v 884.745n 0.95v 884.755n 0.95v 889.745n 0.95v 889.755n 0.95v 894.745n 0.95v 894.755n 0.95v 899.745n 0.95v 899.755n 0.0v 904.745n 0.0v 904.755n 0.0v 909.745n 0.0v 909.755n 0.95v 914.745n 0.95v 914.755n 0.95v 919.745n 0.95v 919.755n 0.95v 924.745n 0.95v 924.755n 0.95v 929.745n 0.95v 929.755n 0.95v 934.745n 0.95v 934.755n 0.0v 939.745n 0.0v 939.755n 0.0v 944.745n 0.0v 944.755n 0.95v 949.745n 0.95v 949.755n 0.95v 954.745n 0.95v 954.755n 0.95v 959.745n 0.95v 959.755n 0.95v 964.745n 0.95v 964.755n 0.95v 969.745n 0.95v 969.755n 0.0v 974.745n 0.0v 974.755n 0.95v 979.745n 0.95v 979.755n 0.95v 984.745n 0.95v 984.755n 0.95v 989.745n 0.95v 989.755n 0.95v 994.745n 0.95v 994.755n 0.95v 999.745n 0.95v 999.755n 0.0v 1004.745n 0.0v 1004.755n 0.95v 1009.745n 0.95v 1009.755n 0.95v 1014.745n 0.95v 1014.755n 0.95v 1019.745n 0.95v 1019.755n 0.95v 1024.745n 0.95v 1024.755n 0.95v )
* PULSE: period=5
Vclk0 clk0 0 PULSE (0 0.95 4.995n 0.01n 0.01n 2.49n 5n)

 * Generation of dout measurements
* CHECK dout0_0 vdout0_0ck4 = 0 time = 25
* CHECK dout0_1 vdout0_1ck4 = 0.95 time = 25
* CHECK dout0_2 vdout0_2ck4 = 0 time = 25
* CHECK dout0_3 vdout0_3ck4 = 0 time = 25
* CHECK dout0_4 vdout0_4ck4 = 0.95 time = 25
* CHECK dout0_5 vdout0_5ck4 = 0 time = 25
* CHECK dout0_6 vdout0_6ck4 = 0.95 time = 25
* CHECK dout0_7 vdout0_7ck4 = 0.95 time = 25
* CHECK dout0_8 vdout0_8ck4 = 0 time = 25
* CHECK dout0_9 vdout0_9ck4 = 0.95 time = 25
* CHECK dout0_10 vdout0_10ck4 = 0 time = 25
* CHECK dout0_11 vdout0_11ck4 = 0 time = 25
* CHECK dout0_12 vdout0_12ck4 = 0 time = 25
* CHECK dout0_13 vdout0_13ck4 = 0 time = 25
* CHECK dout0_14 vdout0_14ck4 = 0.95 time = 25
* CHECK dout0_15 vdout0_15ck4 = 0.95 time = 25
* CHECK dout0_16 vdout0_16ck4 = 0 time = 25
* CHECK dout0_17 vdout0_17ck4 = 0 time = 25
* CHECK dout0_18 vdout0_18ck4 = 0 time = 25
* CHECK dout0_19 vdout0_19ck4 = 0 time = 25
* CHECK dout0_20 vdout0_20ck4 = 0 time = 25
* CHECK dout0_21 vdout0_21ck4 = 0 time = 25
* CHECK dout0_22 vdout0_22ck4 = 0.95 time = 25
* CHECK dout0_23 vdout0_23ck4 = 0 time = 25
* CHECK dout0_24 vdout0_24ck4 = 0 time = 25
* CHECK dout0_25 vdout0_25ck4 = 0 time = 25
* CHECK dout0_26 vdout0_26ck4 = 0 time = 25
* CHECK dout0_27 vdout0_27ck4 = 0 time = 25
* CHECK dout0_28 vdout0_28ck4 = 0.95 time = 25
* CHECK dout0_29 vdout0_29ck4 = 0 time = 25
* CHECK dout0_30 vdout0_30ck4 = 0.95 time = 25
* CHECK dout0_31 vdout0_31ck4 = 0.95 time = 25
* CHECK dout0_0 vdout0_0ck5 = 0.95 time = 30
* CHECK dout0_1 vdout0_1ck5 = 0.95 time = 30
* CHECK dout0_2 vdout0_2ck5 = 0 time = 30
* CHECK dout0_3 vdout0_3ck5 = 0 time = 30
* CHECK dout0_4 vdout0_4ck5 = 0 time = 30
* CHECK dout0_5 vdout0_5ck5 = 0 time = 30
* CHECK dout0_6 vdout0_6ck5 = 0.95 time = 30
* CHECK dout0_7 vdout0_7ck5 = 0.95 time = 30
* CHECK dout0_8 vdout0_8ck5 = 0 time = 30
* CHECK dout0_9 vdout0_9ck5 = 0 time = 30
* CHECK dout0_10 vdout0_10ck5 = 0 time = 30
* CHECK dout0_11 vdout0_11ck5 = 0 time = 30
* CHECK dout0_12 vdout0_12ck5 = 0.95 time = 30
* CHECK dout0_13 vdout0_13ck5 = 0.95 time = 30
* CHECK dout0_14 vdout0_14ck5 = 0.95 time = 30
* CHECK dout0_15 vdout0_15ck5 = 0 time = 30
* CHECK dout0_16 vdout0_16ck5 = 0.95 time = 30
* CHECK dout0_17 vdout0_17ck5 = 0 time = 30
* CHECK dout0_18 vdout0_18ck5 = 0.95 time = 30
* CHECK dout0_19 vdout0_19ck5 = 0 time = 30
* CHECK dout0_20 vdout0_20ck5 = 0 time = 30
* CHECK dout0_21 vdout0_21ck5 = 0 time = 30
* CHECK dout0_22 vdout0_22ck5 = 0 time = 30
* CHECK dout0_23 vdout0_23ck5 = 0.95 time = 30
* CHECK dout0_24 vdout0_24ck5 = 0.95 time = 30
* CHECK dout0_25 vdout0_25ck5 = 0 time = 30
* CHECK dout0_26 vdout0_26ck5 = 0 time = 30
* CHECK dout0_27 vdout0_27ck5 = 0 time = 30
* CHECK dout0_28 vdout0_28ck5 = 0 time = 30
* CHECK dout0_29 vdout0_29ck5 = 0.95 time = 30
* CHECK dout0_30 vdout0_30ck5 = 0 time = 30
* CHECK dout0_31 vdout0_31ck5 = 0 time = 30
* CHECK dout0_0 vdout0_0ck7 = 0.95 time = 40
* CHECK dout0_1 vdout0_1ck7 = 0.95 time = 40
* CHECK dout0_2 vdout0_2ck7 = 0 time = 40
* CHECK dout0_3 vdout0_3ck7 = 0 time = 40
* CHECK dout0_4 vdout0_4ck7 = 0 time = 40
* CHECK dout0_5 vdout0_5ck7 = 0 time = 40
* CHECK dout0_6 vdout0_6ck7 = 0.95 time = 40
* CHECK dout0_7 vdout0_7ck7 = 0.95 time = 40
* CHECK dout0_8 vdout0_8ck7 = 0 time = 40
* CHECK dout0_9 vdout0_9ck7 = 0 time = 40
* CHECK dout0_10 vdout0_10ck7 = 0 time = 40
* CHECK dout0_11 vdout0_11ck7 = 0 time = 40
* CHECK dout0_12 vdout0_12ck7 = 0.95 time = 40
* CHECK dout0_13 vdout0_13ck7 = 0.95 time = 40
* CHECK dout0_14 vdout0_14ck7 = 0.95 time = 40
* CHECK dout0_15 vdout0_15ck7 = 0 time = 40
* CHECK dout0_16 vdout0_16ck7 = 0.95 time = 40
* CHECK dout0_17 vdout0_17ck7 = 0 time = 40
* CHECK dout0_18 vdout0_18ck7 = 0.95 time = 40
* CHECK dout0_19 vdout0_19ck7 = 0 time = 40
* CHECK dout0_20 vdout0_20ck7 = 0 time = 40
* CHECK dout0_21 vdout0_21ck7 = 0 time = 40
* CHECK dout0_22 vdout0_22ck7 = 0 time = 40
* CHECK dout0_23 vdout0_23ck7 = 0.95 time = 40
* CHECK dout0_24 vdout0_24ck7 = 0.95 time = 40
* CHECK dout0_25 vdout0_25ck7 = 0 time = 40
* CHECK dout0_26 vdout0_26ck7 = 0 time = 40
* CHECK dout0_27 vdout0_27ck7 = 0 time = 40
* CHECK dout0_28 vdout0_28ck7 = 0 time = 40
* CHECK dout0_29 vdout0_29ck7 = 0.95 time = 40
* CHECK dout0_30 vdout0_30ck7 = 0 time = 40
* CHECK dout0_31 vdout0_31ck7 = 0 time = 40
* CHECK dout0_0 vdout0_0ck8 = 0.95 time = 45
* CHECK dout0_1 vdout0_1ck8 = 0.95 time = 45
* CHECK dout0_2 vdout0_2ck8 = 0 time = 45
* CHECK dout0_3 vdout0_3ck8 = 0 time = 45
* CHECK dout0_4 vdout0_4ck8 = 0 time = 45
* CHECK dout0_5 vdout0_5ck8 = 0 time = 45
* CHECK dout0_6 vdout0_6ck8 = 0.95 time = 45
* CHECK dout0_7 vdout0_7ck8 = 0.95 time = 45
* CHECK dout0_8 vdout0_8ck8 = 0 time = 45
* CHECK dout0_9 vdout0_9ck8 = 0 time = 45
* CHECK dout0_10 vdout0_10ck8 = 0 time = 45
* CHECK dout0_11 vdout0_11ck8 = 0 time = 45
* CHECK dout0_12 vdout0_12ck8 = 0.95 time = 45
* CHECK dout0_13 vdout0_13ck8 = 0.95 time = 45
* CHECK dout0_14 vdout0_14ck8 = 0.95 time = 45
* CHECK dout0_15 vdout0_15ck8 = 0 time = 45
* CHECK dout0_16 vdout0_16ck8 = 0.95 time = 45
* CHECK dout0_17 vdout0_17ck8 = 0 time = 45
* CHECK dout0_18 vdout0_18ck8 = 0.95 time = 45
* CHECK dout0_19 vdout0_19ck8 = 0 time = 45
* CHECK dout0_20 vdout0_20ck8 = 0 time = 45
* CHECK dout0_21 vdout0_21ck8 = 0 time = 45
* CHECK dout0_22 vdout0_22ck8 = 0 time = 45
* CHECK dout0_23 vdout0_23ck8 = 0.95 time = 45
* CHECK dout0_24 vdout0_24ck8 = 0.95 time = 45
* CHECK dout0_25 vdout0_25ck8 = 0 time = 45
* CHECK dout0_26 vdout0_26ck8 = 0 time = 45
* CHECK dout0_27 vdout0_27ck8 = 0 time = 45
* CHECK dout0_28 vdout0_28ck8 = 0 time = 45
* CHECK dout0_29 vdout0_29ck8 = 0.95 time = 45
* CHECK dout0_30 vdout0_30ck8 = 0 time = 45
* CHECK dout0_31 vdout0_31ck8 = 0 time = 45
* CHECK dout0_0 vdout0_0ck11 = 0.95 time = 60
* CHECK dout0_1 vdout0_1ck11 = 0.95 time = 60
* CHECK dout0_2 vdout0_2ck11 = 0 time = 60
* CHECK dout0_3 vdout0_3ck11 = 0 time = 60
* CHECK dout0_4 vdout0_4ck11 = 0.95 time = 60
* CHECK dout0_5 vdout0_5ck11 = 0.95 time = 60
* CHECK dout0_6 vdout0_6ck11 = 0 time = 60
* CHECK dout0_7 vdout0_7ck11 = 0.95 time = 60
* CHECK dout0_8 vdout0_8ck11 = 0 time = 60
* CHECK dout0_9 vdout0_9ck11 = 0.95 time = 60
* CHECK dout0_10 vdout0_10ck11 = 0 time = 60
* CHECK dout0_11 vdout0_11ck11 = 0 time = 60
* CHECK dout0_12 vdout0_12ck11 = 0.95 time = 60
* CHECK dout0_13 vdout0_13ck11 = 0 time = 60
* CHECK dout0_14 vdout0_14ck11 = 0.95 time = 60
* CHECK dout0_15 vdout0_15ck11 = 0.95 time = 60
* CHECK dout0_16 vdout0_16ck11 = 0.95 time = 60
* CHECK dout0_17 vdout0_17ck11 = 0.95 time = 60
* CHECK dout0_18 vdout0_18ck11 = 0.95 time = 60
* CHECK dout0_19 vdout0_19ck11 = 0.95 time = 60
* CHECK dout0_20 vdout0_20ck11 = 0.95 time = 60
* CHECK dout0_21 vdout0_21ck11 = 0.95 time = 60
* CHECK dout0_22 vdout0_22ck11 = 0 time = 60
* CHECK dout0_23 vdout0_23ck11 = 0 time = 60
* CHECK dout0_24 vdout0_24ck11 = 0.95 time = 60
* CHECK dout0_25 vdout0_25ck11 = 0.95 time = 60
* CHECK dout0_26 vdout0_26ck11 = 0.95 time = 60
* CHECK dout0_27 vdout0_27ck11 = 0 time = 60
* CHECK dout0_28 vdout0_28ck11 = 0.95 time = 60
* CHECK dout0_29 vdout0_29ck11 = 0.95 time = 60
* CHECK dout0_30 vdout0_30ck11 = 0 time = 60
* CHECK dout0_31 vdout0_31ck11 = 0.95 time = 60
* CHECK dout0_0 vdout0_0ck12 = 0.95 time = 65
* CHECK dout0_1 vdout0_1ck12 = 0.95 time = 65
* CHECK dout0_2 vdout0_2ck12 = 0 time = 65
* CHECK dout0_3 vdout0_3ck12 = 0 time = 65
* CHECK dout0_4 vdout0_4ck12 = 0 time = 65
* CHECK dout0_5 vdout0_5ck12 = 0 time = 65
* CHECK dout0_6 vdout0_6ck12 = 0.95 time = 65
* CHECK dout0_7 vdout0_7ck12 = 0.95 time = 65
* CHECK dout0_8 vdout0_8ck12 = 0 time = 65
* CHECK dout0_9 vdout0_9ck12 = 0 time = 65
* CHECK dout0_10 vdout0_10ck12 = 0 time = 65
* CHECK dout0_11 vdout0_11ck12 = 0 time = 65
* CHECK dout0_12 vdout0_12ck12 = 0.95 time = 65
* CHECK dout0_13 vdout0_13ck12 = 0.95 time = 65
* CHECK dout0_14 vdout0_14ck12 = 0.95 time = 65
* CHECK dout0_15 vdout0_15ck12 = 0 time = 65
* CHECK dout0_16 vdout0_16ck12 = 0.95 time = 65
* CHECK dout0_17 vdout0_17ck12 = 0 time = 65
* CHECK dout0_18 vdout0_18ck12 = 0.95 time = 65
* CHECK dout0_19 vdout0_19ck12 = 0 time = 65
* CHECK dout0_20 vdout0_20ck12 = 0 time = 65
* CHECK dout0_21 vdout0_21ck12 = 0 time = 65
* CHECK dout0_22 vdout0_22ck12 = 0 time = 65
* CHECK dout0_23 vdout0_23ck12 = 0.95 time = 65
* CHECK dout0_24 vdout0_24ck12 = 0.95 time = 65
* CHECK dout0_25 vdout0_25ck12 = 0 time = 65
* CHECK dout0_26 vdout0_26ck12 = 0 time = 65
* CHECK dout0_27 vdout0_27ck12 = 0 time = 65
* CHECK dout0_28 vdout0_28ck12 = 0 time = 65
* CHECK dout0_29 vdout0_29ck12 = 0.95 time = 65
* CHECK dout0_30 vdout0_30ck12 = 0 time = 65
* CHECK dout0_31 vdout0_31ck12 = 0 time = 65
* CHECK dout0_0 vdout0_0ck16 = 0 time = 85
* CHECK dout0_1 vdout0_1ck16 = 0.95 time = 85
* CHECK dout0_2 vdout0_2ck16 = 0 time = 85
* CHECK dout0_3 vdout0_3ck16 = 0 time = 85
* CHECK dout0_4 vdout0_4ck16 = 0.95 time = 85
* CHECK dout0_5 vdout0_5ck16 = 0 time = 85
* CHECK dout0_6 vdout0_6ck16 = 0.95 time = 85
* CHECK dout0_7 vdout0_7ck16 = 0.95 time = 85
* CHECK dout0_8 vdout0_8ck16 = 0 time = 85
* CHECK dout0_9 vdout0_9ck16 = 0.95 time = 85
* CHECK dout0_10 vdout0_10ck16 = 0 time = 85
* CHECK dout0_11 vdout0_11ck16 = 0 time = 85
* CHECK dout0_12 vdout0_12ck16 = 0 time = 85
* CHECK dout0_13 vdout0_13ck16 = 0 time = 85
* CHECK dout0_14 vdout0_14ck16 = 0.95 time = 85
* CHECK dout0_15 vdout0_15ck16 = 0.95 time = 85
* CHECK dout0_16 vdout0_16ck16 = 0 time = 85
* CHECK dout0_17 vdout0_17ck16 = 0 time = 85
* CHECK dout0_18 vdout0_18ck16 = 0 time = 85
* CHECK dout0_19 vdout0_19ck16 = 0 time = 85
* CHECK dout0_20 vdout0_20ck16 = 0 time = 85
* CHECK dout0_21 vdout0_21ck16 = 0 time = 85
* CHECK dout0_22 vdout0_22ck16 = 0.95 time = 85
* CHECK dout0_23 vdout0_23ck16 = 0 time = 85
* CHECK dout0_24 vdout0_24ck16 = 0 time = 85
* CHECK dout0_25 vdout0_25ck16 = 0 time = 85
* CHECK dout0_26 vdout0_26ck16 = 0 time = 85
* CHECK dout0_27 vdout0_27ck16 = 0 time = 85
* CHECK dout0_28 vdout0_28ck16 = 0.95 time = 85
* CHECK dout0_29 vdout0_29ck16 = 0 time = 85
* CHECK dout0_30 vdout0_30ck16 = 0.95 time = 85
* CHECK dout0_31 vdout0_31ck16 = 0.95 time = 85
* CHECK dout0_0 vdout0_0ck17 = 0.95 time = 90
* CHECK dout0_1 vdout0_1ck17 = 0.95 time = 90
* CHECK dout0_2 vdout0_2ck17 = 0 time = 90
* CHECK dout0_3 vdout0_3ck17 = 0 time = 90
* CHECK dout0_4 vdout0_4ck17 = 0 time = 90
* CHECK dout0_5 vdout0_5ck17 = 0 time = 90
* CHECK dout0_6 vdout0_6ck17 = 0.95 time = 90
* CHECK dout0_7 vdout0_7ck17 = 0.95 time = 90
* CHECK dout0_8 vdout0_8ck17 = 0 time = 90
* CHECK dout0_9 vdout0_9ck17 = 0 time = 90
* CHECK dout0_10 vdout0_10ck17 = 0 time = 90
* CHECK dout0_11 vdout0_11ck17 = 0 time = 90
* CHECK dout0_12 vdout0_12ck17 = 0.95 time = 90
* CHECK dout0_13 vdout0_13ck17 = 0.95 time = 90
* CHECK dout0_14 vdout0_14ck17 = 0.95 time = 90
* CHECK dout0_15 vdout0_15ck17 = 0 time = 90
* CHECK dout0_16 vdout0_16ck17 = 0.95 time = 90
* CHECK dout0_17 vdout0_17ck17 = 0 time = 90
* CHECK dout0_18 vdout0_18ck17 = 0.95 time = 90
* CHECK dout0_19 vdout0_19ck17 = 0 time = 90
* CHECK dout0_20 vdout0_20ck17 = 0 time = 90
* CHECK dout0_21 vdout0_21ck17 = 0 time = 90
* CHECK dout0_22 vdout0_22ck17 = 0 time = 90
* CHECK dout0_23 vdout0_23ck17 = 0.95 time = 90
* CHECK dout0_24 vdout0_24ck17 = 0.95 time = 90
* CHECK dout0_25 vdout0_25ck17 = 0 time = 90
* CHECK dout0_26 vdout0_26ck17 = 0 time = 90
* CHECK dout0_27 vdout0_27ck17 = 0 time = 90
* CHECK dout0_28 vdout0_28ck17 = 0 time = 90
* CHECK dout0_29 vdout0_29ck17 = 0.95 time = 90
* CHECK dout0_30 vdout0_30ck17 = 0 time = 90
* CHECK dout0_31 vdout0_31ck17 = 0 time = 90
* CHECK dout0_0 vdout0_0ck20 = 0.95 time = 105
* CHECK dout0_1 vdout0_1ck20 = 0.95 time = 105
* CHECK dout0_2 vdout0_2ck20 = 0 time = 105
* CHECK dout0_3 vdout0_3ck20 = 0.95 time = 105
* CHECK dout0_4 vdout0_4ck20 = 0.95 time = 105
* CHECK dout0_5 vdout0_5ck20 = 0 time = 105
* CHECK dout0_6 vdout0_6ck20 = 0 time = 105
* CHECK dout0_7 vdout0_7ck20 = 0 time = 105
* CHECK dout0_8 vdout0_8ck20 = 0 time = 105
* CHECK dout0_9 vdout0_9ck20 = 0 time = 105
* CHECK dout0_10 vdout0_10ck20 = 0.95 time = 105
* CHECK dout0_11 vdout0_11ck20 = 0 time = 105
* CHECK dout0_12 vdout0_12ck20 = 0 time = 105
* CHECK dout0_13 vdout0_13ck20 = 0 time = 105
* CHECK dout0_14 vdout0_14ck20 = 0.95 time = 105
* CHECK dout0_15 vdout0_15ck20 = 0.95 time = 105
* CHECK dout0_16 vdout0_16ck20 = 0.95 time = 105
* CHECK dout0_17 vdout0_17ck20 = 0.95 time = 105
* CHECK dout0_18 vdout0_18ck20 = 0.95 time = 105
* CHECK dout0_19 vdout0_19ck20 = 0 time = 105
* CHECK dout0_20 vdout0_20ck20 = 0.95 time = 105
* CHECK dout0_21 vdout0_21ck20 = 0.95 time = 105
* CHECK dout0_22 vdout0_22ck20 = 0 time = 105
* CHECK dout0_23 vdout0_23ck20 = 0.95 time = 105
* CHECK dout0_24 vdout0_24ck20 = 0 time = 105
* CHECK dout0_25 vdout0_25ck20 = 0.95 time = 105
* CHECK dout0_26 vdout0_26ck20 = 0.95 time = 105
* CHECK dout0_27 vdout0_27ck20 = 0 time = 105
* CHECK dout0_28 vdout0_28ck20 = 0 time = 105
* CHECK dout0_29 vdout0_29ck20 = 0 time = 105
* CHECK dout0_30 vdout0_30ck20 = 0.95 time = 105
* CHECK dout0_31 vdout0_31ck20 = 0.95 time = 105
* CHECK dout0_0 vdout0_0ck21 = 0.95 time = 110
* CHECK dout0_1 vdout0_1ck21 = 0.95 time = 110
* CHECK dout0_2 vdout0_2ck21 = 0 time = 110
* CHECK dout0_3 vdout0_3ck21 = 0.95 time = 110
* CHECK dout0_4 vdout0_4ck21 = 0.95 time = 110
* CHECK dout0_5 vdout0_5ck21 = 0 time = 110
* CHECK dout0_6 vdout0_6ck21 = 0 time = 110
* CHECK dout0_7 vdout0_7ck21 = 0 time = 110
* CHECK dout0_8 vdout0_8ck21 = 0 time = 110
* CHECK dout0_9 vdout0_9ck21 = 0 time = 110
* CHECK dout0_10 vdout0_10ck21 = 0.95 time = 110
* CHECK dout0_11 vdout0_11ck21 = 0 time = 110
* CHECK dout0_12 vdout0_12ck21 = 0 time = 110
* CHECK dout0_13 vdout0_13ck21 = 0 time = 110
* CHECK dout0_14 vdout0_14ck21 = 0.95 time = 110
* CHECK dout0_15 vdout0_15ck21 = 0.95 time = 110
* CHECK dout0_16 vdout0_16ck21 = 0.95 time = 110
* CHECK dout0_17 vdout0_17ck21 = 0.95 time = 110
* CHECK dout0_18 vdout0_18ck21 = 0.95 time = 110
* CHECK dout0_19 vdout0_19ck21 = 0 time = 110
* CHECK dout0_20 vdout0_20ck21 = 0.95 time = 110
* CHECK dout0_21 vdout0_21ck21 = 0.95 time = 110
* CHECK dout0_22 vdout0_22ck21 = 0 time = 110
* CHECK dout0_23 vdout0_23ck21 = 0.95 time = 110
* CHECK dout0_24 vdout0_24ck21 = 0 time = 110
* CHECK dout0_25 vdout0_25ck21 = 0.95 time = 110
* CHECK dout0_26 vdout0_26ck21 = 0.95 time = 110
* CHECK dout0_27 vdout0_27ck21 = 0 time = 110
* CHECK dout0_28 vdout0_28ck21 = 0 time = 110
* CHECK dout0_29 vdout0_29ck21 = 0 time = 110
* CHECK dout0_30 vdout0_30ck21 = 0.95 time = 110
* CHECK dout0_31 vdout0_31ck21 = 0.95 time = 110
* CHECK dout0_0 vdout0_0ck24 = 0 time = 125
* CHECK dout0_1 vdout0_1ck24 = 0.95 time = 125
* CHECK dout0_2 vdout0_2ck24 = 0.95 time = 125
* CHECK dout0_3 vdout0_3ck24 = 0.95 time = 125
* CHECK dout0_4 vdout0_4ck24 = 0 time = 125
* CHECK dout0_5 vdout0_5ck24 = 0.95 time = 125
* CHECK dout0_6 vdout0_6ck24 = 0.95 time = 125
* CHECK dout0_7 vdout0_7ck24 = 0 time = 125
* CHECK dout0_8 vdout0_8ck24 = 0.95 time = 125
* CHECK dout0_9 vdout0_9ck24 = 0 time = 125
* CHECK dout0_10 vdout0_10ck24 = 0.95 time = 125
* CHECK dout0_11 vdout0_11ck24 = 0.95 time = 125
* CHECK dout0_12 vdout0_12ck24 = 0.95 time = 125
* CHECK dout0_13 vdout0_13ck24 = 0.95 time = 125
* CHECK dout0_14 vdout0_14ck24 = 0 time = 125
* CHECK dout0_15 vdout0_15ck24 = 0 time = 125
* CHECK dout0_16 vdout0_16ck24 = 0.95 time = 125
* CHECK dout0_17 vdout0_17ck24 = 0.95 time = 125
* CHECK dout0_18 vdout0_18ck24 = 0 time = 125
* CHECK dout0_19 vdout0_19ck24 = 0 time = 125
* CHECK dout0_20 vdout0_20ck24 = 0 time = 125
* CHECK dout0_21 vdout0_21ck24 = 0 time = 125
* CHECK dout0_22 vdout0_22ck24 = 0 time = 125
* CHECK dout0_23 vdout0_23ck24 = 0 time = 125
* CHECK dout0_24 vdout0_24ck24 = 0 time = 125
* CHECK dout0_25 vdout0_25ck24 = 0.95 time = 125
* CHECK dout0_26 vdout0_26ck24 = 0.95 time = 125
* CHECK dout0_27 vdout0_27ck24 = 0.95 time = 125
* CHECK dout0_28 vdout0_28ck24 = 0 time = 125
* CHECK dout0_29 vdout0_29ck24 = 0.95 time = 125
* CHECK dout0_30 vdout0_30ck24 = 0 time = 125
* CHECK dout0_31 vdout0_31ck24 = 0.95 time = 125
* CHECK dout0_0 vdout0_0ck26 = 0 time = 135
* CHECK dout0_1 vdout0_1ck26 = 0 time = 135
* CHECK dout0_2 vdout0_2ck26 = 0 time = 135
* CHECK dout0_3 vdout0_3ck26 = 0 time = 135
* CHECK dout0_4 vdout0_4ck26 = 0 time = 135
* CHECK dout0_5 vdout0_5ck26 = 0.95 time = 135
* CHECK dout0_6 vdout0_6ck26 = 0 time = 135
* CHECK dout0_7 vdout0_7ck26 = 0 time = 135
* CHECK dout0_8 vdout0_8ck26 = 0.95 time = 135
* CHECK dout0_9 vdout0_9ck26 = 0 time = 135
* CHECK dout0_10 vdout0_10ck26 = 0 time = 135
* CHECK dout0_11 vdout0_11ck26 = 0 time = 135
* CHECK dout0_12 vdout0_12ck26 = 0.95 time = 135
* CHECK dout0_13 vdout0_13ck26 = 0 time = 135
* CHECK dout0_14 vdout0_14ck26 = 0.95 time = 135
* CHECK dout0_15 vdout0_15ck26 = 0.95 time = 135
* CHECK dout0_16 vdout0_16ck26 = 0 time = 135
* CHECK dout0_17 vdout0_17ck26 = 0 time = 135
* CHECK dout0_18 vdout0_18ck26 = 0 time = 135
* CHECK dout0_19 vdout0_19ck26 = 0.95 time = 135
* CHECK dout0_20 vdout0_20ck26 = 0 time = 135
* CHECK dout0_21 vdout0_21ck26 = 0 time = 135
* CHECK dout0_22 vdout0_22ck26 = 0.95 time = 135
* CHECK dout0_23 vdout0_23ck26 = 0.95 time = 135
* CHECK dout0_24 vdout0_24ck26 = 0.95 time = 135
* CHECK dout0_25 vdout0_25ck26 = 0 time = 135
* CHECK dout0_26 vdout0_26ck26 = 0 time = 135
* CHECK dout0_27 vdout0_27ck26 = 0.95 time = 135
* CHECK dout0_28 vdout0_28ck26 = 0.95 time = 135
* CHECK dout0_29 vdout0_29ck26 = 0 time = 135
* CHECK dout0_30 vdout0_30ck26 = 0 time = 135
* CHECK dout0_31 vdout0_31ck26 = 0.95 time = 135
* CHECK dout0_0 vdout0_0ck31 = 0.95 time = 160
* CHECK dout0_1 vdout0_1ck31 = 0.95 time = 160
* CHECK dout0_2 vdout0_2ck31 = 0 time = 160
* CHECK dout0_3 vdout0_3ck31 = 0 time = 160
* CHECK dout0_4 vdout0_4ck31 = 0 time = 160
* CHECK dout0_5 vdout0_5ck31 = 0 time = 160
* CHECK dout0_6 vdout0_6ck31 = 0.95 time = 160
* CHECK dout0_7 vdout0_7ck31 = 0.95 time = 160
* CHECK dout0_8 vdout0_8ck31 = 0 time = 160
* CHECK dout0_9 vdout0_9ck31 = 0 time = 160
* CHECK dout0_10 vdout0_10ck31 = 0 time = 160
* CHECK dout0_11 vdout0_11ck31 = 0 time = 160
* CHECK dout0_12 vdout0_12ck31 = 0.95 time = 160
* CHECK dout0_13 vdout0_13ck31 = 0.95 time = 160
* CHECK dout0_14 vdout0_14ck31 = 0.95 time = 160
* CHECK dout0_15 vdout0_15ck31 = 0 time = 160
* CHECK dout0_16 vdout0_16ck31 = 0.95 time = 160
* CHECK dout0_17 vdout0_17ck31 = 0 time = 160
* CHECK dout0_18 vdout0_18ck31 = 0.95 time = 160
* CHECK dout0_19 vdout0_19ck31 = 0 time = 160
* CHECK dout0_20 vdout0_20ck31 = 0 time = 160
* CHECK dout0_21 vdout0_21ck31 = 0 time = 160
* CHECK dout0_22 vdout0_22ck31 = 0 time = 160
* CHECK dout0_23 vdout0_23ck31 = 0.95 time = 160
* CHECK dout0_24 vdout0_24ck31 = 0.95 time = 160
* CHECK dout0_25 vdout0_25ck31 = 0 time = 160
* CHECK dout0_26 vdout0_26ck31 = 0 time = 160
* CHECK dout0_27 vdout0_27ck31 = 0 time = 160
* CHECK dout0_28 vdout0_28ck31 = 0 time = 160
* CHECK dout0_29 vdout0_29ck31 = 0.95 time = 160
* CHECK dout0_30 vdout0_30ck31 = 0 time = 160
* CHECK dout0_31 vdout0_31ck31 = 0 time = 160
* CHECK dout0_0 vdout0_0ck34 = 0.95 time = 175
* CHECK dout0_1 vdout0_1ck34 = 0.95 time = 175
* CHECK dout0_2 vdout0_2ck34 = 0 time = 175
* CHECK dout0_3 vdout0_3ck34 = 0 time = 175
* CHECK dout0_4 vdout0_4ck34 = 0 time = 175
* CHECK dout0_5 vdout0_5ck34 = 0 time = 175
* CHECK dout0_6 vdout0_6ck34 = 0.95 time = 175
* CHECK dout0_7 vdout0_7ck34 = 0.95 time = 175
* CHECK dout0_8 vdout0_8ck34 = 0 time = 175
* CHECK dout0_9 vdout0_9ck34 = 0 time = 175
* CHECK dout0_10 vdout0_10ck34 = 0 time = 175
* CHECK dout0_11 vdout0_11ck34 = 0 time = 175
* CHECK dout0_12 vdout0_12ck34 = 0.95 time = 175
* CHECK dout0_13 vdout0_13ck34 = 0.95 time = 175
* CHECK dout0_14 vdout0_14ck34 = 0.95 time = 175
* CHECK dout0_15 vdout0_15ck34 = 0 time = 175
* CHECK dout0_16 vdout0_16ck34 = 0.95 time = 175
* CHECK dout0_17 vdout0_17ck34 = 0 time = 175
* CHECK dout0_18 vdout0_18ck34 = 0.95 time = 175
* CHECK dout0_19 vdout0_19ck34 = 0 time = 175
* CHECK dout0_20 vdout0_20ck34 = 0 time = 175
* CHECK dout0_21 vdout0_21ck34 = 0 time = 175
* CHECK dout0_22 vdout0_22ck34 = 0 time = 175
* CHECK dout0_23 vdout0_23ck34 = 0.95 time = 175
* CHECK dout0_24 vdout0_24ck34 = 0.95 time = 175
* CHECK dout0_25 vdout0_25ck34 = 0 time = 175
* CHECK dout0_26 vdout0_26ck34 = 0 time = 175
* CHECK dout0_27 vdout0_27ck34 = 0 time = 175
* CHECK dout0_28 vdout0_28ck34 = 0 time = 175
* CHECK dout0_29 vdout0_29ck34 = 0.95 time = 175
* CHECK dout0_30 vdout0_30ck34 = 0 time = 175
* CHECK dout0_31 vdout0_31ck34 = 0 time = 175
* CHECK dout0_0 vdout0_0ck36 = 0.95 time = 185
* CHECK dout0_1 vdout0_1ck36 = 0.95 time = 185
* CHECK dout0_2 vdout0_2ck36 = 0 time = 185
* CHECK dout0_3 vdout0_3ck36 = 0.95 time = 185
* CHECK dout0_4 vdout0_4ck36 = 0.95 time = 185
* CHECK dout0_5 vdout0_5ck36 = 0 time = 185
* CHECK dout0_6 vdout0_6ck36 = 0 time = 185
* CHECK dout0_7 vdout0_7ck36 = 0 time = 185
* CHECK dout0_8 vdout0_8ck36 = 0 time = 185
* CHECK dout0_9 vdout0_9ck36 = 0 time = 185
* CHECK dout0_10 vdout0_10ck36 = 0.95 time = 185
* CHECK dout0_11 vdout0_11ck36 = 0 time = 185
* CHECK dout0_12 vdout0_12ck36 = 0 time = 185
* CHECK dout0_13 vdout0_13ck36 = 0 time = 185
* CHECK dout0_14 vdout0_14ck36 = 0.95 time = 185
* CHECK dout0_15 vdout0_15ck36 = 0.95 time = 185
* CHECK dout0_16 vdout0_16ck36 = 0.95 time = 185
* CHECK dout0_17 vdout0_17ck36 = 0.95 time = 185
* CHECK dout0_18 vdout0_18ck36 = 0.95 time = 185
* CHECK dout0_19 vdout0_19ck36 = 0 time = 185
* CHECK dout0_20 vdout0_20ck36 = 0.95 time = 185
* CHECK dout0_21 vdout0_21ck36 = 0.95 time = 185
* CHECK dout0_22 vdout0_22ck36 = 0 time = 185
* CHECK dout0_23 vdout0_23ck36 = 0.95 time = 185
* CHECK dout0_24 vdout0_24ck36 = 0 time = 185
* CHECK dout0_25 vdout0_25ck36 = 0.95 time = 185
* CHECK dout0_26 vdout0_26ck36 = 0.95 time = 185
* CHECK dout0_27 vdout0_27ck36 = 0 time = 185
* CHECK dout0_28 vdout0_28ck36 = 0 time = 185
* CHECK dout0_29 vdout0_29ck36 = 0 time = 185
* CHECK dout0_30 vdout0_30ck36 = 0.95 time = 185
* CHECK dout0_31 vdout0_31ck36 = 0.95 time = 185
* CHECK dout0_0 vdout0_0ck37 = 0 time = 190
* CHECK dout0_1 vdout0_1ck37 = 0 time = 190
* CHECK dout0_2 vdout0_2ck37 = 0 time = 190
* CHECK dout0_3 vdout0_3ck37 = 0 time = 190
* CHECK dout0_4 vdout0_4ck37 = 0 time = 190
* CHECK dout0_5 vdout0_5ck37 = 0.95 time = 190
* CHECK dout0_6 vdout0_6ck37 = 0 time = 190
* CHECK dout0_7 vdout0_7ck37 = 0 time = 190
* CHECK dout0_8 vdout0_8ck37 = 0.95 time = 190
* CHECK dout0_9 vdout0_9ck37 = 0 time = 190
* CHECK dout0_10 vdout0_10ck37 = 0 time = 190
* CHECK dout0_11 vdout0_11ck37 = 0 time = 190
* CHECK dout0_12 vdout0_12ck37 = 0.95 time = 190
* CHECK dout0_13 vdout0_13ck37 = 0 time = 190
* CHECK dout0_14 vdout0_14ck37 = 0.95 time = 190
* CHECK dout0_15 vdout0_15ck37 = 0.95 time = 190
* CHECK dout0_16 vdout0_16ck37 = 0 time = 190
* CHECK dout0_17 vdout0_17ck37 = 0 time = 190
* CHECK dout0_18 vdout0_18ck37 = 0 time = 190
* CHECK dout0_19 vdout0_19ck37 = 0.95 time = 190
* CHECK dout0_20 vdout0_20ck37 = 0 time = 190
* CHECK dout0_21 vdout0_21ck37 = 0 time = 190
* CHECK dout0_22 vdout0_22ck37 = 0.95 time = 190
* CHECK dout0_23 vdout0_23ck37 = 0.95 time = 190
* CHECK dout0_24 vdout0_24ck37 = 0.95 time = 190
* CHECK dout0_25 vdout0_25ck37 = 0 time = 190
* CHECK dout0_26 vdout0_26ck37 = 0 time = 190
* CHECK dout0_27 vdout0_27ck37 = 0.95 time = 190
* CHECK dout0_28 vdout0_28ck37 = 0.95 time = 190
* CHECK dout0_29 vdout0_29ck37 = 0 time = 190
* CHECK dout0_30 vdout0_30ck37 = 0 time = 190
* CHECK dout0_31 vdout0_31ck37 = 0.95 time = 190
* CHECK dout0_0 vdout0_0ck40 = 0 time = 205
* CHECK dout0_1 vdout0_1ck40 = 0 time = 205
* CHECK dout0_2 vdout0_2ck40 = 0.95 time = 205
* CHECK dout0_3 vdout0_3ck40 = 0 time = 205
* CHECK dout0_4 vdout0_4ck40 = 0.95 time = 205
* CHECK dout0_5 vdout0_5ck40 = 0.95 time = 205
* CHECK dout0_6 vdout0_6ck40 = 0 time = 205
* CHECK dout0_7 vdout0_7ck40 = 0.95 time = 205
* CHECK dout0_8 vdout0_8ck40 = 0.95 time = 205
* CHECK dout0_9 vdout0_9ck40 = 0.95 time = 205
* CHECK dout0_10 vdout0_10ck40 = 0 time = 205
* CHECK dout0_11 vdout0_11ck40 = 0 time = 205
* CHECK dout0_12 vdout0_12ck40 = 0 time = 205
* CHECK dout0_13 vdout0_13ck40 = 0 time = 205
* CHECK dout0_14 vdout0_14ck40 = 0 time = 205
* CHECK dout0_15 vdout0_15ck40 = 0 time = 205
* CHECK dout0_16 vdout0_16ck40 = 0 time = 205
* CHECK dout0_17 vdout0_17ck40 = 0.95 time = 205
* CHECK dout0_18 vdout0_18ck40 = 0.95 time = 205
* CHECK dout0_19 vdout0_19ck40 = 0.95 time = 205
* CHECK dout0_20 vdout0_20ck40 = 0.95 time = 205
* CHECK dout0_21 vdout0_21ck40 = 0.95 time = 205
* CHECK dout0_22 vdout0_22ck40 = 0.95 time = 205
* CHECK dout0_23 vdout0_23ck40 = 0.95 time = 205
* CHECK dout0_24 vdout0_24ck40 = 0.95 time = 205
* CHECK dout0_25 vdout0_25ck40 = 0.95 time = 205
* CHECK dout0_26 vdout0_26ck40 = 0.95 time = 205
* CHECK dout0_27 vdout0_27ck40 = 0.95 time = 205
* CHECK dout0_28 vdout0_28ck40 = 0.95 time = 205
* CHECK dout0_29 vdout0_29ck40 = 0.95 time = 205
* CHECK dout0_30 vdout0_30ck40 = 0 time = 205
* CHECK dout0_31 vdout0_31ck40 = 0 time = 205
* CHECK dout0_0 vdout0_0ck41 = 0 time = 210
* CHECK dout0_1 vdout0_1ck41 = 0.95 time = 210
* CHECK dout0_2 vdout0_2ck41 = 0 time = 210
* CHECK dout0_3 vdout0_3ck41 = 0.95 time = 210
* CHECK dout0_4 vdout0_4ck41 = 0 time = 210
* CHECK dout0_5 vdout0_5ck41 = 0 time = 210
* CHECK dout0_6 vdout0_6ck41 = 0.95 time = 210
* CHECK dout0_7 vdout0_7ck41 = 0 time = 210
* CHECK dout0_8 vdout0_8ck41 = 0.95 time = 210
* CHECK dout0_9 vdout0_9ck41 = 0 time = 210
* CHECK dout0_10 vdout0_10ck41 = 0.95 time = 210
* CHECK dout0_11 vdout0_11ck41 = 0.95 time = 210
* CHECK dout0_12 vdout0_12ck41 = 0.95 time = 210
* CHECK dout0_13 vdout0_13ck41 = 0 time = 210
* CHECK dout0_14 vdout0_14ck41 = 0 time = 210
* CHECK dout0_15 vdout0_15ck41 = 0.95 time = 210
* CHECK dout0_16 vdout0_16ck41 = 0.95 time = 210
* CHECK dout0_17 vdout0_17ck41 = 0 time = 210
* CHECK dout0_18 vdout0_18ck41 = 0 time = 210
* CHECK dout0_19 vdout0_19ck41 = 0 time = 210
* CHECK dout0_20 vdout0_20ck41 = 0 time = 210
* CHECK dout0_21 vdout0_21ck41 = 0.95 time = 210
* CHECK dout0_22 vdout0_22ck41 = 0 time = 210
* CHECK dout0_23 vdout0_23ck41 = 0 time = 210
* CHECK dout0_24 vdout0_24ck41 = 0.95 time = 210
* CHECK dout0_25 vdout0_25ck41 = 0.95 time = 210
* CHECK dout0_26 vdout0_26ck41 = 0 time = 210
* CHECK dout0_27 vdout0_27ck41 = 0.95 time = 210
* CHECK dout0_28 vdout0_28ck41 = 0 time = 210
* CHECK dout0_29 vdout0_29ck41 = 0.95 time = 210
* CHECK dout0_30 vdout0_30ck41 = 0.95 time = 210
* CHECK dout0_31 vdout0_31ck41 = 0.95 time = 210
* CHECK dout0_0 vdout0_0ck42 = 0.95 time = 215
* CHECK dout0_1 vdout0_1ck42 = 0 time = 215
* CHECK dout0_2 vdout0_2ck42 = 0 time = 215
* CHECK dout0_3 vdout0_3ck42 = 0.95 time = 215
* CHECK dout0_4 vdout0_4ck42 = 0 time = 215
* CHECK dout0_5 vdout0_5ck42 = 0 time = 215
* CHECK dout0_6 vdout0_6ck42 = 0.95 time = 215
* CHECK dout0_7 vdout0_7ck42 = 0 time = 215
* CHECK dout0_8 vdout0_8ck42 = 0 time = 215
* CHECK dout0_9 vdout0_9ck42 = 0 time = 215
* CHECK dout0_10 vdout0_10ck42 = 0 time = 215
* CHECK dout0_11 vdout0_11ck42 = 0.95 time = 215
* CHECK dout0_12 vdout0_12ck42 = 0 time = 215
* CHECK dout0_13 vdout0_13ck42 = 0.95 time = 215
* CHECK dout0_14 vdout0_14ck42 = 0.95 time = 215
* CHECK dout0_15 vdout0_15ck42 = 0 time = 215
* CHECK dout0_16 vdout0_16ck42 = 0 time = 215
* CHECK dout0_17 vdout0_17ck42 = 0 time = 215
* CHECK dout0_18 vdout0_18ck42 = 0 time = 215
* CHECK dout0_19 vdout0_19ck42 = 0 time = 215
* CHECK dout0_20 vdout0_20ck42 = 0.95 time = 215
* CHECK dout0_21 vdout0_21ck42 = 0.95 time = 215
* CHECK dout0_22 vdout0_22ck42 = 0 time = 215
* CHECK dout0_23 vdout0_23ck42 = 0.95 time = 215
* CHECK dout0_24 vdout0_24ck42 = 0.95 time = 215
* CHECK dout0_25 vdout0_25ck42 = 0 time = 215
* CHECK dout0_26 vdout0_26ck42 = 0 time = 215
* CHECK dout0_27 vdout0_27ck42 = 0.95 time = 215
* CHECK dout0_28 vdout0_28ck42 = 0.95 time = 215
* CHECK dout0_29 vdout0_29ck42 = 0 time = 215
* CHECK dout0_30 vdout0_30ck42 = 0 time = 215
* CHECK dout0_31 vdout0_31ck42 = 0.95 time = 215
* CHECK dout0_0 vdout0_0ck44 = 0 time = 225
* CHECK dout0_1 vdout0_1ck44 = 0 time = 225
* CHECK dout0_2 vdout0_2ck44 = 0 time = 225
* CHECK dout0_3 vdout0_3ck44 = 0 time = 225
* CHECK dout0_4 vdout0_4ck44 = 0 time = 225
* CHECK dout0_5 vdout0_5ck44 = 0.95 time = 225
* CHECK dout0_6 vdout0_6ck44 = 0.95 time = 225
* CHECK dout0_7 vdout0_7ck44 = 0 time = 225
* CHECK dout0_8 vdout0_8ck44 = 0 time = 225
* CHECK dout0_9 vdout0_9ck44 = 0.95 time = 225
* CHECK dout0_10 vdout0_10ck44 = 0.95 time = 225
* CHECK dout0_11 vdout0_11ck44 = 0.95 time = 225
* CHECK dout0_12 vdout0_12ck44 = 0 time = 225
* CHECK dout0_13 vdout0_13ck44 = 0 time = 225
* CHECK dout0_14 vdout0_14ck44 = 0 time = 225
* CHECK dout0_15 vdout0_15ck44 = 0.95 time = 225
* CHECK dout0_16 vdout0_16ck44 = 0 time = 225
* CHECK dout0_17 vdout0_17ck44 = 0.95 time = 225
* CHECK dout0_18 vdout0_18ck44 = 0 time = 225
* CHECK dout0_19 vdout0_19ck44 = 0.95 time = 225
* CHECK dout0_20 vdout0_20ck44 = 0.95 time = 225
* CHECK dout0_21 vdout0_21ck44 = 0 time = 225
* CHECK dout0_22 vdout0_22ck44 = 0 time = 225
* CHECK dout0_23 vdout0_23ck44 = 0 time = 225
* CHECK dout0_24 vdout0_24ck44 = 0 time = 225
* CHECK dout0_25 vdout0_25ck44 = 0.95 time = 225
* CHECK dout0_26 vdout0_26ck44 = 0.95 time = 225
* CHECK dout0_27 vdout0_27ck44 = 0 time = 225
* CHECK dout0_28 vdout0_28ck44 = 0.95 time = 225
* CHECK dout0_29 vdout0_29ck44 = 0.95 time = 225
* CHECK dout0_30 vdout0_30ck44 = 0.95 time = 225
* CHECK dout0_31 vdout0_31ck44 = 0.95 time = 225
* CHECK dout0_0 vdout0_0ck45 = 0 time = 230
* CHECK dout0_1 vdout0_1ck45 = 0 time = 230
* CHECK dout0_2 vdout0_2ck45 = 0 time = 230
* CHECK dout0_3 vdout0_3ck45 = 0 time = 230
* CHECK dout0_4 vdout0_4ck45 = 0 time = 230
* CHECK dout0_5 vdout0_5ck45 = 0.95 time = 230
* CHECK dout0_6 vdout0_6ck45 = 0.95 time = 230
* CHECK dout0_7 vdout0_7ck45 = 0 time = 230
* CHECK dout0_8 vdout0_8ck45 = 0 time = 230
* CHECK dout0_9 vdout0_9ck45 = 0.95 time = 230
* CHECK dout0_10 vdout0_10ck45 = 0.95 time = 230
* CHECK dout0_11 vdout0_11ck45 = 0.95 time = 230
* CHECK dout0_12 vdout0_12ck45 = 0 time = 230
* CHECK dout0_13 vdout0_13ck45 = 0 time = 230
* CHECK dout0_14 vdout0_14ck45 = 0 time = 230
* CHECK dout0_15 vdout0_15ck45 = 0.95 time = 230
* CHECK dout0_16 vdout0_16ck45 = 0 time = 230
* CHECK dout0_17 vdout0_17ck45 = 0.95 time = 230
* CHECK dout0_18 vdout0_18ck45 = 0 time = 230
* CHECK dout0_19 vdout0_19ck45 = 0.95 time = 230
* CHECK dout0_20 vdout0_20ck45 = 0.95 time = 230
* CHECK dout0_21 vdout0_21ck45 = 0 time = 230
* CHECK dout0_22 vdout0_22ck45 = 0 time = 230
* CHECK dout0_23 vdout0_23ck45 = 0 time = 230
* CHECK dout0_24 vdout0_24ck45 = 0 time = 230
* CHECK dout0_25 vdout0_25ck45 = 0.95 time = 230
* CHECK dout0_26 vdout0_26ck45 = 0.95 time = 230
* CHECK dout0_27 vdout0_27ck45 = 0 time = 230
* CHECK dout0_28 vdout0_28ck45 = 0.95 time = 230
* CHECK dout0_29 vdout0_29ck45 = 0.95 time = 230
* CHECK dout0_30 vdout0_30ck45 = 0.95 time = 230
* CHECK dout0_31 vdout0_31ck45 = 0.95 time = 230
* CHECK dout0_0 vdout0_0ck46 = 0 time = 235
* CHECK dout0_1 vdout0_1ck46 = 0.95 time = 235
* CHECK dout0_2 vdout0_2ck46 = 0 time = 235
* CHECK dout0_3 vdout0_3ck46 = 0.95 time = 235
* CHECK dout0_4 vdout0_4ck46 = 0 time = 235
* CHECK dout0_5 vdout0_5ck46 = 0 time = 235
* CHECK dout0_6 vdout0_6ck46 = 0.95 time = 235
* CHECK dout0_7 vdout0_7ck46 = 0 time = 235
* CHECK dout0_8 vdout0_8ck46 = 0.95 time = 235
* CHECK dout0_9 vdout0_9ck46 = 0 time = 235
* CHECK dout0_10 vdout0_10ck46 = 0.95 time = 235
* CHECK dout0_11 vdout0_11ck46 = 0.95 time = 235
* CHECK dout0_12 vdout0_12ck46 = 0.95 time = 235
* CHECK dout0_13 vdout0_13ck46 = 0 time = 235
* CHECK dout0_14 vdout0_14ck46 = 0 time = 235
* CHECK dout0_15 vdout0_15ck46 = 0.95 time = 235
* CHECK dout0_16 vdout0_16ck46 = 0.95 time = 235
* CHECK dout0_17 vdout0_17ck46 = 0 time = 235
* CHECK dout0_18 vdout0_18ck46 = 0 time = 235
* CHECK dout0_19 vdout0_19ck46 = 0 time = 235
* CHECK dout0_20 vdout0_20ck46 = 0 time = 235
* CHECK dout0_21 vdout0_21ck46 = 0.95 time = 235
* CHECK dout0_22 vdout0_22ck46 = 0 time = 235
* CHECK dout0_23 vdout0_23ck46 = 0 time = 235
* CHECK dout0_24 vdout0_24ck46 = 0.95 time = 235
* CHECK dout0_25 vdout0_25ck46 = 0.95 time = 235
* CHECK dout0_26 vdout0_26ck46 = 0 time = 235
* CHECK dout0_27 vdout0_27ck46 = 0.95 time = 235
* CHECK dout0_28 vdout0_28ck46 = 0 time = 235
* CHECK dout0_29 vdout0_29ck46 = 0.95 time = 235
* CHECK dout0_30 vdout0_30ck46 = 0.95 time = 235
* CHECK dout0_31 vdout0_31ck46 = 0.95 time = 235
* CHECK dout0_0 vdout0_0ck47 = 0.95 time = 240
* CHECK dout0_1 vdout0_1ck47 = 0 time = 240
* CHECK dout0_2 vdout0_2ck47 = 0 time = 240
* CHECK dout0_3 vdout0_3ck47 = 0.95 time = 240
* CHECK dout0_4 vdout0_4ck47 = 0 time = 240
* CHECK dout0_5 vdout0_5ck47 = 0 time = 240
* CHECK dout0_6 vdout0_6ck47 = 0.95 time = 240
* CHECK dout0_7 vdout0_7ck47 = 0 time = 240
* CHECK dout0_8 vdout0_8ck47 = 0 time = 240
* CHECK dout0_9 vdout0_9ck47 = 0 time = 240
* CHECK dout0_10 vdout0_10ck47 = 0 time = 240
* CHECK dout0_11 vdout0_11ck47 = 0.95 time = 240
* CHECK dout0_12 vdout0_12ck47 = 0 time = 240
* CHECK dout0_13 vdout0_13ck47 = 0.95 time = 240
* CHECK dout0_14 vdout0_14ck47 = 0.95 time = 240
* CHECK dout0_15 vdout0_15ck47 = 0 time = 240
* CHECK dout0_16 vdout0_16ck47 = 0 time = 240
* CHECK dout0_17 vdout0_17ck47 = 0 time = 240
* CHECK dout0_18 vdout0_18ck47 = 0 time = 240
* CHECK dout0_19 vdout0_19ck47 = 0 time = 240
* CHECK dout0_20 vdout0_20ck47 = 0.95 time = 240
* CHECK dout0_21 vdout0_21ck47 = 0.95 time = 240
* CHECK dout0_22 vdout0_22ck47 = 0 time = 240
* CHECK dout0_23 vdout0_23ck47 = 0.95 time = 240
* CHECK dout0_24 vdout0_24ck47 = 0.95 time = 240
* CHECK dout0_25 vdout0_25ck47 = 0 time = 240
* CHECK dout0_26 vdout0_26ck47 = 0 time = 240
* CHECK dout0_27 vdout0_27ck47 = 0.95 time = 240
* CHECK dout0_28 vdout0_28ck47 = 0.95 time = 240
* CHECK dout0_29 vdout0_29ck47 = 0 time = 240
* CHECK dout0_30 vdout0_30ck47 = 0 time = 240
* CHECK dout0_31 vdout0_31ck47 = 0.95 time = 240
* CHECK dout0_0 vdout0_0ck49 = 0.95 time = 250
* CHECK dout0_1 vdout0_1ck49 = 0 time = 250
* CHECK dout0_2 vdout0_2ck49 = 0 time = 250
* CHECK dout0_3 vdout0_3ck49 = 0.95 time = 250
* CHECK dout0_4 vdout0_4ck49 = 0 time = 250
* CHECK dout0_5 vdout0_5ck49 = 0 time = 250
* CHECK dout0_6 vdout0_6ck49 = 0.95 time = 250
* CHECK dout0_7 vdout0_7ck49 = 0 time = 250
* CHECK dout0_8 vdout0_8ck49 = 0 time = 250
* CHECK dout0_9 vdout0_9ck49 = 0 time = 250
* CHECK dout0_10 vdout0_10ck49 = 0 time = 250
* CHECK dout0_11 vdout0_11ck49 = 0.95 time = 250
* CHECK dout0_12 vdout0_12ck49 = 0 time = 250
* CHECK dout0_13 vdout0_13ck49 = 0.95 time = 250
* CHECK dout0_14 vdout0_14ck49 = 0.95 time = 250
* CHECK dout0_15 vdout0_15ck49 = 0 time = 250
* CHECK dout0_16 vdout0_16ck49 = 0 time = 250
* CHECK dout0_17 vdout0_17ck49 = 0 time = 250
* CHECK dout0_18 vdout0_18ck49 = 0 time = 250
* CHECK dout0_19 vdout0_19ck49 = 0 time = 250
* CHECK dout0_20 vdout0_20ck49 = 0.95 time = 250
* CHECK dout0_21 vdout0_21ck49 = 0.95 time = 250
* CHECK dout0_22 vdout0_22ck49 = 0 time = 250
* CHECK dout0_23 vdout0_23ck49 = 0.95 time = 250
* CHECK dout0_24 vdout0_24ck49 = 0.95 time = 250
* CHECK dout0_25 vdout0_25ck49 = 0 time = 250
* CHECK dout0_26 vdout0_26ck49 = 0 time = 250
* CHECK dout0_27 vdout0_27ck49 = 0.95 time = 250
* CHECK dout0_28 vdout0_28ck49 = 0.95 time = 250
* CHECK dout0_29 vdout0_29ck49 = 0 time = 250
* CHECK dout0_30 vdout0_30ck49 = 0 time = 250
* CHECK dout0_31 vdout0_31ck49 = 0.95 time = 250
* CHECK dout0_0 vdout0_0ck54 = 0 time = 275
* CHECK dout0_1 vdout0_1ck54 = 0 time = 275
* CHECK dout0_2 vdout0_2ck54 = 0.95 time = 275
* CHECK dout0_3 vdout0_3ck54 = 0 time = 275
* CHECK dout0_4 vdout0_4ck54 = 0.95 time = 275
* CHECK dout0_5 vdout0_5ck54 = 0.95 time = 275
* CHECK dout0_6 vdout0_6ck54 = 0 time = 275
* CHECK dout0_7 vdout0_7ck54 = 0.95 time = 275
* CHECK dout0_8 vdout0_8ck54 = 0.95 time = 275
* CHECK dout0_9 vdout0_9ck54 = 0.95 time = 275
* CHECK dout0_10 vdout0_10ck54 = 0 time = 275
* CHECK dout0_11 vdout0_11ck54 = 0 time = 275
* CHECK dout0_12 vdout0_12ck54 = 0 time = 275
* CHECK dout0_13 vdout0_13ck54 = 0 time = 275
* CHECK dout0_14 vdout0_14ck54 = 0 time = 275
* CHECK dout0_15 vdout0_15ck54 = 0 time = 275
* CHECK dout0_16 vdout0_16ck54 = 0 time = 275
* CHECK dout0_17 vdout0_17ck54 = 0.95 time = 275
* CHECK dout0_18 vdout0_18ck54 = 0.95 time = 275
* CHECK dout0_19 vdout0_19ck54 = 0.95 time = 275
* CHECK dout0_20 vdout0_20ck54 = 0.95 time = 275
* CHECK dout0_21 vdout0_21ck54 = 0.95 time = 275
* CHECK dout0_22 vdout0_22ck54 = 0.95 time = 275
* CHECK dout0_23 vdout0_23ck54 = 0.95 time = 275
* CHECK dout0_24 vdout0_24ck54 = 0.95 time = 275
* CHECK dout0_25 vdout0_25ck54 = 0.95 time = 275
* CHECK dout0_26 vdout0_26ck54 = 0.95 time = 275
* CHECK dout0_27 vdout0_27ck54 = 0.95 time = 275
* CHECK dout0_28 vdout0_28ck54 = 0.95 time = 275
* CHECK dout0_29 vdout0_29ck54 = 0.95 time = 275
* CHECK dout0_30 vdout0_30ck54 = 0 time = 275
* CHECK dout0_31 vdout0_31ck54 = 0 time = 275
* CHECK dout0_0 vdout0_0ck55 = 0.95 time = 280
* CHECK dout0_1 vdout0_1ck55 = 0.95 time = 280
* CHECK dout0_2 vdout0_2ck55 = 0 time = 280
* CHECK dout0_3 vdout0_3ck55 = 0 time = 280
* CHECK dout0_4 vdout0_4ck55 = 0 time = 280
* CHECK dout0_5 vdout0_5ck55 = 0 time = 280
* CHECK dout0_6 vdout0_6ck55 = 0.95 time = 280
* CHECK dout0_7 vdout0_7ck55 = 0.95 time = 280
* CHECK dout0_8 vdout0_8ck55 = 0 time = 280
* CHECK dout0_9 vdout0_9ck55 = 0 time = 280
* CHECK dout0_10 vdout0_10ck55 = 0 time = 280
* CHECK dout0_11 vdout0_11ck55 = 0 time = 280
* CHECK dout0_12 vdout0_12ck55 = 0.95 time = 280
* CHECK dout0_13 vdout0_13ck55 = 0.95 time = 280
* CHECK dout0_14 vdout0_14ck55 = 0.95 time = 280
* CHECK dout0_15 vdout0_15ck55 = 0 time = 280
* CHECK dout0_16 vdout0_16ck55 = 0.95 time = 280
* CHECK dout0_17 vdout0_17ck55 = 0 time = 280
* CHECK dout0_18 vdout0_18ck55 = 0.95 time = 280
* CHECK dout0_19 vdout0_19ck55 = 0 time = 280
* CHECK dout0_20 vdout0_20ck55 = 0 time = 280
* CHECK dout0_21 vdout0_21ck55 = 0 time = 280
* CHECK dout0_22 vdout0_22ck55 = 0 time = 280
* CHECK dout0_23 vdout0_23ck55 = 0.95 time = 280
* CHECK dout0_24 vdout0_24ck55 = 0.95 time = 280
* CHECK dout0_25 vdout0_25ck55 = 0 time = 280
* CHECK dout0_26 vdout0_26ck55 = 0 time = 280
* CHECK dout0_27 vdout0_27ck55 = 0 time = 280
* CHECK dout0_28 vdout0_28ck55 = 0 time = 280
* CHECK dout0_29 vdout0_29ck55 = 0.95 time = 280
* CHECK dout0_30 vdout0_30ck55 = 0 time = 280
* CHECK dout0_31 vdout0_31ck55 = 0 time = 280
* CHECK dout0_0 vdout0_0ck56 = 0.95 time = 285
* CHECK dout0_1 vdout0_1ck56 = 0 time = 285
* CHECK dout0_2 vdout0_2ck56 = 0 time = 285
* CHECK dout0_3 vdout0_3ck56 = 0.95 time = 285
* CHECK dout0_4 vdout0_4ck56 = 0 time = 285
* CHECK dout0_5 vdout0_5ck56 = 0 time = 285
* CHECK dout0_6 vdout0_6ck56 = 0.95 time = 285
* CHECK dout0_7 vdout0_7ck56 = 0 time = 285
* CHECK dout0_8 vdout0_8ck56 = 0 time = 285
* CHECK dout0_9 vdout0_9ck56 = 0 time = 285
* CHECK dout0_10 vdout0_10ck56 = 0 time = 285
* CHECK dout0_11 vdout0_11ck56 = 0.95 time = 285
* CHECK dout0_12 vdout0_12ck56 = 0 time = 285
* CHECK dout0_13 vdout0_13ck56 = 0.95 time = 285
* CHECK dout0_14 vdout0_14ck56 = 0.95 time = 285
* CHECK dout0_15 vdout0_15ck56 = 0 time = 285
* CHECK dout0_16 vdout0_16ck56 = 0 time = 285
* CHECK dout0_17 vdout0_17ck56 = 0 time = 285
* CHECK dout0_18 vdout0_18ck56 = 0 time = 285
* CHECK dout0_19 vdout0_19ck56 = 0 time = 285
* CHECK dout0_20 vdout0_20ck56 = 0.95 time = 285
* CHECK dout0_21 vdout0_21ck56 = 0.95 time = 285
* CHECK dout0_22 vdout0_22ck56 = 0 time = 285
* CHECK dout0_23 vdout0_23ck56 = 0.95 time = 285
* CHECK dout0_24 vdout0_24ck56 = 0.95 time = 285
* CHECK dout0_25 vdout0_25ck56 = 0 time = 285
* CHECK dout0_26 vdout0_26ck56 = 0 time = 285
* CHECK dout0_27 vdout0_27ck56 = 0.95 time = 285
* CHECK dout0_28 vdout0_28ck56 = 0.95 time = 285
* CHECK dout0_29 vdout0_29ck56 = 0 time = 285
* CHECK dout0_30 vdout0_30ck56 = 0 time = 285
* CHECK dout0_31 vdout0_31ck56 = 0.95 time = 285
* CHECK dout0_0 vdout0_0ck59 = 0.95 time = 300
* CHECK dout0_1 vdout0_1ck59 = 0 time = 300
* CHECK dout0_2 vdout0_2ck59 = 0 time = 300
* CHECK dout0_3 vdout0_3ck59 = 0.95 time = 300
* CHECK dout0_4 vdout0_4ck59 = 0 time = 300
* CHECK dout0_5 vdout0_5ck59 = 0 time = 300
* CHECK dout0_6 vdout0_6ck59 = 0.95 time = 300
* CHECK dout0_7 vdout0_7ck59 = 0 time = 300
* CHECK dout0_8 vdout0_8ck59 = 0 time = 300
* CHECK dout0_9 vdout0_9ck59 = 0 time = 300
* CHECK dout0_10 vdout0_10ck59 = 0 time = 300
* CHECK dout0_11 vdout0_11ck59 = 0.95 time = 300
* CHECK dout0_12 vdout0_12ck59 = 0 time = 300
* CHECK dout0_13 vdout0_13ck59 = 0.95 time = 300
* CHECK dout0_14 vdout0_14ck59 = 0.95 time = 300
* CHECK dout0_15 vdout0_15ck59 = 0 time = 300
* CHECK dout0_16 vdout0_16ck59 = 0 time = 300
* CHECK dout0_17 vdout0_17ck59 = 0 time = 300
* CHECK dout0_18 vdout0_18ck59 = 0 time = 300
* CHECK dout0_19 vdout0_19ck59 = 0 time = 300
* CHECK dout0_20 vdout0_20ck59 = 0.95 time = 300
* CHECK dout0_21 vdout0_21ck59 = 0.95 time = 300
* CHECK dout0_22 vdout0_22ck59 = 0 time = 300
* CHECK dout0_23 vdout0_23ck59 = 0.95 time = 300
* CHECK dout0_24 vdout0_24ck59 = 0.95 time = 300
* CHECK dout0_25 vdout0_25ck59 = 0 time = 300
* CHECK dout0_26 vdout0_26ck59 = 0 time = 300
* CHECK dout0_27 vdout0_27ck59 = 0.95 time = 300
* CHECK dout0_28 vdout0_28ck59 = 0.95 time = 300
* CHECK dout0_29 vdout0_29ck59 = 0 time = 300
* CHECK dout0_30 vdout0_30ck59 = 0 time = 300
* CHECK dout0_31 vdout0_31ck59 = 0.95 time = 300
* CHECK dout0_0 vdout0_0ck60 = 0 time = 305
* CHECK dout0_1 vdout0_1ck60 = 0 time = 305
* CHECK dout0_2 vdout0_2ck60 = 0 time = 305
* CHECK dout0_3 vdout0_3ck60 = 0.95 time = 305
* CHECK dout0_4 vdout0_4ck60 = 0.95 time = 305
* CHECK dout0_5 vdout0_5ck60 = 0.95 time = 305
* CHECK dout0_6 vdout0_6ck60 = 0.95 time = 305
* CHECK dout0_7 vdout0_7ck60 = 0 time = 305
* CHECK dout0_8 vdout0_8ck60 = 0 time = 305
* CHECK dout0_9 vdout0_9ck60 = 0.95 time = 305
* CHECK dout0_10 vdout0_10ck60 = 0 time = 305
* CHECK dout0_11 vdout0_11ck60 = 0 time = 305
* CHECK dout0_12 vdout0_12ck60 = 0.95 time = 305
* CHECK dout0_13 vdout0_13ck60 = 0 time = 305
* CHECK dout0_14 vdout0_14ck60 = 0 time = 305
* CHECK dout0_15 vdout0_15ck60 = 0 time = 305
* CHECK dout0_16 vdout0_16ck60 = 0.95 time = 305
* CHECK dout0_17 vdout0_17ck60 = 0 time = 305
* CHECK dout0_18 vdout0_18ck60 = 0 time = 305
* CHECK dout0_19 vdout0_19ck60 = 0.95 time = 305
* CHECK dout0_20 vdout0_20ck60 = 0 time = 305
* CHECK dout0_21 vdout0_21ck60 = 0.95 time = 305
* CHECK dout0_22 vdout0_22ck60 = 0 time = 305
* CHECK dout0_23 vdout0_23ck60 = 0 time = 305
* CHECK dout0_24 vdout0_24ck60 = 0.95 time = 305
* CHECK dout0_25 vdout0_25ck60 = 0.95 time = 305
* CHECK dout0_26 vdout0_26ck60 = 0 time = 305
* CHECK dout0_27 vdout0_27ck60 = 0.95 time = 305
* CHECK dout0_28 vdout0_28ck60 = 0 time = 305
* CHECK dout0_29 vdout0_29ck60 = 0.95 time = 305
* CHECK dout0_30 vdout0_30ck60 = 0.95 time = 305
* CHECK dout0_31 vdout0_31ck60 = 0 time = 305
* CHECK dout0_0 vdout0_0ck61 = 0.95 time = 310
* CHECK dout0_1 vdout0_1ck61 = 0.95 time = 310
* CHECK dout0_2 vdout0_2ck61 = 0 time = 310
* CHECK dout0_3 vdout0_3ck61 = 0 time = 310
* CHECK dout0_4 vdout0_4ck61 = 0 time = 310
* CHECK dout0_5 vdout0_5ck61 = 0 time = 310
* CHECK dout0_6 vdout0_6ck61 = 0.95 time = 310
* CHECK dout0_7 vdout0_7ck61 = 0.95 time = 310
* CHECK dout0_8 vdout0_8ck61 = 0 time = 310
* CHECK dout0_9 vdout0_9ck61 = 0 time = 310
* CHECK dout0_10 vdout0_10ck61 = 0 time = 310
* CHECK dout0_11 vdout0_11ck61 = 0 time = 310
* CHECK dout0_12 vdout0_12ck61 = 0.95 time = 310
* CHECK dout0_13 vdout0_13ck61 = 0.95 time = 310
* CHECK dout0_14 vdout0_14ck61 = 0.95 time = 310
* CHECK dout0_15 vdout0_15ck61 = 0 time = 310
* CHECK dout0_16 vdout0_16ck61 = 0.95 time = 310
* CHECK dout0_17 vdout0_17ck61 = 0 time = 310
* CHECK dout0_18 vdout0_18ck61 = 0.95 time = 310
* CHECK dout0_19 vdout0_19ck61 = 0 time = 310
* CHECK dout0_20 vdout0_20ck61 = 0 time = 310
* CHECK dout0_21 vdout0_21ck61 = 0 time = 310
* CHECK dout0_22 vdout0_22ck61 = 0 time = 310
* CHECK dout0_23 vdout0_23ck61 = 0.95 time = 310
* CHECK dout0_24 vdout0_24ck61 = 0.95 time = 310
* CHECK dout0_25 vdout0_25ck61 = 0 time = 310
* CHECK dout0_26 vdout0_26ck61 = 0 time = 310
* CHECK dout0_27 vdout0_27ck61 = 0 time = 310
* CHECK dout0_28 vdout0_28ck61 = 0 time = 310
* CHECK dout0_29 vdout0_29ck61 = 0.95 time = 310
* CHECK dout0_30 vdout0_30ck61 = 0 time = 310
* CHECK dout0_31 vdout0_31ck61 = 0 time = 310
* CHECK dout0_0 vdout0_0ck62 = 0.95 time = 315
* CHECK dout0_1 vdout0_1ck62 = 0.95 time = 315
* CHECK dout0_2 vdout0_2ck62 = 0 time = 315
* CHECK dout0_3 vdout0_3ck62 = 0 time = 315
* CHECK dout0_4 vdout0_4ck62 = 0 time = 315
* CHECK dout0_5 vdout0_5ck62 = 0 time = 315
* CHECK dout0_6 vdout0_6ck62 = 0.95 time = 315
* CHECK dout0_7 vdout0_7ck62 = 0.95 time = 315
* CHECK dout0_8 vdout0_8ck62 = 0 time = 315
* CHECK dout0_9 vdout0_9ck62 = 0 time = 315
* CHECK dout0_10 vdout0_10ck62 = 0 time = 315
* CHECK dout0_11 vdout0_11ck62 = 0 time = 315
* CHECK dout0_12 vdout0_12ck62 = 0.95 time = 315
* CHECK dout0_13 vdout0_13ck62 = 0.95 time = 315
* CHECK dout0_14 vdout0_14ck62 = 0.95 time = 315
* CHECK dout0_15 vdout0_15ck62 = 0 time = 315
* CHECK dout0_16 vdout0_16ck62 = 0.95 time = 315
* CHECK dout0_17 vdout0_17ck62 = 0 time = 315
* CHECK dout0_18 vdout0_18ck62 = 0.95 time = 315
* CHECK dout0_19 vdout0_19ck62 = 0 time = 315
* CHECK dout0_20 vdout0_20ck62 = 0 time = 315
* CHECK dout0_21 vdout0_21ck62 = 0 time = 315
* CHECK dout0_22 vdout0_22ck62 = 0 time = 315
* CHECK dout0_23 vdout0_23ck62 = 0.95 time = 315
* CHECK dout0_24 vdout0_24ck62 = 0.95 time = 315
* CHECK dout0_25 vdout0_25ck62 = 0 time = 315
* CHECK dout0_26 vdout0_26ck62 = 0 time = 315
* CHECK dout0_27 vdout0_27ck62 = 0 time = 315
* CHECK dout0_28 vdout0_28ck62 = 0 time = 315
* CHECK dout0_29 vdout0_29ck62 = 0.95 time = 315
* CHECK dout0_30 vdout0_30ck62 = 0 time = 315
* CHECK dout0_31 vdout0_31ck62 = 0 time = 315
* CHECK dout0_0 vdout0_0ck69 = 0.95 time = 350
* CHECK dout0_1 vdout0_1ck69 = 0.95 time = 350
* CHECK dout0_2 vdout0_2ck69 = 0 time = 350
* CHECK dout0_3 vdout0_3ck69 = 0.95 time = 350
* CHECK dout0_4 vdout0_4ck69 = 0 time = 350
* CHECK dout0_5 vdout0_5ck69 = 0.95 time = 350
* CHECK dout0_6 vdout0_6ck69 = 0 time = 350
* CHECK dout0_7 vdout0_7ck69 = 0.95 time = 350
* CHECK dout0_8 vdout0_8ck69 = 0.95 time = 350
* CHECK dout0_9 vdout0_9ck69 = 0 time = 350
* CHECK dout0_10 vdout0_10ck69 = 0 time = 350
* CHECK dout0_11 vdout0_11ck69 = 0 time = 350
* CHECK dout0_12 vdout0_12ck69 = 0 time = 350
* CHECK dout0_13 vdout0_13ck69 = 0.95 time = 350
* CHECK dout0_14 vdout0_14ck69 = 0.95 time = 350
* CHECK dout0_15 vdout0_15ck69 = 0.95 time = 350
* CHECK dout0_16 vdout0_16ck69 = 0 time = 350
* CHECK dout0_17 vdout0_17ck69 = 0.95 time = 350
* CHECK dout0_18 vdout0_18ck69 = 0.95 time = 350
* CHECK dout0_19 vdout0_19ck69 = 0 time = 350
* CHECK dout0_20 vdout0_20ck69 = 0.95 time = 350
* CHECK dout0_21 vdout0_21ck69 = 0 time = 350
* CHECK dout0_22 vdout0_22ck69 = 0 time = 350
* CHECK dout0_23 vdout0_23ck69 = 0.95 time = 350
* CHECK dout0_24 vdout0_24ck69 = 0.95 time = 350
* CHECK dout0_25 vdout0_25ck69 = 0.95 time = 350
* CHECK dout0_26 vdout0_26ck69 = 0.95 time = 350
* CHECK dout0_27 vdout0_27ck69 = 0.95 time = 350
* CHECK dout0_28 vdout0_28ck69 = 0 time = 350
* CHECK dout0_29 vdout0_29ck69 = 0 time = 350
* CHECK dout0_30 vdout0_30ck69 = 0 time = 350
* CHECK dout0_31 vdout0_31ck69 = 0.95 time = 350
* CHECK dout0_0 vdout0_0ck71 = 0.95 time = 360
* CHECK dout0_1 vdout0_1ck71 = 0.95 time = 360
* CHECK dout0_2 vdout0_2ck71 = 0 time = 360
* CHECK dout0_3 vdout0_3ck71 = 0.95 time = 360
* CHECK dout0_4 vdout0_4ck71 = 0 time = 360
* CHECK dout0_5 vdout0_5ck71 = 0.95 time = 360
* CHECK dout0_6 vdout0_6ck71 = 0 time = 360
* CHECK dout0_7 vdout0_7ck71 = 0.95 time = 360
* CHECK dout0_8 vdout0_8ck71 = 0.95 time = 360
* CHECK dout0_9 vdout0_9ck71 = 0 time = 360
* CHECK dout0_10 vdout0_10ck71 = 0 time = 360
* CHECK dout0_11 vdout0_11ck71 = 0 time = 360
* CHECK dout0_12 vdout0_12ck71 = 0 time = 360
* CHECK dout0_13 vdout0_13ck71 = 0.95 time = 360
* CHECK dout0_14 vdout0_14ck71 = 0.95 time = 360
* CHECK dout0_15 vdout0_15ck71 = 0.95 time = 360
* CHECK dout0_16 vdout0_16ck71 = 0 time = 360
* CHECK dout0_17 vdout0_17ck71 = 0.95 time = 360
* CHECK dout0_18 vdout0_18ck71 = 0.95 time = 360
* CHECK dout0_19 vdout0_19ck71 = 0 time = 360
* CHECK dout0_20 vdout0_20ck71 = 0.95 time = 360
* CHECK dout0_21 vdout0_21ck71 = 0 time = 360
* CHECK dout0_22 vdout0_22ck71 = 0 time = 360
* CHECK dout0_23 vdout0_23ck71 = 0.95 time = 360
* CHECK dout0_24 vdout0_24ck71 = 0.95 time = 360
* CHECK dout0_25 vdout0_25ck71 = 0.95 time = 360
* CHECK dout0_26 vdout0_26ck71 = 0.95 time = 360
* CHECK dout0_27 vdout0_27ck71 = 0.95 time = 360
* CHECK dout0_28 vdout0_28ck71 = 0 time = 360
* CHECK dout0_29 vdout0_29ck71 = 0 time = 360
* CHECK dout0_30 vdout0_30ck71 = 0 time = 360
* CHECK dout0_31 vdout0_31ck71 = 0.95 time = 360
* CHECK dout0_0 vdout0_0ck72 = 0 time = 365
* CHECK dout0_1 vdout0_1ck72 = 0 time = 365
* CHECK dout0_2 vdout0_2ck72 = 0.95 time = 365
* CHECK dout0_3 vdout0_3ck72 = 0 time = 365
* CHECK dout0_4 vdout0_4ck72 = 0.95 time = 365
* CHECK dout0_5 vdout0_5ck72 = 0.95 time = 365
* CHECK dout0_6 vdout0_6ck72 = 0 time = 365
* CHECK dout0_7 vdout0_7ck72 = 0.95 time = 365
* CHECK dout0_8 vdout0_8ck72 = 0.95 time = 365
* CHECK dout0_9 vdout0_9ck72 = 0.95 time = 365
* CHECK dout0_10 vdout0_10ck72 = 0 time = 365
* CHECK dout0_11 vdout0_11ck72 = 0 time = 365
* CHECK dout0_12 vdout0_12ck72 = 0 time = 365
* CHECK dout0_13 vdout0_13ck72 = 0 time = 365
* CHECK dout0_14 vdout0_14ck72 = 0 time = 365
* CHECK dout0_15 vdout0_15ck72 = 0 time = 365
* CHECK dout0_16 vdout0_16ck72 = 0 time = 365
* CHECK dout0_17 vdout0_17ck72 = 0.95 time = 365
* CHECK dout0_18 vdout0_18ck72 = 0.95 time = 365
* CHECK dout0_19 vdout0_19ck72 = 0.95 time = 365
* CHECK dout0_20 vdout0_20ck72 = 0.95 time = 365
* CHECK dout0_21 vdout0_21ck72 = 0.95 time = 365
* CHECK dout0_22 vdout0_22ck72 = 0.95 time = 365
* CHECK dout0_23 vdout0_23ck72 = 0.95 time = 365
* CHECK dout0_24 vdout0_24ck72 = 0.95 time = 365
* CHECK dout0_25 vdout0_25ck72 = 0.95 time = 365
* CHECK dout0_26 vdout0_26ck72 = 0.95 time = 365
* CHECK dout0_27 vdout0_27ck72 = 0.95 time = 365
* CHECK dout0_28 vdout0_28ck72 = 0.95 time = 365
* CHECK dout0_29 vdout0_29ck72 = 0.95 time = 365
* CHECK dout0_30 vdout0_30ck72 = 0 time = 365
* CHECK dout0_31 vdout0_31ck72 = 0 time = 365
* CHECK dout0_0 vdout0_0ck73 = 0 time = 370
* CHECK dout0_1 vdout0_1ck73 = 0 time = 370
* CHECK dout0_2 vdout0_2ck73 = 0 time = 370
* CHECK dout0_3 vdout0_3ck73 = 0 time = 370
* CHECK dout0_4 vdout0_4ck73 = 0 time = 370
* CHECK dout0_5 vdout0_5ck73 = 0.95 time = 370
* CHECK dout0_6 vdout0_6ck73 = 0.95 time = 370
* CHECK dout0_7 vdout0_7ck73 = 0 time = 370
* CHECK dout0_8 vdout0_8ck73 = 0 time = 370
* CHECK dout0_9 vdout0_9ck73 = 0.95 time = 370
* CHECK dout0_10 vdout0_10ck73 = 0.95 time = 370
* CHECK dout0_11 vdout0_11ck73 = 0.95 time = 370
* CHECK dout0_12 vdout0_12ck73 = 0 time = 370
* CHECK dout0_13 vdout0_13ck73 = 0 time = 370
* CHECK dout0_14 vdout0_14ck73 = 0 time = 370
* CHECK dout0_15 vdout0_15ck73 = 0.95 time = 370
* CHECK dout0_16 vdout0_16ck73 = 0 time = 370
* CHECK dout0_17 vdout0_17ck73 = 0.95 time = 370
* CHECK dout0_18 vdout0_18ck73 = 0 time = 370
* CHECK dout0_19 vdout0_19ck73 = 0.95 time = 370
* CHECK dout0_20 vdout0_20ck73 = 0.95 time = 370
* CHECK dout0_21 vdout0_21ck73 = 0 time = 370
* CHECK dout0_22 vdout0_22ck73 = 0 time = 370
* CHECK dout0_23 vdout0_23ck73 = 0 time = 370
* CHECK dout0_24 vdout0_24ck73 = 0 time = 370
* CHECK dout0_25 vdout0_25ck73 = 0.95 time = 370
* CHECK dout0_26 vdout0_26ck73 = 0.95 time = 370
* CHECK dout0_27 vdout0_27ck73 = 0 time = 370
* CHECK dout0_28 vdout0_28ck73 = 0.95 time = 370
* CHECK dout0_29 vdout0_29ck73 = 0.95 time = 370
* CHECK dout0_30 vdout0_30ck73 = 0.95 time = 370
* CHECK dout0_31 vdout0_31ck73 = 0.95 time = 370
* CHECK dout0_0 vdout0_0ck74 = 0 time = 375
* CHECK dout0_1 vdout0_1ck74 = 0 time = 375
* CHECK dout0_2 vdout0_2ck74 = 0 time = 375
* CHECK dout0_3 vdout0_3ck74 = 0 time = 375
* CHECK dout0_4 vdout0_4ck74 = 0 time = 375
* CHECK dout0_5 vdout0_5ck74 = 0.95 time = 375
* CHECK dout0_6 vdout0_6ck74 = 0.95 time = 375
* CHECK dout0_7 vdout0_7ck74 = 0 time = 375
* CHECK dout0_8 vdout0_8ck74 = 0 time = 375
* CHECK dout0_9 vdout0_9ck74 = 0.95 time = 375
* CHECK dout0_10 vdout0_10ck74 = 0.95 time = 375
* CHECK dout0_11 vdout0_11ck74 = 0.95 time = 375
* CHECK dout0_12 vdout0_12ck74 = 0 time = 375
* CHECK dout0_13 vdout0_13ck74 = 0 time = 375
* CHECK dout0_14 vdout0_14ck74 = 0 time = 375
* CHECK dout0_15 vdout0_15ck74 = 0.95 time = 375
* CHECK dout0_16 vdout0_16ck74 = 0 time = 375
* CHECK dout0_17 vdout0_17ck74 = 0.95 time = 375
* CHECK dout0_18 vdout0_18ck74 = 0 time = 375
* CHECK dout0_19 vdout0_19ck74 = 0.95 time = 375
* CHECK dout0_20 vdout0_20ck74 = 0.95 time = 375
* CHECK dout0_21 vdout0_21ck74 = 0 time = 375
* CHECK dout0_22 vdout0_22ck74 = 0 time = 375
* CHECK dout0_23 vdout0_23ck74 = 0 time = 375
* CHECK dout0_24 vdout0_24ck74 = 0 time = 375
* CHECK dout0_25 vdout0_25ck74 = 0.95 time = 375
* CHECK dout0_26 vdout0_26ck74 = 0.95 time = 375
* CHECK dout0_27 vdout0_27ck74 = 0 time = 375
* CHECK dout0_28 vdout0_28ck74 = 0.95 time = 375
* CHECK dout0_29 vdout0_29ck74 = 0.95 time = 375
* CHECK dout0_30 vdout0_30ck74 = 0.95 time = 375
* CHECK dout0_31 vdout0_31ck74 = 0.95 time = 375
* CHECK dout0_0 vdout0_0ck75 = 0.95 time = 380
* CHECK dout0_1 vdout0_1ck75 = 0 time = 380
* CHECK dout0_2 vdout0_2ck75 = 0.95 time = 380
* CHECK dout0_3 vdout0_3ck75 = 0 time = 380
* CHECK dout0_4 vdout0_4ck75 = 0.95 time = 380
* CHECK dout0_5 vdout0_5ck75 = 0.95 time = 380
* CHECK dout0_6 vdout0_6ck75 = 0.95 time = 380
* CHECK dout0_7 vdout0_7ck75 = 0 time = 380
* CHECK dout0_8 vdout0_8ck75 = 0.95 time = 380
* CHECK dout0_9 vdout0_9ck75 = 0 time = 380
* CHECK dout0_10 vdout0_10ck75 = 0 time = 380
* CHECK dout0_11 vdout0_11ck75 = 0 time = 380
* CHECK dout0_12 vdout0_12ck75 = 0 time = 380
* CHECK dout0_13 vdout0_13ck75 = 0 time = 380
* CHECK dout0_14 vdout0_14ck75 = 0 time = 380
* CHECK dout0_15 vdout0_15ck75 = 0.95 time = 380
* CHECK dout0_16 vdout0_16ck75 = 0.95 time = 380
* CHECK dout0_17 vdout0_17ck75 = 0 time = 380
* CHECK dout0_18 vdout0_18ck75 = 0 time = 380
* CHECK dout0_19 vdout0_19ck75 = 0 time = 380
* CHECK dout0_20 vdout0_20ck75 = 0.95 time = 380
* CHECK dout0_21 vdout0_21ck75 = 0.95 time = 380
* CHECK dout0_22 vdout0_22ck75 = 0 time = 380
* CHECK dout0_23 vdout0_23ck75 = 0.95 time = 380
* CHECK dout0_24 vdout0_24ck75 = 0 time = 380
* CHECK dout0_25 vdout0_25ck75 = 0.95 time = 380
* CHECK dout0_26 vdout0_26ck75 = 0.95 time = 380
* CHECK dout0_27 vdout0_27ck75 = 0.95 time = 380
* CHECK dout0_28 vdout0_28ck75 = 0 time = 380
* CHECK dout0_29 vdout0_29ck75 = 0 time = 380
* CHECK dout0_30 vdout0_30ck75 = 0 time = 380
* CHECK dout0_31 vdout0_31ck75 = 0 time = 380
* CHECK dout0_0 vdout0_0ck77 = 0.95 time = 390
* CHECK dout0_1 vdout0_1ck77 = 0.95 time = 390
* CHECK dout0_2 vdout0_2ck77 = 0 time = 390
* CHECK dout0_3 vdout0_3ck77 = 0 time = 390
* CHECK dout0_4 vdout0_4ck77 = 0 time = 390
* CHECK dout0_5 vdout0_5ck77 = 0 time = 390
* CHECK dout0_6 vdout0_6ck77 = 0.95 time = 390
* CHECK dout0_7 vdout0_7ck77 = 0.95 time = 390
* CHECK dout0_8 vdout0_8ck77 = 0 time = 390
* CHECK dout0_9 vdout0_9ck77 = 0 time = 390
* CHECK dout0_10 vdout0_10ck77 = 0 time = 390
* CHECK dout0_11 vdout0_11ck77 = 0 time = 390
* CHECK dout0_12 vdout0_12ck77 = 0.95 time = 390
* CHECK dout0_13 vdout0_13ck77 = 0.95 time = 390
* CHECK dout0_14 vdout0_14ck77 = 0.95 time = 390
* CHECK dout0_15 vdout0_15ck77 = 0 time = 390
* CHECK dout0_16 vdout0_16ck77 = 0.95 time = 390
* CHECK dout0_17 vdout0_17ck77 = 0 time = 390
* CHECK dout0_18 vdout0_18ck77 = 0.95 time = 390
* CHECK dout0_19 vdout0_19ck77 = 0 time = 390
* CHECK dout0_20 vdout0_20ck77 = 0 time = 390
* CHECK dout0_21 vdout0_21ck77 = 0 time = 390
* CHECK dout0_22 vdout0_22ck77 = 0 time = 390
* CHECK dout0_23 vdout0_23ck77 = 0.95 time = 390
* CHECK dout0_24 vdout0_24ck77 = 0.95 time = 390
* CHECK dout0_25 vdout0_25ck77 = 0 time = 390
* CHECK dout0_26 vdout0_26ck77 = 0 time = 390
* CHECK dout0_27 vdout0_27ck77 = 0 time = 390
* CHECK dout0_28 vdout0_28ck77 = 0 time = 390
* CHECK dout0_29 vdout0_29ck77 = 0.95 time = 390
* CHECK dout0_30 vdout0_30ck77 = 0 time = 390
* CHECK dout0_31 vdout0_31ck77 = 0 time = 390
* CHECK dout0_0 vdout0_0ck79 = 0 time = 400
* CHECK dout0_1 vdout0_1ck79 = 0.95 time = 400
* CHECK dout0_2 vdout0_2ck79 = 0.95 time = 400
* CHECK dout0_3 vdout0_3ck79 = 0.95 time = 400
* CHECK dout0_4 vdout0_4ck79 = 0 time = 400
* CHECK dout0_5 vdout0_5ck79 = 0.95 time = 400
* CHECK dout0_6 vdout0_6ck79 = 0.95 time = 400
* CHECK dout0_7 vdout0_7ck79 = 0 time = 400
* CHECK dout0_8 vdout0_8ck79 = 0.95 time = 400
* CHECK dout0_9 vdout0_9ck79 = 0 time = 400
* CHECK dout0_10 vdout0_10ck79 = 0.95 time = 400
* CHECK dout0_11 vdout0_11ck79 = 0.95 time = 400
* CHECK dout0_12 vdout0_12ck79 = 0.95 time = 400
* CHECK dout0_13 vdout0_13ck79 = 0.95 time = 400
* CHECK dout0_14 vdout0_14ck79 = 0 time = 400
* CHECK dout0_15 vdout0_15ck79 = 0 time = 400
* CHECK dout0_16 vdout0_16ck79 = 0.95 time = 400
* CHECK dout0_17 vdout0_17ck79 = 0.95 time = 400
* CHECK dout0_18 vdout0_18ck79 = 0 time = 400
* CHECK dout0_19 vdout0_19ck79 = 0 time = 400
* CHECK dout0_20 vdout0_20ck79 = 0 time = 400
* CHECK dout0_21 vdout0_21ck79 = 0 time = 400
* CHECK dout0_22 vdout0_22ck79 = 0 time = 400
* CHECK dout0_23 vdout0_23ck79 = 0 time = 400
* CHECK dout0_24 vdout0_24ck79 = 0 time = 400
* CHECK dout0_25 vdout0_25ck79 = 0.95 time = 400
* CHECK dout0_26 vdout0_26ck79 = 0.95 time = 400
* CHECK dout0_27 vdout0_27ck79 = 0.95 time = 400
* CHECK dout0_28 vdout0_28ck79 = 0 time = 400
* CHECK dout0_29 vdout0_29ck79 = 0.95 time = 400
* CHECK dout0_30 vdout0_30ck79 = 0 time = 400
* CHECK dout0_31 vdout0_31ck79 = 0.95 time = 400
* CHECK dout0_0 vdout0_0ck80 = 0.95 time = 405
* CHECK dout0_1 vdout0_1ck80 = 0.95 time = 405
* CHECK dout0_2 vdout0_2ck80 = 0 time = 405
* CHECK dout0_3 vdout0_3ck80 = 0.95 time = 405
* CHECK dout0_4 vdout0_4ck80 = 0 time = 405
* CHECK dout0_5 vdout0_5ck80 = 0.95 time = 405
* CHECK dout0_6 vdout0_6ck80 = 0 time = 405
* CHECK dout0_7 vdout0_7ck80 = 0.95 time = 405
* CHECK dout0_8 vdout0_8ck80 = 0.95 time = 405
* CHECK dout0_9 vdout0_9ck80 = 0 time = 405
* CHECK dout0_10 vdout0_10ck80 = 0 time = 405
* CHECK dout0_11 vdout0_11ck80 = 0 time = 405
* CHECK dout0_12 vdout0_12ck80 = 0 time = 405
* CHECK dout0_13 vdout0_13ck80 = 0.95 time = 405
* CHECK dout0_14 vdout0_14ck80 = 0.95 time = 405
* CHECK dout0_15 vdout0_15ck80 = 0.95 time = 405
* CHECK dout0_16 vdout0_16ck80 = 0 time = 405
* CHECK dout0_17 vdout0_17ck80 = 0.95 time = 405
* CHECK dout0_18 vdout0_18ck80 = 0.95 time = 405
* CHECK dout0_19 vdout0_19ck80 = 0 time = 405
* CHECK dout0_20 vdout0_20ck80 = 0.95 time = 405
* CHECK dout0_21 vdout0_21ck80 = 0 time = 405
* CHECK dout0_22 vdout0_22ck80 = 0 time = 405
* CHECK dout0_23 vdout0_23ck80 = 0.95 time = 405
* CHECK dout0_24 vdout0_24ck80 = 0.95 time = 405
* CHECK dout0_25 vdout0_25ck80 = 0.95 time = 405
* CHECK dout0_26 vdout0_26ck80 = 0.95 time = 405
* CHECK dout0_27 vdout0_27ck80 = 0.95 time = 405
* CHECK dout0_28 vdout0_28ck80 = 0 time = 405
* CHECK dout0_29 vdout0_29ck80 = 0 time = 405
* CHECK dout0_30 vdout0_30ck80 = 0 time = 405
* CHECK dout0_31 vdout0_31ck80 = 0.95 time = 405
* CHECK dout0_0 vdout0_0ck83 = 0.95 time = 420
* CHECK dout0_1 vdout0_1ck83 = 0.95 time = 420
* CHECK dout0_2 vdout0_2ck83 = 0 time = 420
* CHECK dout0_3 vdout0_3ck83 = 0.95 time = 420
* CHECK dout0_4 vdout0_4ck83 = 0 time = 420
* CHECK dout0_5 vdout0_5ck83 = 0.95 time = 420
* CHECK dout0_6 vdout0_6ck83 = 0 time = 420
* CHECK dout0_7 vdout0_7ck83 = 0.95 time = 420
* CHECK dout0_8 vdout0_8ck83 = 0.95 time = 420
* CHECK dout0_9 vdout0_9ck83 = 0 time = 420
* CHECK dout0_10 vdout0_10ck83 = 0 time = 420
* CHECK dout0_11 vdout0_11ck83 = 0 time = 420
* CHECK dout0_12 vdout0_12ck83 = 0 time = 420
* CHECK dout0_13 vdout0_13ck83 = 0.95 time = 420
* CHECK dout0_14 vdout0_14ck83 = 0.95 time = 420
* CHECK dout0_15 vdout0_15ck83 = 0.95 time = 420
* CHECK dout0_16 vdout0_16ck83 = 0 time = 420
* CHECK dout0_17 vdout0_17ck83 = 0.95 time = 420
* CHECK dout0_18 vdout0_18ck83 = 0.95 time = 420
* CHECK dout0_19 vdout0_19ck83 = 0 time = 420
* CHECK dout0_20 vdout0_20ck83 = 0.95 time = 420
* CHECK dout0_21 vdout0_21ck83 = 0 time = 420
* CHECK dout0_22 vdout0_22ck83 = 0 time = 420
* CHECK dout0_23 vdout0_23ck83 = 0.95 time = 420
* CHECK dout0_24 vdout0_24ck83 = 0.95 time = 420
* CHECK dout0_25 vdout0_25ck83 = 0.95 time = 420
* CHECK dout0_26 vdout0_26ck83 = 0.95 time = 420
* CHECK dout0_27 vdout0_27ck83 = 0.95 time = 420
* CHECK dout0_28 vdout0_28ck83 = 0 time = 420
* CHECK dout0_29 vdout0_29ck83 = 0 time = 420
* CHECK dout0_30 vdout0_30ck83 = 0 time = 420
* CHECK dout0_31 vdout0_31ck83 = 0.95 time = 420
* CHECK dout0_0 vdout0_0ck84 = 0 time = 425
* CHECK dout0_1 vdout0_1ck84 = 0.95 time = 425
* CHECK dout0_2 vdout0_2ck84 = 0.95 time = 425
* CHECK dout0_3 vdout0_3ck84 = 0 time = 425
* CHECK dout0_4 vdout0_4ck84 = 0 time = 425
* CHECK dout0_5 vdout0_5ck84 = 0.95 time = 425
* CHECK dout0_6 vdout0_6ck84 = 0.95 time = 425
* CHECK dout0_7 vdout0_7ck84 = 0.95 time = 425
* CHECK dout0_8 vdout0_8ck84 = 0.95 time = 425
* CHECK dout0_9 vdout0_9ck84 = 0 time = 425
* CHECK dout0_10 vdout0_10ck84 = 0 time = 425
* CHECK dout0_11 vdout0_11ck84 = 0 time = 425
* CHECK dout0_12 vdout0_12ck84 = 0.95 time = 425
* CHECK dout0_13 vdout0_13ck84 = 0.95 time = 425
* CHECK dout0_14 vdout0_14ck84 = 0 time = 425
* CHECK dout0_15 vdout0_15ck84 = 0 time = 425
* CHECK dout0_16 vdout0_16ck84 = 0 time = 425
* CHECK dout0_17 vdout0_17ck84 = 0.95 time = 425
* CHECK dout0_18 vdout0_18ck84 = 0 time = 425
* CHECK dout0_19 vdout0_19ck84 = 0.95 time = 425
* CHECK dout0_20 vdout0_20ck84 = 0 time = 425
* CHECK dout0_21 vdout0_21ck84 = 0 time = 425
* CHECK dout0_22 vdout0_22ck84 = 0 time = 425
* CHECK dout0_23 vdout0_23ck84 = 0 time = 425
* CHECK dout0_24 vdout0_24ck84 = 0.95 time = 425
* CHECK dout0_25 vdout0_25ck84 = 0.95 time = 425
* CHECK dout0_26 vdout0_26ck84 = 0 time = 425
* CHECK dout0_27 vdout0_27ck84 = 0 time = 425
* CHECK dout0_28 vdout0_28ck84 = 0 time = 425
* CHECK dout0_29 vdout0_29ck84 = 0.95 time = 425
* CHECK dout0_30 vdout0_30ck84 = 0 time = 425
* CHECK dout0_31 vdout0_31ck84 = 0 time = 425
* CHECK dout0_0 vdout0_0ck87 = 0.95 time = 440
* CHECK dout0_1 vdout0_1ck87 = 0.95 time = 440
* CHECK dout0_2 vdout0_2ck87 = 0 time = 440
* CHECK dout0_3 vdout0_3ck87 = 0.95 time = 440
* CHECK dout0_4 vdout0_4ck87 = 0.95 time = 440
* CHECK dout0_5 vdout0_5ck87 = 0.95 time = 440
* CHECK dout0_6 vdout0_6ck87 = 0 time = 440
* CHECK dout0_7 vdout0_7ck87 = 0 time = 440
* CHECK dout0_8 vdout0_8ck87 = 0.95 time = 440
* CHECK dout0_9 vdout0_9ck87 = 0 time = 440
* CHECK dout0_10 vdout0_10ck87 = 0.95 time = 440
* CHECK dout0_11 vdout0_11ck87 = 0.95 time = 440
* CHECK dout0_12 vdout0_12ck87 = 0 time = 440
* CHECK dout0_13 vdout0_13ck87 = 0 time = 440
* CHECK dout0_14 vdout0_14ck87 = 0.95 time = 440
* CHECK dout0_15 vdout0_15ck87 = 0 time = 440
* CHECK dout0_16 vdout0_16ck87 = 0 time = 440
* CHECK dout0_17 vdout0_17ck87 = 0 time = 440
* CHECK dout0_18 vdout0_18ck87 = 0 time = 440
* CHECK dout0_19 vdout0_19ck87 = 0.95 time = 440
* CHECK dout0_20 vdout0_20ck87 = 0.95 time = 440
* CHECK dout0_21 vdout0_21ck87 = 0.95 time = 440
* CHECK dout0_22 vdout0_22ck87 = 0.95 time = 440
* CHECK dout0_23 vdout0_23ck87 = 0.95 time = 440
* CHECK dout0_24 vdout0_24ck87 = 0 time = 440
* CHECK dout0_25 vdout0_25ck87 = 0.95 time = 440
* CHECK dout0_26 vdout0_26ck87 = 0 time = 440
* CHECK dout0_27 vdout0_27ck87 = 0.95 time = 440
* CHECK dout0_28 vdout0_28ck87 = 0.95 time = 440
* CHECK dout0_29 vdout0_29ck87 = 0.95 time = 440
* CHECK dout0_30 vdout0_30ck87 = 0 time = 440
* CHECK dout0_31 vdout0_31ck87 = 0.95 time = 440
* CHECK dout0_0 vdout0_0ck90 = 0 time = 455
* CHECK dout0_1 vdout0_1ck90 = 0 time = 455
* CHECK dout0_2 vdout0_2ck90 = 0 time = 455
* CHECK dout0_3 vdout0_3ck90 = 0 time = 455
* CHECK dout0_4 vdout0_4ck90 = 0 time = 455
* CHECK dout0_5 vdout0_5ck90 = 0.95 time = 455
* CHECK dout0_6 vdout0_6ck90 = 0.95 time = 455
* CHECK dout0_7 vdout0_7ck90 = 0 time = 455
* CHECK dout0_8 vdout0_8ck90 = 0 time = 455
* CHECK dout0_9 vdout0_9ck90 = 0.95 time = 455
* CHECK dout0_10 vdout0_10ck90 = 0.95 time = 455
* CHECK dout0_11 vdout0_11ck90 = 0.95 time = 455
* CHECK dout0_12 vdout0_12ck90 = 0 time = 455
* CHECK dout0_13 vdout0_13ck90 = 0 time = 455
* CHECK dout0_14 vdout0_14ck90 = 0 time = 455
* CHECK dout0_15 vdout0_15ck90 = 0.95 time = 455
* CHECK dout0_16 vdout0_16ck90 = 0 time = 455
* CHECK dout0_17 vdout0_17ck90 = 0.95 time = 455
* CHECK dout0_18 vdout0_18ck90 = 0 time = 455
* CHECK dout0_19 vdout0_19ck90 = 0.95 time = 455
* CHECK dout0_20 vdout0_20ck90 = 0.95 time = 455
* CHECK dout0_21 vdout0_21ck90 = 0 time = 455
* CHECK dout0_22 vdout0_22ck90 = 0 time = 455
* CHECK dout0_23 vdout0_23ck90 = 0 time = 455
* CHECK dout0_24 vdout0_24ck90 = 0 time = 455
* CHECK dout0_25 vdout0_25ck90 = 0.95 time = 455
* CHECK dout0_26 vdout0_26ck90 = 0.95 time = 455
* CHECK dout0_27 vdout0_27ck90 = 0 time = 455
* CHECK dout0_28 vdout0_28ck90 = 0.95 time = 455
* CHECK dout0_29 vdout0_29ck90 = 0.95 time = 455
* CHECK dout0_30 vdout0_30ck90 = 0.95 time = 455
* CHECK dout0_31 vdout0_31ck90 = 0.95 time = 455
* CHECK dout0_0 vdout0_0ck92 = 0 time = 465
* CHECK dout0_1 vdout0_1ck92 = 0.95 time = 465
* CHECK dout0_2 vdout0_2ck92 = 0.95 time = 465
* CHECK dout0_3 vdout0_3ck92 = 0.95 time = 465
* CHECK dout0_4 vdout0_4ck92 = 0 time = 465
* CHECK dout0_5 vdout0_5ck92 = 0.95 time = 465
* CHECK dout0_6 vdout0_6ck92 = 0.95 time = 465
* CHECK dout0_7 vdout0_7ck92 = 0 time = 465
* CHECK dout0_8 vdout0_8ck92 = 0.95 time = 465
* CHECK dout0_9 vdout0_9ck92 = 0 time = 465
* CHECK dout0_10 vdout0_10ck92 = 0.95 time = 465
* CHECK dout0_11 vdout0_11ck92 = 0.95 time = 465
* CHECK dout0_12 vdout0_12ck92 = 0.95 time = 465
* CHECK dout0_13 vdout0_13ck92 = 0.95 time = 465
* CHECK dout0_14 vdout0_14ck92 = 0 time = 465
* CHECK dout0_15 vdout0_15ck92 = 0 time = 465
* CHECK dout0_16 vdout0_16ck92 = 0.95 time = 465
* CHECK dout0_17 vdout0_17ck92 = 0.95 time = 465
* CHECK dout0_18 vdout0_18ck92 = 0 time = 465
* CHECK dout0_19 vdout0_19ck92 = 0 time = 465
* CHECK dout0_20 vdout0_20ck92 = 0 time = 465
* CHECK dout0_21 vdout0_21ck92 = 0 time = 465
* CHECK dout0_22 vdout0_22ck92 = 0 time = 465
* CHECK dout0_23 vdout0_23ck92 = 0 time = 465
* CHECK dout0_24 vdout0_24ck92 = 0 time = 465
* CHECK dout0_25 vdout0_25ck92 = 0.95 time = 465
* CHECK dout0_26 vdout0_26ck92 = 0.95 time = 465
* CHECK dout0_27 vdout0_27ck92 = 0.95 time = 465
* CHECK dout0_28 vdout0_28ck92 = 0 time = 465
* CHECK dout0_29 vdout0_29ck92 = 0.95 time = 465
* CHECK dout0_30 vdout0_30ck92 = 0 time = 465
* CHECK dout0_31 vdout0_31ck92 = 0.95 time = 465
* CHECK dout0_0 vdout0_0ck93 = 0.95 time = 470
* CHECK dout0_1 vdout0_1ck93 = 0.95 time = 470
* CHECK dout0_2 vdout0_2ck93 = 0 time = 470
* CHECK dout0_3 vdout0_3ck93 = 0.95 time = 470
* CHECK dout0_4 vdout0_4ck93 = 0.95 time = 470
* CHECK dout0_5 vdout0_5ck93 = 0.95 time = 470
* CHECK dout0_6 vdout0_6ck93 = 0 time = 470
* CHECK dout0_7 vdout0_7ck93 = 0 time = 470
* CHECK dout0_8 vdout0_8ck93 = 0.95 time = 470
* CHECK dout0_9 vdout0_9ck93 = 0 time = 470
* CHECK dout0_10 vdout0_10ck93 = 0.95 time = 470
* CHECK dout0_11 vdout0_11ck93 = 0.95 time = 470
* CHECK dout0_12 vdout0_12ck93 = 0 time = 470
* CHECK dout0_13 vdout0_13ck93 = 0 time = 470
* CHECK dout0_14 vdout0_14ck93 = 0.95 time = 470
* CHECK dout0_15 vdout0_15ck93 = 0 time = 470
* CHECK dout0_16 vdout0_16ck93 = 0 time = 470
* CHECK dout0_17 vdout0_17ck93 = 0 time = 470
* CHECK dout0_18 vdout0_18ck93 = 0 time = 470
* CHECK dout0_19 vdout0_19ck93 = 0.95 time = 470
* CHECK dout0_20 vdout0_20ck93 = 0.95 time = 470
* CHECK dout0_21 vdout0_21ck93 = 0.95 time = 470
* CHECK dout0_22 vdout0_22ck93 = 0.95 time = 470
* CHECK dout0_23 vdout0_23ck93 = 0.95 time = 470
* CHECK dout0_24 vdout0_24ck93 = 0 time = 470
* CHECK dout0_25 vdout0_25ck93 = 0.95 time = 470
* CHECK dout0_26 vdout0_26ck93 = 0 time = 470
* CHECK dout0_27 vdout0_27ck93 = 0.95 time = 470
* CHECK dout0_28 vdout0_28ck93 = 0.95 time = 470
* CHECK dout0_29 vdout0_29ck93 = 0.95 time = 470
* CHECK dout0_30 vdout0_30ck93 = 0 time = 470
* CHECK dout0_31 vdout0_31ck93 = 0.95 time = 470
* CHECK dout0_0 vdout0_0ck94 = 0 time = 475
* CHECK dout0_1 vdout0_1ck94 = 0 time = 475
* CHECK dout0_2 vdout0_2ck94 = 0 time = 475
* CHECK dout0_3 vdout0_3ck94 = 0 time = 475
* CHECK dout0_4 vdout0_4ck94 = 0 time = 475
* CHECK dout0_5 vdout0_5ck94 = 0.95 time = 475
* CHECK dout0_6 vdout0_6ck94 = 0.95 time = 475
* CHECK dout0_7 vdout0_7ck94 = 0 time = 475
* CHECK dout0_8 vdout0_8ck94 = 0 time = 475
* CHECK dout0_9 vdout0_9ck94 = 0.95 time = 475
* CHECK dout0_10 vdout0_10ck94 = 0.95 time = 475
* CHECK dout0_11 vdout0_11ck94 = 0.95 time = 475
* CHECK dout0_12 vdout0_12ck94 = 0 time = 475
* CHECK dout0_13 vdout0_13ck94 = 0 time = 475
* CHECK dout0_14 vdout0_14ck94 = 0 time = 475
* CHECK dout0_15 vdout0_15ck94 = 0.95 time = 475
* CHECK dout0_16 vdout0_16ck94 = 0 time = 475
* CHECK dout0_17 vdout0_17ck94 = 0.95 time = 475
* CHECK dout0_18 vdout0_18ck94 = 0 time = 475
* CHECK dout0_19 vdout0_19ck94 = 0.95 time = 475
* CHECK dout0_20 vdout0_20ck94 = 0.95 time = 475
* CHECK dout0_21 vdout0_21ck94 = 0 time = 475
* CHECK dout0_22 vdout0_22ck94 = 0 time = 475
* CHECK dout0_23 vdout0_23ck94 = 0 time = 475
* CHECK dout0_24 vdout0_24ck94 = 0 time = 475
* CHECK dout0_25 vdout0_25ck94 = 0.95 time = 475
* CHECK dout0_26 vdout0_26ck94 = 0.95 time = 475
* CHECK dout0_27 vdout0_27ck94 = 0 time = 475
* CHECK dout0_28 vdout0_28ck94 = 0.95 time = 475
* CHECK dout0_29 vdout0_29ck94 = 0.95 time = 475
* CHECK dout0_30 vdout0_30ck94 = 0.95 time = 475
* CHECK dout0_31 vdout0_31ck94 = 0.95 time = 475
* CHECK dout0_0 vdout0_0ck95 = 0 time = 480
* CHECK dout0_1 vdout0_1ck95 = 0 time = 480
* CHECK dout0_2 vdout0_2ck95 = 0 time = 480
* CHECK dout0_3 vdout0_3ck95 = 0.95 time = 480
* CHECK dout0_4 vdout0_4ck95 = 0.95 time = 480
* CHECK dout0_5 vdout0_5ck95 = 0.95 time = 480
* CHECK dout0_6 vdout0_6ck95 = 0.95 time = 480
* CHECK dout0_7 vdout0_7ck95 = 0 time = 480
* CHECK dout0_8 vdout0_8ck95 = 0 time = 480
* CHECK dout0_9 vdout0_9ck95 = 0.95 time = 480
* CHECK dout0_10 vdout0_10ck95 = 0 time = 480
* CHECK dout0_11 vdout0_11ck95 = 0 time = 480
* CHECK dout0_12 vdout0_12ck95 = 0.95 time = 480
* CHECK dout0_13 vdout0_13ck95 = 0 time = 480
* CHECK dout0_14 vdout0_14ck95 = 0 time = 480
* CHECK dout0_15 vdout0_15ck95 = 0 time = 480
* CHECK dout0_16 vdout0_16ck95 = 0.95 time = 480
* CHECK dout0_17 vdout0_17ck95 = 0 time = 480
* CHECK dout0_18 vdout0_18ck95 = 0 time = 480
* CHECK dout0_19 vdout0_19ck95 = 0.95 time = 480
* CHECK dout0_20 vdout0_20ck95 = 0 time = 480
* CHECK dout0_21 vdout0_21ck95 = 0.95 time = 480
* CHECK dout0_22 vdout0_22ck95 = 0 time = 480
* CHECK dout0_23 vdout0_23ck95 = 0 time = 480
* CHECK dout0_24 vdout0_24ck95 = 0.95 time = 480
* CHECK dout0_25 vdout0_25ck95 = 0.95 time = 480
* CHECK dout0_26 vdout0_26ck95 = 0 time = 480
* CHECK dout0_27 vdout0_27ck95 = 0.95 time = 480
* CHECK dout0_28 vdout0_28ck95 = 0 time = 480
* CHECK dout0_29 vdout0_29ck95 = 0.95 time = 480
* CHECK dout0_30 vdout0_30ck95 = 0.95 time = 480
* CHECK dout0_31 vdout0_31ck95 = 0 time = 480
* CHECK dout0_0 vdout0_0ck96 = 0.95 time = 485
* CHECK dout0_1 vdout0_1ck96 = 0 time = 485
* CHECK dout0_2 vdout0_2ck96 = 0.95 time = 485
* CHECK dout0_3 vdout0_3ck96 = 0 time = 485
* CHECK dout0_4 vdout0_4ck96 = 0.95 time = 485
* CHECK dout0_5 vdout0_5ck96 = 0.95 time = 485
* CHECK dout0_6 vdout0_6ck96 = 0.95 time = 485
* CHECK dout0_7 vdout0_7ck96 = 0 time = 485
* CHECK dout0_8 vdout0_8ck96 = 0 time = 485
* CHECK dout0_9 vdout0_9ck96 = 0 time = 485
* CHECK dout0_10 vdout0_10ck96 = 0.95 time = 485
* CHECK dout0_11 vdout0_11ck96 = 0 time = 485
* CHECK dout0_12 vdout0_12ck96 = 0 time = 485
* CHECK dout0_13 vdout0_13ck96 = 0.95 time = 485
* CHECK dout0_14 vdout0_14ck96 = 0.95 time = 485
* CHECK dout0_15 vdout0_15ck96 = 0.95 time = 485
* CHECK dout0_16 vdout0_16ck96 = 0 time = 485
* CHECK dout0_17 vdout0_17ck96 = 0 time = 485
* CHECK dout0_18 vdout0_18ck96 = 0.95 time = 485
* CHECK dout0_19 vdout0_19ck96 = 0.95 time = 485
* CHECK dout0_20 vdout0_20ck96 = 0 time = 485
* CHECK dout0_21 vdout0_21ck96 = 0 time = 485
* CHECK dout0_22 vdout0_22ck96 = 0 time = 485
* CHECK dout0_23 vdout0_23ck96 = 0 time = 485
* CHECK dout0_24 vdout0_24ck96 = 0.95 time = 485
* CHECK dout0_25 vdout0_25ck96 = 0 time = 485
* CHECK dout0_26 vdout0_26ck96 = 0 time = 485
* CHECK dout0_27 vdout0_27ck96 = 0.95 time = 485
* CHECK dout0_28 vdout0_28ck96 = 0.95 time = 485
* CHECK dout0_29 vdout0_29ck96 = 0.95 time = 485
* CHECK dout0_30 vdout0_30ck96 = 0 time = 485
* CHECK dout0_31 vdout0_31ck96 = 0.95 time = 485
* CHECK dout0_0 vdout0_0ck97 = 0 time = 490
* CHECK dout0_1 vdout0_1ck97 = 0.95 time = 490
* CHECK dout0_2 vdout0_2ck97 = 0.95 time = 490
* CHECK dout0_3 vdout0_3ck97 = 0.95 time = 490
* CHECK dout0_4 vdout0_4ck97 = 0 time = 490
* CHECK dout0_5 vdout0_5ck97 = 0.95 time = 490
* CHECK dout0_6 vdout0_6ck97 = 0.95 time = 490
* CHECK dout0_7 vdout0_7ck97 = 0 time = 490
* CHECK dout0_8 vdout0_8ck97 = 0.95 time = 490
* CHECK dout0_9 vdout0_9ck97 = 0 time = 490
* CHECK dout0_10 vdout0_10ck97 = 0.95 time = 490
* CHECK dout0_11 vdout0_11ck97 = 0.95 time = 490
* CHECK dout0_12 vdout0_12ck97 = 0.95 time = 490
* CHECK dout0_13 vdout0_13ck97 = 0.95 time = 490
* CHECK dout0_14 vdout0_14ck97 = 0 time = 490
* CHECK dout0_15 vdout0_15ck97 = 0 time = 490
* CHECK dout0_16 vdout0_16ck97 = 0.95 time = 490
* CHECK dout0_17 vdout0_17ck97 = 0.95 time = 490
* CHECK dout0_18 vdout0_18ck97 = 0 time = 490
* CHECK dout0_19 vdout0_19ck97 = 0 time = 490
* CHECK dout0_20 vdout0_20ck97 = 0 time = 490
* CHECK dout0_21 vdout0_21ck97 = 0 time = 490
* CHECK dout0_22 vdout0_22ck97 = 0 time = 490
* CHECK dout0_23 vdout0_23ck97 = 0 time = 490
* CHECK dout0_24 vdout0_24ck97 = 0 time = 490
* CHECK dout0_25 vdout0_25ck97 = 0.95 time = 490
* CHECK dout0_26 vdout0_26ck97 = 0.95 time = 490
* CHECK dout0_27 vdout0_27ck97 = 0.95 time = 490
* CHECK dout0_28 vdout0_28ck97 = 0 time = 490
* CHECK dout0_29 vdout0_29ck97 = 0.95 time = 490
* CHECK dout0_30 vdout0_30ck97 = 0 time = 490
* CHECK dout0_31 vdout0_31ck97 = 0.95 time = 490
* CHECK dout0_0 vdout0_0ck98 = 0.95 time = 495
* CHECK dout0_1 vdout0_1ck98 = 0 time = 495
* CHECK dout0_2 vdout0_2ck98 = 0.95 time = 495
* CHECK dout0_3 vdout0_3ck98 = 0 time = 495
* CHECK dout0_4 vdout0_4ck98 = 0.95 time = 495
* CHECK dout0_5 vdout0_5ck98 = 0.95 time = 495
* CHECK dout0_6 vdout0_6ck98 = 0.95 time = 495
* CHECK dout0_7 vdout0_7ck98 = 0 time = 495
* CHECK dout0_8 vdout0_8ck98 = 0.95 time = 495
* CHECK dout0_9 vdout0_9ck98 = 0 time = 495
* CHECK dout0_10 vdout0_10ck98 = 0 time = 495
* CHECK dout0_11 vdout0_11ck98 = 0 time = 495
* CHECK dout0_12 vdout0_12ck98 = 0 time = 495
* CHECK dout0_13 vdout0_13ck98 = 0 time = 495
* CHECK dout0_14 vdout0_14ck98 = 0 time = 495
* CHECK dout0_15 vdout0_15ck98 = 0.95 time = 495
* CHECK dout0_16 vdout0_16ck98 = 0.95 time = 495
* CHECK dout0_17 vdout0_17ck98 = 0 time = 495
* CHECK dout0_18 vdout0_18ck98 = 0 time = 495
* CHECK dout0_19 vdout0_19ck98 = 0 time = 495
* CHECK dout0_20 vdout0_20ck98 = 0.95 time = 495
* CHECK dout0_21 vdout0_21ck98 = 0.95 time = 495
* CHECK dout0_22 vdout0_22ck98 = 0 time = 495
* CHECK dout0_23 vdout0_23ck98 = 0.95 time = 495
* CHECK dout0_24 vdout0_24ck98 = 0 time = 495
* CHECK dout0_25 vdout0_25ck98 = 0.95 time = 495
* CHECK dout0_26 vdout0_26ck98 = 0.95 time = 495
* CHECK dout0_27 vdout0_27ck98 = 0.95 time = 495
* CHECK dout0_28 vdout0_28ck98 = 0 time = 495
* CHECK dout0_29 vdout0_29ck98 = 0 time = 495
* CHECK dout0_30 vdout0_30ck98 = 0 time = 495
* CHECK dout0_31 vdout0_31ck98 = 0 time = 495
* CHECK dout0_0 vdout0_0ck99 = 0.95 time = 500
* CHECK dout0_1 vdout0_1ck99 = 0 time = 500
* CHECK dout0_2 vdout0_2ck99 = 0.95 time = 500
* CHECK dout0_3 vdout0_3ck99 = 0 time = 500
* CHECK dout0_4 vdout0_4ck99 = 0.95 time = 500
* CHECK dout0_5 vdout0_5ck99 = 0.95 time = 500
* CHECK dout0_6 vdout0_6ck99 = 0.95 time = 500
* CHECK dout0_7 vdout0_7ck99 = 0 time = 500
* CHECK dout0_8 vdout0_8ck99 = 0.95 time = 500
* CHECK dout0_9 vdout0_9ck99 = 0 time = 500
* CHECK dout0_10 vdout0_10ck99 = 0 time = 500
* CHECK dout0_11 vdout0_11ck99 = 0 time = 500
* CHECK dout0_12 vdout0_12ck99 = 0 time = 500
* CHECK dout0_13 vdout0_13ck99 = 0 time = 500
* CHECK dout0_14 vdout0_14ck99 = 0 time = 500
* CHECK dout0_15 vdout0_15ck99 = 0.95 time = 500
* CHECK dout0_16 vdout0_16ck99 = 0.95 time = 500
* CHECK dout0_17 vdout0_17ck99 = 0 time = 500
* CHECK dout0_18 vdout0_18ck99 = 0 time = 500
* CHECK dout0_19 vdout0_19ck99 = 0 time = 500
* CHECK dout0_20 vdout0_20ck99 = 0.95 time = 500
* CHECK dout0_21 vdout0_21ck99 = 0.95 time = 500
* CHECK dout0_22 vdout0_22ck99 = 0 time = 500
* CHECK dout0_23 vdout0_23ck99 = 0.95 time = 500
* CHECK dout0_24 vdout0_24ck99 = 0 time = 500
* CHECK dout0_25 vdout0_25ck99 = 0.95 time = 500
* CHECK dout0_26 vdout0_26ck99 = 0.95 time = 500
* CHECK dout0_27 vdout0_27ck99 = 0.95 time = 500
* CHECK dout0_28 vdout0_28ck99 = 0 time = 500
* CHECK dout0_29 vdout0_29ck99 = 0 time = 500
* CHECK dout0_30 vdout0_30ck99 = 0 time = 500
* CHECK dout0_31 vdout0_31ck99 = 0 time = 500
* CHECK dout0_0 vdout0_0ck101 = 0.95 time = 510
* CHECK dout0_1 vdout0_1ck101 = 0 time = 510
* CHECK dout0_2 vdout0_2ck101 = 0.95 time = 510
* CHECK dout0_3 vdout0_3ck101 = 0 time = 510
* CHECK dout0_4 vdout0_4ck101 = 0.95 time = 510
* CHECK dout0_5 vdout0_5ck101 = 0.95 time = 510
* CHECK dout0_6 vdout0_6ck101 = 0.95 time = 510
* CHECK dout0_7 vdout0_7ck101 = 0 time = 510
* CHECK dout0_8 vdout0_8ck101 = 0.95 time = 510
* CHECK dout0_9 vdout0_9ck101 = 0 time = 510
* CHECK dout0_10 vdout0_10ck101 = 0 time = 510
* CHECK dout0_11 vdout0_11ck101 = 0 time = 510
* CHECK dout0_12 vdout0_12ck101 = 0 time = 510
* CHECK dout0_13 vdout0_13ck101 = 0 time = 510
* CHECK dout0_14 vdout0_14ck101 = 0 time = 510
* CHECK dout0_15 vdout0_15ck101 = 0.95 time = 510
* CHECK dout0_16 vdout0_16ck101 = 0.95 time = 510
* CHECK dout0_17 vdout0_17ck101 = 0 time = 510
* CHECK dout0_18 vdout0_18ck101 = 0 time = 510
* CHECK dout0_19 vdout0_19ck101 = 0 time = 510
* CHECK dout0_20 vdout0_20ck101 = 0.95 time = 510
* CHECK dout0_21 vdout0_21ck101 = 0.95 time = 510
* CHECK dout0_22 vdout0_22ck101 = 0 time = 510
* CHECK dout0_23 vdout0_23ck101 = 0.95 time = 510
* CHECK dout0_24 vdout0_24ck101 = 0 time = 510
* CHECK dout0_25 vdout0_25ck101 = 0.95 time = 510
* CHECK dout0_26 vdout0_26ck101 = 0.95 time = 510
* CHECK dout0_27 vdout0_27ck101 = 0.95 time = 510
* CHECK dout0_28 vdout0_28ck101 = 0 time = 510
* CHECK dout0_29 vdout0_29ck101 = 0 time = 510
* CHECK dout0_30 vdout0_30ck101 = 0 time = 510
* CHECK dout0_31 vdout0_31ck101 = 0 time = 510
* CHECK dout0_0 vdout0_0ck104 = 0.95 time = 525
* CHECK dout0_1 vdout0_1ck104 = 0.95 time = 525
* CHECK dout0_2 vdout0_2ck104 = 0 time = 525
* CHECK dout0_3 vdout0_3ck104 = 0 time = 525
* CHECK dout0_4 vdout0_4ck104 = 0 time = 525
* CHECK dout0_5 vdout0_5ck104 = 0 time = 525
* CHECK dout0_6 vdout0_6ck104 = 0.95 time = 525
* CHECK dout0_7 vdout0_7ck104 = 0.95 time = 525
* CHECK dout0_8 vdout0_8ck104 = 0 time = 525
* CHECK dout0_9 vdout0_9ck104 = 0 time = 525
* CHECK dout0_10 vdout0_10ck104 = 0 time = 525
* CHECK dout0_11 vdout0_11ck104 = 0 time = 525
* CHECK dout0_12 vdout0_12ck104 = 0.95 time = 525
* CHECK dout0_13 vdout0_13ck104 = 0.95 time = 525
* CHECK dout0_14 vdout0_14ck104 = 0.95 time = 525
* CHECK dout0_15 vdout0_15ck104 = 0 time = 525
* CHECK dout0_16 vdout0_16ck104 = 0.95 time = 525
* CHECK dout0_17 vdout0_17ck104 = 0 time = 525
* CHECK dout0_18 vdout0_18ck104 = 0.95 time = 525
* CHECK dout0_19 vdout0_19ck104 = 0 time = 525
* CHECK dout0_20 vdout0_20ck104 = 0 time = 525
* CHECK dout0_21 vdout0_21ck104 = 0 time = 525
* CHECK dout0_22 vdout0_22ck104 = 0 time = 525
* CHECK dout0_23 vdout0_23ck104 = 0.95 time = 525
* CHECK dout0_24 vdout0_24ck104 = 0.95 time = 525
* CHECK dout0_25 vdout0_25ck104 = 0 time = 525
* CHECK dout0_26 vdout0_26ck104 = 0 time = 525
* CHECK dout0_27 vdout0_27ck104 = 0 time = 525
* CHECK dout0_28 vdout0_28ck104 = 0 time = 525
* CHECK dout0_29 vdout0_29ck104 = 0.95 time = 525
* CHECK dout0_30 vdout0_30ck104 = 0 time = 525
* CHECK dout0_31 vdout0_31ck104 = 0 time = 525
* CHECK dout0_0 vdout0_0ck107 = 0 time = 540
* CHECK dout0_1 vdout0_1ck107 = 0.95 time = 540
* CHECK dout0_2 vdout0_2ck107 = 0.95 time = 540
* CHECK dout0_3 vdout0_3ck107 = 0 time = 540
* CHECK dout0_4 vdout0_4ck107 = 0 time = 540
* CHECK dout0_5 vdout0_5ck107 = 0.95 time = 540
* CHECK dout0_6 vdout0_6ck107 = 0.95 time = 540
* CHECK dout0_7 vdout0_7ck107 = 0.95 time = 540
* CHECK dout0_8 vdout0_8ck107 = 0.95 time = 540
* CHECK dout0_9 vdout0_9ck107 = 0 time = 540
* CHECK dout0_10 vdout0_10ck107 = 0 time = 540
* CHECK dout0_11 vdout0_11ck107 = 0 time = 540
* CHECK dout0_12 vdout0_12ck107 = 0.95 time = 540
* CHECK dout0_13 vdout0_13ck107 = 0.95 time = 540
* CHECK dout0_14 vdout0_14ck107 = 0 time = 540
* CHECK dout0_15 vdout0_15ck107 = 0 time = 540
* CHECK dout0_16 vdout0_16ck107 = 0 time = 540
* CHECK dout0_17 vdout0_17ck107 = 0.95 time = 540
* CHECK dout0_18 vdout0_18ck107 = 0 time = 540
* CHECK dout0_19 vdout0_19ck107 = 0.95 time = 540
* CHECK dout0_20 vdout0_20ck107 = 0 time = 540
* CHECK dout0_21 vdout0_21ck107 = 0 time = 540
* CHECK dout0_22 vdout0_22ck107 = 0 time = 540
* CHECK dout0_23 vdout0_23ck107 = 0 time = 540
* CHECK dout0_24 vdout0_24ck107 = 0.95 time = 540
* CHECK dout0_25 vdout0_25ck107 = 0.95 time = 540
* CHECK dout0_26 vdout0_26ck107 = 0 time = 540
* CHECK dout0_27 vdout0_27ck107 = 0 time = 540
* CHECK dout0_28 vdout0_28ck107 = 0 time = 540
* CHECK dout0_29 vdout0_29ck107 = 0.95 time = 540
* CHECK dout0_30 vdout0_30ck107 = 0 time = 540
* CHECK dout0_31 vdout0_31ck107 = 0 time = 540
* CHECK dout0_0 vdout0_0ck109 = 0 time = 550
* CHECK dout0_1 vdout0_1ck109 = 0 time = 550
* CHECK dout0_2 vdout0_2ck109 = 0 time = 550
* CHECK dout0_3 vdout0_3ck109 = 0 time = 550
* CHECK dout0_4 vdout0_4ck109 = 0 time = 550
* CHECK dout0_5 vdout0_5ck109 = 0.95 time = 550
* CHECK dout0_6 vdout0_6ck109 = 0.95 time = 550
* CHECK dout0_7 vdout0_7ck109 = 0 time = 550
* CHECK dout0_8 vdout0_8ck109 = 0 time = 550
* CHECK dout0_9 vdout0_9ck109 = 0.95 time = 550
* CHECK dout0_10 vdout0_10ck109 = 0.95 time = 550
* CHECK dout0_11 vdout0_11ck109 = 0.95 time = 550
* CHECK dout0_12 vdout0_12ck109 = 0 time = 550
* CHECK dout0_13 vdout0_13ck109 = 0 time = 550
* CHECK dout0_14 vdout0_14ck109 = 0 time = 550
* CHECK dout0_15 vdout0_15ck109 = 0.95 time = 550
* CHECK dout0_16 vdout0_16ck109 = 0 time = 550
* CHECK dout0_17 vdout0_17ck109 = 0.95 time = 550
* CHECK dout0_18 vdout0_18ck109 = 0 time = 550
* CHECK dout0_19 vdout0_19ck109 = 0.95 time = 550
* CHECK dout0_20 vdout0_20ck109 = 0.95 time = 550
* CHECK dout0_21 vdout0_21ck109 = 0 time = 550
* CHECK dout0_22 vdout0_22ck109 = 0 time = 550
* CHECK dout0_23 vdout0_23ck109 = 0 time = 550
* CHECK dout0_24 vdout0_24ck109 = 0 time = 550
* CHECK dout0_25 vdout0_25ck109 = 0.95 time = 550
* CHECK dout0_26 vdout0_26ck109 = 0.95 time = 550
* CHECK dout0_27 vdout0_27ck109 = 0 time = 550
* CHECK dout0_28 vdout0_28ck109 = 0.95 time = 550
* CHECK dout0_29 vdout0_29ck109 = 0.95 time = 550
* CHECK dout0_30 vdout0_30ck109 = 0.95 time = 550
* CHECK dout0_31 vdout0_31ck109 = 0.95 time = 550
* CHECK dout0_0 vdout0_0ck112 = 0 time = 565
* CHECK dout0_1 vdout0_1ck112 = 0 time = 565
* CHECK dout0_2 vdout0_2ck112 = 0 time = 565
* CHECK dout0_3 vdout0_3ck112 = 0.95 time = 565
* CHECK dout0_4 vdout0_4ck112 = 0 time = 565
* CHECK dout0_5 vdout0_5ck112 = 0.95 time = 565
* CHECK dout0_6 vdout0_6ck112 = 0 time = 565
* CHECK dout0_7 vdout0_7ck112 = 0 time = 565
* CHECK dout0_8 vdout0_8ck112 = 0 time = 565
* CHECK dout0_9 vdout0_9ck112 = 0.95 time = 565
* CHECK dout0_10 vdout0_10ck112 = 0.95 time = 565
* CHECK dout0_11 vdout0_11ck112 = 0 time = 565
* CHECK dout0_12 vdout0_12ck112 = 0.95 time = 565
* CHECK dout0_13 vdout0_13ck112 = 0 time = 565
* CHECK dout0_14 vdout0_14ck112 = 0.95 time = 565
* CHECK dout0_15 vdout0_15ck112 = 0.95 time = 565
* CHECK dout0_16 vdout0_16ck112 = 0.95 time = 565
* CHECK dout0_17 vdout0_17ck112 = 0 time = 565
* CHECK dout0_18 vdout0_18ck112 = 0 time = 565
* CHECK dout0_19 vdout0_19ck112 = 0 time = 565
* CHECK dout0_20 vdout0_20ck112 = 0 time = 565
* CHECK dout0_21 vdout0_21ck112 = 0 time = 565
* CHECK dout0_22 vdout0_22ck112 = 0.95 time = 565
* CHECK dout0_23 vdout0_23ck112 = 0.95 time = 565
* CHECK dout0_24 vdout0_24ck112 = 0.95 time = 565
* CHECK dout0_25 vdout0_25ck112 = 0 time = 565
* CHECK dout0_26 vdout0_26ck112 = 0 time = 565
* CHECK dout0_27 vdout0_27ck112 = 0.95 time = 565
* CHECK dout0_28 vdout0_28ck112 = 0 time = 565
* CHECK dout0_29 vdout0_29ck112 = 0.95 time = 565
* CHECK dout0_30 vdout0_30ck112 = 0 time = 565
* CHECK dout0_31 vdout0_31ck112 = 0.95 time = 565
* CHECK dout0_0 vdout0_0ck113 = 0 time = 570
* CHECK dout0_1 vdout0_1ck113 = 0.95 time = 570
* CHECK dout0_2 vdout0_2ck113 = 0 time = 570
* CHECK dout0_3 vdout0_3ck113 = 0 time = 570
* CHECK dout0_4 vdout0_4ck113 = 0.95 time = 570
* CHECK dout0_5 vdout0_5ck113 = 0.95 time = 570
* CHECK dout0_6 vdout0_6ck113 = 0.95 time = 570
* CHECK dout0_7 vdout0_7ck113 = 0 time = 570
* CHECK dout0_8 vdout0_8ck113 = 0.95 time = 570
* CHECK dout0_9 vdout0_9ck113 = 0 time = 570
* CHECK dout0_10 vdout0_10ck113 = 0.95 time = 570
* CHECK dout0_11 vdout0_11ck113 = 0 time = 570
* CHECK dout0_12 vdout0_12ck113 = 0 time = 570
* CHECK dout0_13 vdout0_13ck113 = 0 time = 570
* CHECK dout0_14 vdout0_14ck113 = 0 time = 570
* CHECK dout0_15 vdout0_15ck113 = 0.95 time = 570
* CHECK dout0_16 vdout0_16ck113 = 0 time = 570
* CHECK dout0_17 vdout0_17ck113 = 0.95 time = 570
* CHECK dout0_18 vdout0_18ck113 = 0.95 time = 570
* CHECK dout0_19 vdout0_19ck113 = 0 time = 570
* CHECK dout0_20 vdout0_20ck113 = 0.95 time = 570
* CHECK dout0_21 vdout0_21ck113 = 0.95 time = 570
* CHECK dout0_22 vdout0_22ck113 = 0.95 time = 570
* CHECK dout0_23 vdout0_23ck113 = 0 time = 570
* CHECK dout0_24 vdout0_24ck113 = 0.95 time = 570
* CHECK dout0_25 vdout0_25ck113 = 0 time = 570
* CHECK dout0_26 vdout0_26ck113 = 0 time = 570
* CHECK dout0_27 vdout0_27ck113 = 0.95 time = 570
* CHECK dout0_28 vdout0_28ck113 = 0.95 time = 570
* CHECK dout0_29 vdout0_29ck113 = 0.95 time = 570
* CHECK dout0_30 vdout0_30ck113 = 0 time = 570
* CHECK dout0_31 vdout0_31ck113 = 0 time = 570
* CHECK dout0_0 vdout0_0ck116 = 0.95 time = 585
* CHECK dout0_1 vdout0_1ck116 = 0 time = 585
* CHECK dout0_2 vdout0_2ck116 = 0.95 time = 585
* CHECK dout0_3 vdout0_3ck116 = 0 time = 585
* CHECK dout0_4 vdout0_4ck116 = 0.95 time = 585
* CHECK dout0_5 vdout0_5ck116 = 0.95 time = 585
* CHECK dout0_6 vdout0_6ck116 = 0.95 time = 585
* CHECK dout0_7 vdout0_7ck116 = 0.95 time = 585
* CHECK dout0_8 vdout0_8ck116 = 0.95 time = 585
* CHECK dout0_9 vdout0_9ck116 = 0 time = 585
* CHECK dout0_10 vdout0_10ck116 = 0 time = 585
* CHECK dout0_11 vdout0_11ck116 = 0 time = 585
* CHECK dout0_12 vdout0_12ck116 = 0.95 time = 585
* CHECK dout0_13 vdout0_13ck116 = 0 time = 585
* CHECK dout0_14 vdout0_14ck116 = 0 time = 585
* CHECK dout0_15 vdout0_15ck116 = 0.95 time = 585
* CHECK dout0_16 vdout0_16ck116 = 0.95 time = 585
* CHECK dout0_17 vdout0_17ck116 = 0 time = 585
* CHECK dout0_18 vdout0_18ck116 = 0 time = 585
* CHECK dout0_19 vdout0_19ck116 = 0.95 time = 585
* CHECK dout0_20 vdout0_20ck116 = 0.95 time = 585
* CHECK dout0_21 vdout0_21ck116 = 0.95 time = 585
* CHECK dout0_22 vdout0_22ck116 = 0.95 time = 585
* CHECK dout0_23 vdout0_23ck116 = 0.95 time = 585
* CHECK dout0_24 vdout0_24ck116 = 0.95 time = 585
* CHECK dout0_25 vdout0_25ck116 = 0 time = 585
* CHECK dout0_26 vdout0_26ck116 = 0.95 time = 585
* CHECK dout0_27 vdout0_27ck116 = 0.95 time = 585
* CHECK dout0_28 vdout0_28ck116 = 0.95 time = 585
* CHECK dout0_29 vdout0_29ck116 = 0 time = 585
* CHECK dout0_30 vdout0_30ck116 = 0 time = 585
* CHECK dout0_31 vdout0_31ck116 = 0 time = 585
* CHECK dout0_0 vdout0_0ck117 = 0 time = 590
* CHECK dout0_1 vdout0_1ck117 = 0 time = 590
* CHECK dout0_2 vdout0_2ck117 = 0 time = 590
* CHECK dout0_3 vdout0_3ck117 = 0.95 time = 590
* CHECK dout0_4 vdout0_4ck117 = 0 time = 590
* CHECK dout0_5 vdout0_5ck117 = 0.95 time = 590
* CHECK dout0_6 vdout0_6ck117 = 0 time = 590
* CHECK dout0_7 vdout0_7ck117 = 0 time = 590
* CHECK dout0_8 vdout0_8ck117 = 0 time = 590
* CHECK dout0_9 vdout0_9ck117 = 0.95 time = 590
* CHECK dout0_10 vdout0_10ck117 = 0.95 time = 590
* CHECK dout0_11 vdout0_11ck117 = 0 time = 590
* CHECK dout0_12 vdout0_12ck117 = 0.95 time = 590
* CHECK dout0_13 vdout0_13ck117 = 0 time = 590
* CHECK dout0_14 vdout0_14ck117 = 0.95 time = 590
* CHECK dout0_15 vdout0_15ck117 = 0.95 time = 590
* CHECK dout0_16 vdout0_16ck117 = 0.95 time = 590
* CHECK dout0_17 vdout0_17ck117 = 0 time = 590
* CHECK dout0_18 vdout0_18ck117 = 0 time = 590
* CHECK dout0_19 vdout0_19ck117 = 0 time = 590
* CHECK dout0_20 vdout0_20ck117 = 0 time = 590
* CHECK dout0_21 vdout0_21ck117 = 0 time = 590
* CHECK dout0_22 vdout0_22ck117 = 0.95 time = 590
* CHECK dout0_23 vdout0_23ck117 = 0.95 time = 590
* CHECK dout0_24 vdout0_24ck117 = 0.95 time = 590
* CHECK dout0_25 vdout0_25ck117 = 0 time = 590
* CHECK dout0_26 vdout0_26ck117 = 0 time = 590
* CHECK dout0_27 vdout0_27ck117 = 0.95 time = 590
* CHECK dout0_28 vdout0_28ck117 = 0 time = 590
* CHECK dout0_29 vdout0_29ck117 = 0.95 time = 590
* CHECK dout0_30 vdout0_30ck117 = 0 time = 590
* CHECK dout0_31 vdout0_31ck117 = 0.95 time = 590
* CHECK dout0_0 vdout0_0ck119 = 0 time = 600
* CHECK dout0_1 vdout0_1ck119 = 0 time = 600
* CHECK dout0_2 vdout0_2ck119 = 0 time = 600
* CHECK dout0_3 vdout0_3ck119 = 0.95 time = 600
* CHECK dout0_4 vdout0_4ck119 = 0.95 time = 600
* CHECK dout0_5 vdout0_5ck119 = 0.95 time = 600
* CHECK dout0_6 vdout0_6ck119 = 0.95 time = 600
* CHECK dout0_7 vdout0_7ck119 = 0 time = 600
* CHECK dout0_8 vdout0_8ck119 = 0 time = 600
* CHECK dout0_9 vdout0_9ck119 = 0.95 time = 600
* CHECK dout0_10 vdout0_10ck119 = 0 time = 600
* CHECK dout0_11 vdout0_11ck119 = 0 time = 600
* CHECK dout0_12 vdout0_12ck119 = 0.95 time = 600
* CHECK dout0_13 vdout0_13ck119 = 0 time = 600
* CHECK dout0_14 vdout0_14ck119 = 0 time = 600
* CHECK dout0_15 vdout0_15ck119 = 0 time = 600
* CHECK dout0_16 vdout0_16ck119 = 0.95 time = 600
* CHECK dout0_17 vdout0_17ck119 = 0 time = 600
* CHECK dout0_18 vdout0_18ck119 = 0 time = 600
* CHECK dout0_19 vdout0_19ck119 = 0.95 time = 600
* CHECK dout0_20 vdout0_20ck119 = 0 time = 600
* CHECK dout0_21 vdout0_21ck119 = 0.95 time = 600
* CHECK dout0_22 vdout0_22ck119 = 0 time = 600
* CHECK dout0_23 vdout0_23ck119 = 0 time = 600
* CHECK dout0_24 vdout0_24ck119 = 0.95 time = 600
* CHECK dout0_25 vdout0_25ck119 = 0.95 time = 600
* CHECK dout0_26 vdout0_26ck119 = 0 time = 600
* CHECK dout0_27 vdout0_27ck119 = 0.95 time = 600
* CHECK dout0_28 vdout0_28ck119 = 0 time = 600
* CHECK dout0_29 vdout0_29ck119 = 0.95 time = 600
* CHECK dout0_30 vdout0_30ck119 = 0.95 time = 600
* CHECK dout0_31 vdout0_31ck119 = 0 time = 600
* CHECK dout0_0 vdout0_0ck121 = 0 time = 610
* CHECK dout0_1 vdout0_1ck121 = 0.95 time = 610
* CHECK dout0_2 vdout0_2ck121 = 0.95 time = 610
* CHECK dout0_3 vdout0_3ck121 = 0.95 time = 610
* CHECK dout0_4 vdout0_4ck121 = 0 time = 610
* CHECK dout0_5 vdout0_5ck121 = 0.95 time = 610
* CHECK dout0_6 vdout0_6ck121 = 0.95 time = 610
* CHECK dout0_7 vdout0_7ck121 = 0 time = 610
* CHECK dout0_8 vdout0_8ck121 = 0.95 time = 610
* CHECK dout0_9 vdout0_9ck121 = 0 time = 610
* CHECK dout0_10 vdout0_10ck121 = 0.95 time = 610
* CHECK dout0_11 vdout0_11ck121 = 0.95 time = 610
* CHECK dout0_12 vdout0_12ck121 = 0.95 time = 610
* CHECK dout0_13 vdout0_13ck121 = 0.95 time = 610
* CHECK dout0_14 vdout0_14ck121 = 0 time = 610
* CHECK dout0_15 vdout0_15ck121 = 0 time = 610
* CHECK dout0_16 vdout0_16ck121 = 0.95 time = 610
* CHECK dout0_17 vdout0_17ck121 = 0.95 time = 610
* CHECK dout0_18 vdout0_18ck121 = 0 time = 610
* CHECK dout0_19 vdout0_19ck121 = 0 time = 610
* CHECK dout0_20 vdout0_20ck121 = 0 time = 610
* CHECK dout0_21 vdout0_21ck121 = 0 time = 610
* CHECK dout0_22 vdout0_22ck121 = 0 time = 610
* CHECK dout0_23 vdout0_23ck121 = 0 time = 610
* CHECK dout0_24 vdout0_24ck121 = 0 time = 610
* CHECK dout0_25 vdout0_25ck121 = 0.95 time = 610
* CHECK dout0_26 vdout0_26ck121 = 0.95 time = 610
* CHECK dout0_27 vdout0_27ck121 = 0.95 time = 610
* CHECK dout0_28 vdout0_28ck121 = 0 time = 610
* CHECK dout0_29 vdout0_29ck121 = 0.95 time = 610
* CHECK dout0_30 vdout0_30ck121 = 0 time = 610
* CHECK dout0_31 vdout0_31ck121 = 0.95 time = 610
* CHECK dout0_0 vdout0_0ck122 = 0.95 time = 615
* CHECK dout0_1 vdout0_1ck122 = 0 time = 615
* CHECK dout0_2 vdout0_2ck122 = 0.95 time = 615
* CHECK dout0_3 vdout0_3ck122 = 0 time = 615
* CHECK dout0_4 vdout0_4ck122 = 0.95 time = 615
* CHECK dout0_5 vdout0_5ck122 = 0.95 time = 615
* CHECK dout0_6 vdout0_6ck122 = 0.95 time = 615
* CHECK dout0_7 vdout0_7ck122 = 0 time = 615
* CHECK dout0_8 vdout0_8ck122 = 0.95 time = 615
* CHECK dout0_9 vdout0_9ck122 = 0 time = 615
* CHECK dout0_10 vdout0_10ck122 = 0 time = 615
* CHECK dout0_11 vdout0_11ck122 = 0 time = 615
* CHECK dout0_12 vdout0_12ck122 = 0 time = 615
* CHECK dout0_13 vdout0_13ck122 = 0 time = 615
* CHECK dout0_14 vdout0_14ck122 = 0 time = 615
* CHECK dout0_15 vdout0_15ck122 = 0.95 time = 615
* CHECK dout0_16 vdout0_16ck122 = 0.95 time = 615
* CHECK dout0_17 vdout0_17ck122 = 0 time = 615
* CHECK dout0_18 vdout0_18ck122 = 0 time = 615
* CHECK dout0_19 vdout0_19ck122 = 0 time = 615
* CHECK dout0_20 vdout0_20ck122 = 0.95 time = 615
* CHECK dout0_21 vdout0_21ck122 = 0.95 time = 615
* CHECK dout0_22 vdout0_22ck122 = 0 time = 615
* CHECK dout0_23 vdout0_23ck122 = 0.95 time = 615
* CHECK dout0_24 vdout0_24ck122 = 0 time = 615
* CHECK dout0_25 vdout0_25ck122 = 0.95 time = 615
* CHECK dout0_26 vdout0_26ck122 = 0.95 time = 615
* CHECK dout0_27 vdout0_27ck122 = 0.95 time = 615
* CHECK dout0_28 vdout0_28ck122 = 0 time = 615
* CHECK dout0_29 vdout0_29ck122 = 0 time = 615
* CHECK dout0_30 vdout0_30ck122 = 0 time = 615
* CHECK dout0_31 vdout0_31ck122 = 0 time = 615
* CHECK dout0_0 vdout0_0ck125 = 0 time = 630
* CHECK dout0_1 vdout0_1ck125 = 0.95 time = 630
* CHECK dout0_2 vdout0_2ck125 = 0 time = 630
* CHECK dout0_3 vdout0_3ck125 = 0 time = 630
* CHECK dout0_4 vdout0_4ck125 = 0.95 time = 630
* CHECK dout0_5 vdout0_5ck125 = 0.95 time = 630
* CHECK dout0_6 vdout0_6ck125 = 0.95 time = 630
* CHECK dout0_7 vdout0_7ck125 = 0 time = 630
* CHECK dout0_8 vdout0_8ck125 = 0.95 time = 630
* CHECK dout0_9 vdout0_9ck125 = 0 time = 630
* CHECK dout0_10 vdout0_10ck125 = 0.95 time = 630
* CHECK dout0_11 vdout0_11ck125 = 0 time = 630
* CHECK dout0_12 vdout0_12ck125 = 0 time = 630
* CHECK dout0_13 vdout0_13ck125 = 0 time = 630
* CHECK dout0_14 vdout0_14ck125 = 0 time = 630
* CHECK dout0_15 vdout0_15ck125 = 0.95 time = 630
* CHECK dout0_16 vdout0_16ck125 = 0 time = 630
* CHECK dout0_17 vdout0_17ck125 = 0.95 time = 630
* CHECK dout0_18 vdout0_18ck125 = 0.95 time = 630
* CHECK dout0_19 vdout0_19ck125 = 0 time = 630
* CHECK dout0_20 vdout0_20ck125 = 0.95 time = 630
* CHECK dout0_21 vdout0_21ck125 = 0.95 time = 630
* CHECK dout0_22 vdout0_22ck125 = 0.95 time = 630
* CHECK dout0_23 vdout0_23ck125 = 0 time = 630
* CHECK dout0_24 vdout0_24ck125 = 0.95 time = 630
* CHECK dout0_25 vdout0_25ck125 = 0 time = 630
* CHECK dout0_26 vdout0_26ck125 = 0 time = 630
* CHECK dout0_27 vdout0_27ck125 = 0.95 time = 630
* CHECK dout0_28 vdout0_28ck125 = 0.95 time = 630
* CHECK dout0_29 vdout0_29ck125 = 0.95 time = 630
* CHECK dout0_30 vdout0_30ck125 = 0 time = 630
* CHECK dout0_31 vdout0_31ck125 = 0 time = 630
* CHECK dout0_0 vdout0_0ck126 = 0 time = 635
* CHECK dout0_1 vdout0_1ck126 = 0.95 time = 635
* CHECK dout0_2 vdout0_2ck126 = 0 time = 635
* CHECK dout0_3 vdout0_3ck126 = 0 time = 635
* CHECK dout0_4 vdout0_4ck126 = 0 time = 635
* CHECK dout0_5 vdout0_5ck126 = 0 time = 635
* CHECK dout0_6 vdout0_6ck126 = 0.95 time = 635
* CHECK dout0_7 vdout0_7ck126 = 0.95 time = 635
* CHECK dout0_8 vdout0_8ck126 = 0.95 time = 635
* CHECK dout0_9 vdout0_9ck126 = 0.95 time = 635
* CHECK dout0_10 vdout0_10ck126 = 0.95 time = 635
* CHECK dout0_11 vdout0_11ck126 = 0 time = 635
* CHECK dout0_12 vdout0_12ck126 = 0 time = 635
* CHECK dout0_13 vdout0_13ck126 = 0.95 time = 635
* CHECK dout0_14 vdout0_14ck126 = 0.95 time = 635
* CHECK dout0_15 vdout0_15ck126 = 0 time = 635
* CHECK dout0_16 vdout0_16ck126 = 0 time = 635
* CHECK dout0_17 vdout0_17ck126 = 0.95 time = 635
* CHECK dout0_18 vdout0_18ck126 = 0.95 time = 635
* CHECK dout0_19 vdout0_19ck126 = 0 time = 635
* CHECK dout0_20 vdout0_20ck126 = 0.95 time = 635
* CHECK dout0_21 vdout0_21ck126 = 0.95 time = 635
* CHECK dout0_22 vdout0_22ck126 = 0 time = 635
* CHECK dout0_23 vdout0_23ck126 = 0 time = 635
* CHECK dout0_24 vdout0_24ck126 = 0 time = 635
* CHECK dout0_25 vdout0_25ck126 = 0 time = 635
* CHECK dout0_26 vdout0_26ck126 = 0 time = 635
* CHECK dout0_27 vdout0_27ck126 = 0.95 time = 635
* CHECK dout0_28 vdout0_28ck126 = 0 time = 635
* CHECK dout0_29 vdout0_29ck126 = 0.95 time = 635
* CHECK dout0_30 vdout0_30ck126 = 0 time = 635
* CHECK dout0_31 vdout0_31ck126 = 0 time = 635
* CHECK dout0_0 vdout0_0ck127 = 0 time = 640
* CHECK dout0_1 vdout0_1ck127 = 0.95 time = 640
* CHECK dout0_2 vdout0_2ck127 = 0 time = 640
* CHECK dout0_3 vdout0_3ck127 = 0 time = 640
* CHECK dout0_4 vdout0_4ck127 = 0 time = 640
* CHECK dout0_5 vdout0_5ck127 = 0 time = 640
* CHECK dout0_6 vdout0_6ck127 = 0.95 time = 640
* CHECK dout0_7 vdout0_7ck127 = 0.95 time = 640
* CHECK dout0_8 vdout0_8ck127 = 0.95 time = 640
* CHECK dout0_9 vdout0_9ck127 = 0.95 time = 640
* CHECK dout0_10 vdout0_10ck127 = 0.95 time = 640
* CHECK dout0_11 vdout0_11ck127 = 0 time = 640
* CHECK dout0_12 vdout0_12ck127 = 0 time = 640
* CHECK dout0_13 vdout0_13ck127 = 0.95 time = 640
* CHECK dout0_14 vdout0_14ck127 = 0.95 time = 640
* CHECK dout0_15 vdout0_15ck127 = 0 time = 640
* CHECK dout0_16 vdout0_16ck127 = 0 time = 640
* CHECK dout0_17 vdout0_17ck127 = 0.95 time = 640
* CHECK dout0_18 vdout0_18ck127 = 0.95 time = 640
* CHECK dout0_19 vdout0_19ck127 = 0 time = 640
* CHECK dout0_20 vdout0_20ck127 = 0.95 time = 640
* CHECK dout0_21 vdout0_21ck127 = 0.95 time = 640
* CHECK dout0_22 vdout0_22ck127 = 0 time = 640
* CHECK dout0_23 vdout0_23ck127 = 0 time = 640
* CHECK dout0_24 vdout0_24ck127 = 0 time = 640
* CHECK dout0_25 vdout0_25ck127 = 0 time = 640
* CHECK dout0_26 vdout0_26ck127 = 0 time = 640
* CHECK dout0_27 vdout0_27ck127 = 0.95 time = 640
* CHECK dout0_28 vdout0_28ck127 = 0 time = 640
* CHECK dout0_29 vdout0_29ck127 = 0.95 time = 640
* CHECK dout0_30 vdout0_30ck127 = 0 time = 640
* CHECK dout0_31 vdout0_31ck127 = 0 time = 640
* CHECK dout0_0 vdout0_0ck128 = 0 time = 645
* CHECK dout0_1 vdout0_1ck128 = 0.95 time = 645
* CHECK dout0_2 vdout0_2ck128 = 0 time = 645
* CHECK dout0_3 vdout0_3ck128 = 0 time = 645
* CHECK dout0_4 vdout0_4ck128 = 0.95 time = 645
* CHECK dout0_5 vdout0_5ck128 = 0.95 time = 645
* CHECK dout0_6 vdout0_6ck128 = 0.95 time = 645
* CHECK dout0_7 vdout0_7ck128 = 0 time = 645
* CHECK dout0_8 vdout0_8ck128 = 0.95 time = 645
* CHECK dout0_9 vdout0_9ck128 = 0 time = 645
* CHECK dout0_10 vdout0_10ck128 = 0.95 time = 645
* CHECK dout0_11 vdout0_11ck128 = 0 time = 645
* CHECK dout0_12 vdout0_12ck128 = 0 time = 645
* CHECK dout0_13 vdout0_13ck128 = 0 time = 645
* CHECK dout0_14 vdout0_14ck128 = 0 time = 645
* CHECK dout0_15 vdout0_15ck128 = 0.95 time = 645
* CHECK dout0_16 vdout0_16ck128 = 0 time = 645
* CHECK dout0_17 vdout0_17ck128 = 0.95 time = 645
* CHECK dout0_18 vdout0_18ck128 = 0.95 time = 645
* CHECK dout0_19 vdout0_19ck128 = 0 time = 645
* CHECK dout0_20 vdout0_20ck128 = 0.95 time = 645
* CHECK dout0_21 vdout0_21ck128 = 0.95 time = 645
* CHECK dout0_22 vdout0_22ck128 = 0.95 time = 645
* CHECK dout0_23 vdout0_23ck128 = 0 time = 645
* CHECK dout0_24 vdout0_24ck128 = 0.95 time = 645
* CHECK dout0_25 vdout0_25ck128 = 0 time = 645
* CHECK dout0_26 vdout0_26ck128 = 0 time = 645
* CHECK dout0_27 vdout0_27ck128 = 0.95 time = 645
* CHECK dout0_28 vdout0_28ck128 = 0.95 time = 645
* CHECK dout0_29 vdout0_29ck128 = 0.95 time = 645
* CHECK dout0_30 vdout0_30ck128 = 0 time = 645
* CHECK dout0_31 vdout0_31ck128 = 0 time = 645
* CHECK dout0_0 vdout0_0ck129 = 0.95 time = 650
* CHECK dout0_1 vdout0_1ck129 = 0 time = 650
* CHECK dout0_2 vdout0_2ck129 = 0.95 time = 650
* CHECK dout0_3 vdout0_3ck129 = 0 time = 650
* CHECK dout0_4 vdout0_4ck129 = 0.95 time = 650
* CHECK dout0_5 vdout0_5ck129 = 0.95 time = 650
* CHECK dout0_6 vdout0_6ck129 = 0.95 time = 650
* CHECK dout0_7 vdout0_7ck129 = 0 time = 650
* CHECK dout0_8 vdout0_8ck129 = 0.95 time = 650
* CHECK dout0_9 vdout0_9ck129 = 0 time = 650
* CHECK dout0_10 vdout0_10ck129 = 0 time = 650
* CHECK dout0_11 vdout0_11ck129 = 0 time = 650
* CHECK dout0_12 vdout0_12ck129 = 0 time = 650
* CHECK dout0_13 vdout0_13ck129 = 0 time = 650
* CHECK dout0_14 vdout0_14ck129 = 0 time = 650
* CHECK dout0_15 vdout0_15ck129 = 0.95 time = 650
* CHECK dout0_16 vdout0_16ck129 = 0.95 time = 650
* CHECK dout0_17 vdout0_17ck129 = 0 time = 650
* CHECK dout0_18 vdout0_18ck129 = 0 time = 650
* CHECK dout0_19 vdout0_19ck129 = 0 time = 650
* CHECK dout0_20 vdout0_20ck129 = 0.95 time = 650
* CHECK dout0_21 vdout0_21ck129 = 0.95 time = 650
* CHECK dout0_22 vdout0_22ck129 = 0 time = 650
* CHECK dout0_23 vdout0_23ck129 = 0.95 time = 650
* CHECK dout0_24 vdout0_24ck129 = 0 time = 650
* CHECK dout0_25 vdout0_25ck129 = 0.95 time = 650
* CHECK dout0_26 vdout0_26ck129 = 0.95 time = 650
* CHECK dout0_27 vdout0_27ck129 = 0.95 time = 650
* CHECK dout0_28 vdout0_28ck129 = 0 time = 650
* CHECK dout0_29 vdout0_29ck129 = 0 time = 650
* CHECK dout0_30 vdout0_30ck129 = 0 time = 650
* CHECK dout0_31 vdout0_31ck129 = 0 time = 650
* CHECK dout0_0 vdout0_0ck132 = 0.95 time = 665
* CHECK dout0_1 vdout0_1ck132 = 0 time = 665
* CHECK dout0_2 vdout0_2ck132 = 0.95 time = 665
* CHECK dout0_3 vdout0_3ck132 = 0 time = 665
* CHECK dout0_4 vdout0_4ck132 = 0 time = 665
* CHECK dout0_5 vdout0_5ck132 = 0.95 time = 665
* CHECK dout0_6 vdout0_6ck132 = 0 time = 665
* CHECK dout0_7 vdout0_7ck132 = 0 time = 665
* CHECK dout0_8 vdout0_8ck132 = 0.95 time = 665
* CHECK dout0_9 vdout0_9ck132 = 0.95 time = 665
* CHECK dout0_10 vdout0_10ck132 = 0.95 time = 665
* CHECK dout0_11 vdout0_11ck132 = 0 time = 665
* CHECK dout0_12 vdout0_12ck132 = 0.95 time = 665
* CHECK dout0_13 vdout0_13ck132 = 0 time = 665
* CHECK dout0_14 vdout0_14ck132 = 0 time = 665
* CHECK dout0_15 vdout0_15ck132 = 0.95 time = 665
* CHECK dout0_16 vdout0_16ck132 = 0.95 time = 665
* CHECK dout0_17 vdout0_17ck132 = 0.95 time = 665
* CHECK dout0_18 vdout0_18ck132 = 0 time = 665
* CHECK dout0_19 vdout0_19ck132 = 0 time = 665
* CHECK dout0_20 vdout0_20ck132 = 0 time = 665
* CHECK dout0_21 vdout0_21ck132 = 0.95 time = 665
* CHECK dout0_22 vdout0_22ck132 = 0 time = 665
* CHECK dout0_23 vdout0_23ck132 = 0 time = 665
* CHECK dout0_24 vdout0_24ck132 = 0 time = 665
* CHECK dout0_25 vdout0_25ck132 = 0.95 time = 665
* CHECK dout0_26 vdout0_26ck132 = 0 time = 665
* CHECK dout0_27 vdout0_27ck132 = 0.95 time = 665
* CHECK dout0_28 vdout0_28ck132 = 0.95 time = 665
* CHECK dout0_29 vdout0_29ck132 = 0 time = 665
* CHECK dout0_30 vdout0_30ck132 = 0.95 time = 665
* CHECK dout0_31 vdout0_31ck132 = 0.95 time = 665
* CHECK dout0_0 vdout0_0ck133 = 0 time = 670
* CHECK dout0_1 vdout0_1ck133 = 0 time = 670
* CHECK dout0_2 vdout0_2ck133 = 0 time = 670
* CHECK dout0_3 vdout0_3ck133 = 0.95 time = 670
* CHECK dout0_4 vdout0_4ck133 = 0.95 time = 670
* CHECK dout0_5 vdout0_5ck133 = 0.95 time = 670
* CHECK dout0_6 vdout0_6ck133 = 0 time = 670
* CHECK dout0_7 vdout0_7ck133 = 0 time = 670
* CHECK dout0_8 vdout0_8ck133 = 0 time = 670
* CHECK dout0_9 vdout0_9ck133 = 0.95 time = 670
* CHECK dout0_10 vdout0_10ck133 = 0 time = 670
* CHECK dout0_11 vdout0_11ck133 = 0.95 time = 670
* CHECK dout0_12 vdout0_12ck133 = 0.95 time = 670
* CHECK dout0_13 vdout0_13ck133 = 0.95 time = 670
* CHECK dout0_14 vdout0_14ck133 = 0.95 time = 670
* CHECK dout0_15 vdout0_15ck133 = 0 time = 670
* CHECK dout0_16 vdout0_16ck133 = 0 time = 670
* CHECK dout0_17 vdout0_17ck133 = 0 time = 670
* CHECK dout0_18 vdout0_18ck133 = 0.95 time = 670
* CHECK dout0_19 vdout0_19ck133 = 0 time = 670
* CHECK dout0_20 vdout0_20ck133 = 0 time = 670
* CHECK dout0_21 vdout0_21ck133 = 0.95 time = 670
* CHECK dout0_22 vdout0_22ck133 = 0.95 time = 670
* CHECK dout0_23 vdout0_23ck133 = 0.95 time = 670
* CHECK dout0_24 vdout0_24ck133 = 0.95 time = 670
* CHECK dout0_25 vdout0_25ck133 = 0.95 time = 670
* CHECK dout0_26 vdout0_26ck133 = 0.95 time = 670
* CHECK dout0_27 vdout0_27ck133 = 0 time = 670
* CHECK dout0_28 vdout0_28ck133 = 0.95 time = 670
* CHECK dout0_29 vdout0_29ck133 = 0.95 time = 670
* CHECK dout0_30 vdout0_30ck133 = 0 time = 670
* CHECK dout0_31 vdout0_31ck133 = 0.95 time = 670
* CHECK dout0_0 vdout0_0ck134 = 0 time = 675
* CHECK dout0_1 vdout0_1ck134 = 0 time = 675
* CHECK dout0_2 vdout0_2ck134 = 0 time = 675
* CHECK dout0_3 vdout0_3ck134 = 0.95 time = 675
* CHECK dout0_4 vdout0_4ck134 = 0.95 time = 675
* CHECK dout0_5 vdout0_5ck134 = 0.95 time = 675
* CHECK dout0_6 vdout0_6ck134 = 0.95 time = 675
* CHECK dout0_7 vdout0_7ck134 = 0 time = 675
* CHECK dout0_8 vdout0_8ck134 = 0 time = 675
* CHECK dout0_9 vdout0_9ck134 = 0.95 time = 675
* CHECK dout0_10 vdout0_10ck134 = 0 time = 675
* CHECK dout0_11 vdout0_11ck134 = 0 time = 675
* CHECK dout0_12 vdout0_12ck134 = 0.95 time = 675
* CHECK dout0_13 vdout0_13ck134 = 0 time = 675
* CHECK dout0_14 vdout0_14ck134 = 0 time = 675
* CHECK dout0_15 vdout0_15ck134 = 0 time = 675
* CHECK dout0_16 vdout0_16ck134 = 0.95 time = 675
* CHECK dout0_17 vdout0_17ck134 = 0 time = 675
* CHECK dout0_18 vdout0_18ck134 = 0 time = 675
* CHECK dout0_19 vdout0_19ck134 = 0.95 time = 675
* CHECK dout0_20 vdout0_20ck134 = 0 time = 675
* CHECK dout0_21 vdout0_21ck134 = 0.95 time = 675
* CHECK dout0_22 vdout0_22ck134 = 0 time = 675
* CHECK dout0_23 vdout0_23ck134 = 0 time = 675
* CHECK dout0_24 vdout0_24ck134 = 0.95 time = 675
* CHECK dout0_25 vdout0_25ck134 = 0.95 time = 675
* CHECK dout0_26 vdout0_26ck134 = 0 time = 675
* CHECK dout0_27 vdout0_27ck134 = 0.95 time = 675
* CHECK dout0_28 vdout0_28ck134 = 0 time = 675
* CHECK dout0_29 vdout0_29ck134 = 0.95 time = 675
* CHECK dout0_30 vdout0_30ck134 = 0.95 time = 675
* CHECK dout0_31 vdout0_31ck134 = 0 time = 675
* CHECK dout0_0 vdout0_0ck135 = 0 time = 680
* CHECK dout0_1 vdout0_1ck135 = 0.95 time = 680
* CHECK dout0_2 vdout0_2ck135 = 0 time = 680
* CHECK dout0_3 vdout0_3ck135 = 0 time = 680
* CHECK dout0_4 vdout0_4ck135 = 0.95 time = 680
* CHECK dout0_5 vdout0_5ck135 = 0.95 time = 680
* CHECK dout0_6 vdout0_6ck135 = 0.95 time = 680
* CHECK dout0_7 vdout0_7ck135 = 0 time = 680
* CHECK dout0_8 vdout0_8ck135 = 0.95 time = 680
* CHECK dout0_9 vdout0_9ck135 = 0 time = 680
* CHECK dout0_10 vdout0_10ck135 = 0.95 time = 680
* CHECK dout0_11 vdout0_11ck135 = 0 time = 680
* CHECK dout0_12 vdout0_12ck135 = 0 time = 680
* CHECK dout0_13 vdout0_13ck135 = 0 time = 680
* CHECK dout0_14 vdout0_14ck135 = 0 time = 680
* CHECK dout0_15 vdout0_15ck135 = 0.95 time = 680
* CHECK dout0_16 vdout0_16ck135 = 0 time = 680
* CHECK dout0_17 vdout0_17ck135 = 0.95 time = 680
* CHECK dout0_18 vdout0_18ck135 = 0.95 time = 680
* CHECK dout0_19 vdout0_19ck135 = 0 time = 680
* CHECK dout0_20 vdout0_20ck135 = 0.95 time = 680
* CHECK dout0_21 vdout0_21ck135 = 0.95 time = 680
* CHECK dout0_22 vdout0_22ck135 = 0.95 time = 680
* CHECK dout0_23 vdout0_23ck135 = 0 time = 680
* CHECK dout0_24 vdout0_24ck135 = 0.95 time = 680
* CHECK dout0_25 vdout0_25ck135 = 0 time = 680
* CHECK dout0_26 vdout0_26ck135 = 0 time = 680
* CHECK dout0_27 vdout0_27ck135 = 0.95 time = 680
* CHECK dout0_28 vdout0_28ck135 = 0.95 time = 680
* CHECK dout0_29 vdout0_29ck135 = 0.95 time = 680
* CHECK dout0_30 vdout0_30ck135 = 0 time = 680
* CHECK dout0_31 vdout0_31ck135 = 0 time = 680
* CHECK dout0_0 vdout0_0ck136 = 0 time = 685
* CHECK dout0_1 vdout0_1ck136 = 0.95 time = 685
* CHECK dout0_2 vdout0_2ck136 = 0 time = 685
* CHECK dout0_3 vdout0_3ck136 = 0 time = 685
* CHECK dout0_4 vdout0_4ck136 = 0.95 time = 685
* CHECK dout0_5 vdout0_5ck136 = 0.95 time = 685
* CHECK dout0_6 vdout0_6ck136 = 0.95 time = 685
* CHECK dout0_7 vdout0_7ck136 = 0 time = 685
* CHECK dout0_8 vdout0_8ck136 = 0.95 time = 685
* CHECK dout0_9 vdout0_9ck136 = 0 time = 685
* CHECK dout0_10 vdout0_10ck136 = 0.95 time = 685
* CHECK dout0_11 vdout0_11ck136 = 0 time = 685
* CHECK dout0_12 vdout0_12ck136 = 0 time = 685
* CHECK dout0_13 vdout0_13ck136 = 0 time = 685
* CHECK dout0_14 vdout0_14ck136 = 0 time = 685
* CHECK dout0_15 vdout0_15ck136 = 0.95 time = 685
* CHECK dout0_16 vdout0_16ck136 = 0 time = 685
* CHECK dout0_17 vdout0_17ck136 = 0.95 time = 685
* CHECK dout0_18 vdout0_18ck136 = 0.95 time = 685
* CHECK dout0_19 vdout0_19ck136 = 0 time = 685
* CHECK dout0_20 vdout0_20ck136 = 0.95 time = 685
* CHECK dout0_21 vdout0_21ck136 = 0.95 time = 685
* CHECK dout0_22 vdout0_22ck136 = 0.95 time = 685
* CHECK dout0_23 vdout0_23ck136 = 0 time = 685
* CHECK dout0_24 vdout0_24ck136 = 0.95 time = 685
* CHECK dout0_25 vdout0_25ck136 = 0 time = 685
* CHECK dout0_26 vdout0_26ck136 = 0 time = 685
* CHECK dout0_27 vdout0_27ck136 = 0.95 time = 685
* CHECK dout0_28 vdout0_28ck136 = 0.95 time = 685
* CHECK dout0_29 vdout0_29ck136 = 0.95 time = 685
* CHECK dout0_30 vdout0_30ck136 = 0 time = 685
* CHECK dout0_31 vdout0_31ck136 = 0 time = 685
* CHECK dout0_0 vdout0_0ck139 = 0.95 time = 700
* CHECK dout0_1 vdout0_1ck139 = 0.95 time = 700
* CHECK dout0_2 vdout0_2ck139 = 0 time = 700
* CHECK dout0_3 vdout0_3ck139 = 0 time = 700
* CHECK dout0_4 vdout0_4ck139 = 0 time = 700
* CHECK dout0_5 vdout0_5ck139 = 0 time = 700
* CHECK dout0_6 vdout0_6ck139 = 0.95 time = 700
* CHECK dout0_7 vdout0_7ck139 = 0.95 time = 700
* CHECK dout0_8 vdout0_8ck139 = 0 time = 700
* CHECK dout0_9 vdout0_9ck139 = 0 time = 700
* CHECK dout0_10 vdout0_10ck139 = 0 time = 700
* CHECK dout0_11 vdout0_11ck139 = 0 time = 700
* CHECK dout0_12 vdout0_12ck139 = 0.95 time = 700
* CHECK dout0_13 vdout0_13ck139 = 0.95 time = 700
* CHECK dout0_14 vdout0_14ck139 = 0.95 time = 700
* CHECK dout0_15 vdout0_15ck139 = 0 time = 700
* CHECK dout0_16 vdout0_16ck139 = 0.95 time = 700
* CHECK dout0_17 vdout0_17ck139 = 0 time = 700
* CHECK dout0_18 vdout0_18ck139 = 0.95 time = 700
* CHECK dout0_19 vdout0_19ck139 = 0 time = 700
* CHECK dout0_20 vdout0_20ck139 = 0 time = 700
* CHECK dout0_21 vdout0_21ck139 = 0 time = 700
* CHECK dout0_22 vdout0_22ck139 = 0 time = 700
* CHECK dout0_23 vdout0_23ck139 = 0.95 time = 700
* CHECK dout0_24 vdout0_24ck139 = 0.95 time = 700
* CHECK dout0_25 vdout0_25ck139 = 0 time = 700
* CHECK dout0_26 vdout0_26ck139 = 0 time = 700
* CHECK dout0_27 vdout0_27ck139 = 0 time = 700
* CHECK dout0_28 vdout0_28ck139 = 0 time = 700
* CHECK dout0_29 vdout0_29ck139 = 0.95 time = 700
* CHECK dout0_30 vdout0_30ck139 = 0 time = 700
* CHECK dout0_31 vdout0_31ck139 = 0 time = 700
* CHECK dout0_0 vdout0_0ck140 = 0.95 time = 705
* CHECK dout0_1 vdout0_1ck140 = 0 time = 705
* CHECK dout0_2 vdout0_2ck140 = 0.95 time = 705
* CHECK dout0_3 vdout0_3ck140 = 0 time = 705
* CHECK dout0_4 vdout0_4ck140 = 0.95 time = 705
* CHECK dout0_5 vdout0_5ck140 = 0.95 time = 705
* CHECK dout0_6 vdout0_6ck140 = 0.95 time = 705
* CHECK dout0_7 vdout0_7ck140 = 0.95 time = 705
* CHECK dout0_8 vdout0_8ck140 = 0.95 time = 705
* CHECK dout0_9 vdout0_9ck140 = 0 time = 705
* CHECK dout0_10 vdout0_10ck140 = 0 time = 705
* CHECK dout0_11 vdout0_11ck140 = 0 time = 705
* CHECK dout0_12 vdout0_12ck140 = 0.95 time = 705
* CHECK dout0_13 vdout0_13ck140 = 0 time = 705
* CHECK dout0_14 vdout0_14ck140 = 0 time = 705
* CHECK dout0_15 vdout0_15ck140 = 0.95 time = 705
* CHECK dout0_16 vdout0_16ck140 = 0.95 time = 705
* CHECK dout0_17 vdout0_17ck140 = 0 time = 705
* CHECK dout0_18 vdout0_18ck140 = 0 time = 705
* CHECK dout0_19 vdout0_19ck140 = 0.95 time = 705
* CHECK dout0_20 vdout0_20ck140 = 0.95 time = 705
* CHECK dout0_21 vdout0_21ck140 = 0.95 time = 705
* CHECK dout0_22 vdout0_22ck140 = 0.95 time = 705
* CHECK dout0_23 vdout0_23ck140 = 0.95 time = 705
* CHECK dout0_24 vdout0_24ck140 = 0.95 time = 705
* CHECK dout0_25 vdout0_25ck140 = 0 time = 705
* CHECK dout0_26 vdout0_26ck140 = 0.95 time = 705
* CHECK dout0_27 vdout0_27ck140 = 0.95 time = 705
* CHECK dout0_28 vdout0_28ck140 = 0.95 time = 705
* CHECK dout0_29 vdout0_29ck140 = 0 time = 705
* CHECK dout0_30 vdout0_30ck140 = 0 time = 705
* CHECK dout0_31 vdout0_31ck140 = 0 time = 705
* CHECK dout0_0 vdout0_0ck142 = 0 time = 715
* CHECK dout0_1 vdout0_1ck142 = 0.95 time = 715
* CHECK dout0_2 vdout0_2ck142 = 0.95 time = 715
* CHECK dout0_3 vdout0_3ck142 = 0 time = 715
* CHECK dout0_4 vdout0_4ck142 = 0 time = 715
* CHECK dout0_5 vdout0_5ck142 = 0.95 time = 715
* CHECK dout0_6 vdout0_6ck142 = 0.95 time = 715
* CHECK dout0_7 vdout0_7ck142 = 0.95 time = 715
* CHECK dout0_8 vdout0_8ck142 = 0.95 time = 715
* CHECK dout0_9 vdout0_9ck142 = 0 time = 715
* CHECK dout0_10 vdout0_10ck142 = 0 time = 715
* CHECK dout0_11 vdout0_11ck142 = 0 time = 715
* CHECK dout0_12 vdout0_12ck142 = 0.95 time = 715
* CHECK dout0_13 vdout0_13ck142 = 0.95 time = 715
* CHECK dout0_14 vdout0_14ck142 = 0 time = 715
* CHECK dout0_15 vdout0_15ck142 = 0 time = 715
* CHECK dout0_16 vdout0_16ck142 = 0 time = 715
* CHECK dout0_17 vdout0_17ck142 = 0.95 time = 715
* CHECK dout0_18 vdout0_18ck142 = 0 time = 715
* CHECK dout0_19 vdout0_19ck142 = 0.95 time = 715
* CHECK dout0_20 vdout0_20ck142 = 0 time = 715
* CHECK dout0_21 vdout0_21ck142 = 0 time = 715
* CHECK dout0_22 vdout0_22ck142 = 0 time = 715
* CHECK dout0_23 vdout0_23ck142 = 0 time = 715
* CHECK dout0_24 vdout0_24ck142 = 0.95 time = 715
* CHECK dout0_25 vdout0_25ck142 = 0.95 time = 715
* CHECK dout0_26 vdout0_26ck142 = 0 time = 715
* CHECK dout0_27 vdout0_27ck142 = 0 time = 715
* CHECK dout0_28 vdout0_28ck142 = 0 time = 715
* CHECK dout0_29 vdout0_29ck142 = 0.95 time = 715
* CHECK dout0_30 vdout0_30ck142 = 0 time = 715
* CHECK dout0_31 vdout0_31ck142 = 0 time = 715
* CHECK dout0_0 vdout0_0ck145 = 0.95 time = 730
* CHECK dout0_1 vdout0_1ck145 = 0 time = 730
* CHECK dout0_2 vdout0_2ck145 = 0.95 time = 730
* CHECK dout0_3 vdout0_3ck145 = 0 time = 730
* CHECK dout0_4 vdout0_4ck145 = 0 time = 730
* CHECK dout0_5 vdout0_5ck145 = 0.95 time = 730
* CHECK dout0_6 vdout0_6ck145 = 0 time = 730
* CHECK dout0_7 vdout0_7ck145 = 0 time = 730
* CHECK dout0_8 vdout0_8ck145 = 0.95 time = 730
* CHECK dout0_9 vdout0_9ck145 = 0.95 time = 730
* CHECK dout0_10 vdout0_10ck145 = 0.95 time = 730
* CHECK dout0_11 vdout0_11ck145 = 0 time = 730
* CHECK dout0_12 vdout0_12ck145 = 0.95 time = 730
* CHECK dout0_13 vdout0_13ck145 = 0 time = 730
* CHECK dout0_14 vdout0_14ck145 = 0 time = 730
* CHECK dout0_15 vdout0_15ck145 = 0.95 time = 730
* CHECK dout0_16 vdout0_16ck145 = 0.95 time = 730
* CHECK dout0_17 vdout0_17ck145 = 0.95 time = 730
* CHECK dout0_18 vdout0_18ck145 = 0 time = 730
* CHECK dout0_19 vdout0_19ck145 = 0 time = 730
* CHECK dout0_20 vdout0_20ck145 = 0 time = 730
* CHECK dout0_21 vdout0_21ck145 = 0.95 time = 730
* CHECK dout0_22 vdout0_22ck145 = 0 time = 730
* CHECK dout0_23 vdout0_23ck145 = 0 time = 730
* CHECK dout0_24 vdout0_24ck145 = 0 time = 730
* CHECK dout0_25 vdout0_25ck145 = 0.95 time = 730
* CHECK dout0_26 vdout0_26ck145 = 0 time = 730
* CHECK dout0_27 vdout0_27ck145 = 0.95 time = 730
* CHECK dout0_28 vdout0_28ck145 = 0.95 time = 730
* CHECK dout0_29 vdout0_29ck145 = 0 time = 730
* CHECK dout0_30 vdout0_30ck145 = 0.95 time = 730
* CHECK dout0_31 vdout0_31ck145 = 0.95 time = 730
* CHECK dout0_0 vdout0_0ck147 = 0 time = 740
* CHECK dout0_1 vdout0_1ck147 = 0.95 time = 740
* CHECK dout0_2 vdout0_2ck147 = 0.95 time = 740
* CHECK dout0_3 vdout0_3ck147 = 0 time = 740
* CHECK dout0_4 vdout0_4ck147 = 0 time = 740
* CHECK dout0_5 vdout0_5ck147 = 0.95 time = 740
* CHECK dout0_6 vdout0_6ck147 = 0.95 time = 740
* CHECK dout0_7 vdout0_7ck147 = 0.95 time = 740
* CHECK dout0_8 vdout0_8ck147 = 0.95 time = 740
* CHECK dout0_9 vdout0_9ck147 = 0 time = 740
* CHECK dout0_10 vdout0_10ck147 = 0 time = 740
* CHECK dout0_11 vdout0_11ck147 = 0 time = 740
* CHECK dout0_12 vdout0_12ck147 = 0.95 time = 740
* CHECK dout0_13 vdout0_13ck147 = 0.95 time = 740
* CHECK dout0_14 vdout0_14ck147 = 0 time = 740
* CHECK dout0_15 vdout0_15ck147 = 0 time = 740
* CHECK dout0_16 vdout0_16ck147 = 0 time = 740
* CHECK dout0_17 vdout0_17ck147 = 0.95 time = 740
* CHECK dout0_18 vdout0_18ck147 = 0 time = 740
* CHECK dout0_19 vdout0_19ck147 = 0.95 time = 740
* CHECK dout0_20 vdout0_20ck147 = 0 time = 740
* CHECK dout0_21 vdout0_21ck147 = 0 time = 740
* CHECK dout0_22 vdout0_22ck147 = 0 time = 740
* CHECK dout0_23 vdout0_23ck147 = 0 time = 740
* CHECK dout0_24 vdout0_24ck147 = 0.95 time = 740
* CHECK dout0_25 vdout0_25ck147 = 0.95 time = 740
* CHECK dout0_26 vdout0_26ck147 = 0 time = 740
* CHECK dout0_27 vdout0_27ck147 = 0 time = 740
* CHECK dout0_28 vdout0_28ck147 = 0 time = 740
* CHECK dout0_29 vdout0_29ck147 = 0.95 time = 740
* CHECK dout0_30 vdout0_30ck147 = 0 time = 740
* CHECK dout0_31 vdout0_31ck147 = 0 time = 740
* CHECK dout0_0 vdout0_0ck148 = 0 time = 745
* CHECK dout0_1 vdout0_1ck148 = 0.95 time = 745
* CHECK dout0_2 vdout0_2ck148 = 0 time = 745
* CHECK dout0_3 vdout0_3ck148 = 0 time = 745
* CHECK dout0_4 vdout0_4ck148 = 0 time = 745
* CHECK dout0_5 vdout0_5ck148 = 0 time = 745
* CHECK dout0_6 vdout0_6ck148 = 0.95 time = 745
* CHECK dout0_7 vdout0_7ck148 = 0.95 time = 745
* CHECK dout0_8 vdout0_8ck148 = 0.95 time = 745
* CHECK dout0_9 vdout0_9ck148 = 0.95 time = 745
* CHECK dout0_10 vdout0_10ck148 = 0.95 time = 745
* CHECK dout0_11 vdout0_11ck148 = 0 time = 745
* CHECK dout0_12 vdout0_12ck148 = 0 time = 745
* CHECK dout0_13 vdout0_13ck148 = 0.95 time = 745
* CHECK dout0_14 vdout0_14ck148 = 0.95 time = 745
* CHECK dout0_15 vdout0_15ck148 = 0 time = 745
* CHECK dout0_16 vdout0_16ck148 = 0 time = 745
* CHECK dout0_17 vdout0_17ck148 = 0.95 time = 745
* CHECK dout0_18 vdout0_18ck148 = 0.95 time = 745
* CHECK dout0_19 vdout0_19ck148 = 0 time = 745
* CHECK dout0_20 vdout0_20ck148 = 0.95 time = 745
* CHECK dout0_21 vdout0_21ck148 = 0.95 time = 745
* CHECK dout0_22 vdout0_22ck148 = 0 time = 745
* CHECK dout0_23 vdout0_23ck148 = 0 time = 745
* CHECK dout0_24 vdout0_24ck148 = 0 time = 745
* CHECK dout0_25 vdout0_25ck148 = 0 time = 745
* CHECK dout0_26 vdout0_26ck148 = 0 time = 745
* CHECK dout0_27 vdout0_27ck148 = 0.95 time = 745
* CHECK dout0_28 vdout0_28ck148 = 0 time = 745
* CHECK dout0_29 vdout0_29ck148 = 0.95 time = 745
* CHECK dout0_30 vdout0_30ck148 = 0 time = 745
* CHECK dout0_31 vdout0_31ck148 = 0 time = 745
* CHECK dout0_0 vdout0_0ck150 = 0 time = 755
* CHECK dout0_1 vdout0_1ck150 = 0 time = 755
* CHECK dout0_2 vdout0_2ck150 = 0 time = 755
* CHECK dout0_3 vdout0_3ck150 = 0.95 time = 755
* CHECK dout0_4 vdout0_4ck150 = 0.95 time = 755
* CHECK dout0_5 vdout0_5ck150 = 0.95 time = 755
* CHECK dout0_6 vdout0_6ck150 = 0 time = 755
* CHECK dout0_7 vdout0_7ck150 = 0 time = 755
* CHECK dout0_8 vdout0_8ck150 = 0 time = 755
* CHECK dout0_9 vdout0_9ck150 = 0.95 time = 755
* CHECK dout0_10 vdout0_10ck150 = 0 time = 755
* CHECK dout0_11 vdout0_11ck150 = 0.95 time = 755
* CHECK dout0_12 vdout0_12ck150 = 0.95 time = 755
* CHECK dout0_13 vdout0_13ck150 = 0.95 time = 755
* CHECK dout0_14 vdout0_14ck150 = 0.95 time = 755
* CHECK dout0_15 vdout0_15ck150 = 0 time = 755
* CHECK dout0_16 vdout0_16ck150 = 0 time = 755
* CHECK dout0_17 vdout0_17ck150 = 0 time = 755
* CHECK dout0_18 vdout0_18ck150 = 0.95 time = 755
* CHECK dout0_19 vdout0_19ck150 = 0 time = 755
* CHECK dout0_20 vdout0_20ck150 = 0 time = 755
* CHECK dout0_21 vdout0_21ck150 = 0.95 time = 755
* CHECK dout0_22 vdout0_22ck150 = 0.95 time = 755
* CHECK dout0_23 vdout0_23ck150 = 0.95 time = 755
* CHECK dout0_24 vdout0_24ck150 = 0.95 time = 755
* CHECK dout0_25 vdout0_25ck150 = 0.95 time = 755
* CHECK dout0_26 vdout0_26ck150 = 0.95 time = 755
* CHECK dout0_27 vdout0_27ck150 = 0 time = 755
* CHECK dout0_28 vdout0_28ck150 = 0.95 time = 755
* CHECK dout0_29 vdout0_29ck150 = 0.95 time = 755
* CHECK dout0_30 vdout0_30ck150 = 0 time = 755
* CHECK dout0_31 vdout0_31ck150 = 0.95 time = 755
* CHECK dout0_0 vdout0_0ck152 = 0.95 time = 765
* CHECK dout0_1 vdout0_1ck152 = 0.95 time = 765
* CHECK dout0_2 vdout0_2ck152 = 0.95 time = 765
* CHECK dout0_3 vdout0_3ck152 = 0.95 time = 765
* CHECK dout0_4 vdout0_4ck152 = 0 time = 765
* CHECK dout0_5 vdout0_5ck152 = 0 time = 765
* CHECK dout0_6 vdout0_6ck152 = 0.95 time = 765
* CHECK dout0_7 vdout0_7ck152 = 0 time = 765
* CHECK dout0_8 vdout0_8ck152 = 0 time = 765
* CHECK dout0_9 vdout0_9ck152 = 0.95 time = 765
* CHECK dout0_10 vdout0_10ck152 = 0.95 time = 765
* CHECK dout0_11 vdout0_11ck152 = 0 time = 765
* CHECK dout0_12 vdout0_12ck152 = 0 time = 765
* CHECK dout0_13 vdout0_13ck152 = 0 time = 765
* CHECK dout0_14 vdout0_14ck152 = 0 time = 765
* CHECK dout0_15 vdout0_15ck152 = 0 time = 765
* CHECK dout0_16 vdout0_16ck152 = 0.95 time = 765
* CHECK dout0_17 vdout0_17ck152 = 0 time = 765
* CHECK dout0_18 vdout0_18ck152 = 0.95 time = 765
* CHECK dout0_19 vdout0_19ck152 = 0 time = 765
* CHECK dout0_20 vdout0_20ck152 = 0 time = 765
* CHECK dout0_21 vdout0_21ck152 = 0.95 time = 765
* CHECK dout0_22 vdout0_22ck152 = 0 time = 765
* CHECK dout0_23 vdout0_23ck152 = 0 time = 765
* CHECK dout0_24 vdout0_24ck152 = 0 time = 765
* CHECK dout0_25 vdout0_25ck152 = 0 time = 765
* CHECK dout0_26 vdout0_26ck152 = 0.95 time = 765
* CHECK dout0_27 vdout0_27ck152 = 0.95 time = 765
* CHECK dout0_28 vdout0_28ck152 = 0.95 time = 765
* CHECK dout0_29 vdout0_29ck152 = 0.95 time = 765
* CHECK dout0_30 vdout0_30ck152 = 0.95 time = 765
* CHECK dout0_31 vdout0_31ck152 = 0.95 time = 765
* CHECK dout0_0 vdout0_0ck153 = 0 time = 770
* CHECK dout0_1 vdout0_1ck153 = 0.95 time = 770
* CHECK dout0_2 vdout0_2ck153 = 0 time = 770
* CHECK dout0_3 vdout0_3ck153 = 0 time = 770
* CHECK dout0_4 vdout0_4ck153 = 0 time = 770
* CHECK dout0_5 vdout0_5ck153 = 0 time = 770
* CHECK dout0_6 vdout0_6ck153 = 0.95 time = 770
* CHECK dout0_7 vdout0_7ck153 = 0.95 time = 770
* CHECK dout0_8 vdout0_8ck153 = 0.95 time = 770
* CHECK dout0_9 vdout0_9ck153 = 0.95 time = 770
* CHECK dout0_10 vdout0_10ck153 = 0.95 time = 770
* CHECK dout0_11 vdout0_11ck153 = 0 time = 770
* CHECK dout0_12 vdout0_12ck153 = 0 time = 770
* CHECK dout0_13 vdout0_13ck153 = 0.95 time = 770
* CHECK dout0_14 vdout0_14ck153 = 0.95 time = 770
* CHECK dout0_15 vdout0_15ck153 = 0 time = 770
* CHECK dout0_16 vdout0_16ck153 = 0 time = 770
* CHECK dout0_17 vdout0_17ck153 = 0.95 time = 770
* CHECK dout0_18 vdout0_18ck153 = 0.95 time = 770
* CHECK dout0_19 vdout0_19ck153 = 0 time = 770
* CHECK dout0_20 vdout0_20ck153 = 0.95 time = 770
* CHECK dout0_21 vdout0_21ck153 = 0.95 time = 770
* CHECK dout0_22 vdout0_22ck153 = 0 time = 770
* CHECK dout0_23 vdout0_23ck153 = 0 time = 770
* CHECK dout0_24 vdout0_24ck153 = 0 time = 770
* CHECK dout0_25 vdout0_25ck153 = 0 time = 770
* CHECK dout0_26 vdout0_26ck153 = 0 time = 770
* CHECK dout0_27 vdout0_27ck153 = 0.95 time = 770
* CHECK dout0_28 vdout0_28ck153 = 0 time = 770
* CHECK dout0_29 vdout0_29ck153 = 0.95 time = 770
* CHECK dout0_30 vdout0_30ck153 = 0 time = 770
* CHECK dout0_31 vdout0_31ck153 = 0 time = 770
* CHECK dout0_0 vdout0_0ck155 = 0.95 time = 780
* CHECK dout0_1 vdout0_1ck155 = 0.95 time = 780
* CHECK dout0_2 vdout0_2ck155 = 0 time = 780
* CHECK dout0_3 vdout0_3ck155 = 0.95 time = 780
* CHECK dout0_4 vdout0_4ck155 = 0.95 time = 780
* CHECK dout0_5 vdout0_5ck155 = 0.95 time = 780
* CHECK dout0_6 vdout0_6ck155 = 0 time = 780
* CHECK dout0_7 vdout0_7ck155 = 0 time = 780
* CHECK dout0_8 vdout0_8ck155 = 0.95 time = 780
* CHECK dout0_9 vdout0_9ck155 = 0 time = 780
* CHECK dout0_10 vdout0_10ck155 = 0.95 time = 780
* CHECK dout0_11 vdout0_11ck155 = 0.95 time = 780
* CHECK dout0_12 vdout0_12ck155 = 0 time = 780
* CHECK dout0_13 vdout0_13ck155 = 0 time = 780
* CHECK dout0_14 vdout0_14ck155 = 0.95 time = 780
* CHECK dout0_15 vdout0_15ck155 = 0 time = 780
* CHECK dout0_16 vdout0_16ck155 = 0 time = 780
* CHECK dout0_17 vdout0_17ck155 = 0 time = 780
* CHECK dout0_18 vdout0_18ck155 = 0 time = 780
* CHECK dout0_19 vdout0_19ck155 = 0.95 time = 780
* CHECK dout0_20 vdout0_20ck155 = 0.95 time = 780
* CHECK dout0_21 vdout0_21ck155 = 0.95 time = 780
* CHECK dout0_22 vdout0_22ck155 = 0.95 time = 780
* CHECK dout0_23 vdout0_23ck155 = 0.95 time = 780
* CHECK dout0_24 vdout0_24ck155 = 0 time = 780
* CHECK dout0_25 vdout0_25ck155 = 0.95 time = 780
* CHECK dout0_26 vdout0_26ck155 = 0 time = 780
* CHECK dout0_27 vdout0_27ck155 = 0.95 time = 780
* CHECK dout0_28 vdout0_28ck155 = 0.95 time = 780
* CHECK dout0_29 vdout0_29ck155 = 0.95 time = 780
* CHECK dout0_30 vdout0_30ck155 = 0 time = 780
* CHECK dout0_31 vdout0_31ck155 = 0.95 time = 780
* CHECK dout0_0 vdout0_0ck156 = 0 time = 785
* CHECK dout0_1 vdout0_1ck156 = 0.95 time = 785
* CHECK dout0_2 vdout0_2ck156 = 0 time = 785
* CHECK dout0_3 vdout0_3ck156 = 0 time = 785
* CHECK dout0_4 vdout0_4ck156 = 0 time = 785
* CHECK dout0_5 vdout0_5ck156 = 0.95 time = 785
* CHECK dout0_6 vdout0_6ck156 = 0 time = 785
* CHECK dout0_7 vdout0_7ck156 = 0.95 time = 785
* CHECK dout0_8 vdout0_8ck156 = 0.95 time = 785
* CHECK dout0_9 vdout0_9ck156 = 0.95 time = 785
* CHECK dout0_10 vdout0_10ck156 = 0.95 time = 785
* CHECK dout0_11 vdout0_11ck156 = 0 time = 785
* CHECK dout0_12 vdout0_12ck156 = 0 time = 785
* CHECK dout0_13 vdout0_13ck156 = 0.95 time = 785
* CHECK dout0_14 vdout0_14ck156 = 0.95 time = 785
* CHECK dout0_15 vdout0_15ck156 = 0 time = 785
* CHECK dout0_16 vdout0_16ck156 = 0.95 time = 785
* CHECK dout0_17 vdout0_17ck156 = 0 time = 785
* CHECK dout0_18 vdout0_18ck156 = 0 time = 785
* CHECK dout0_19 vdout0_19ck156 = 0 time = 785
* CHECK dout0_20 vdout0_20ck156 = 0 time = 785
* CHECK dout0_21 vdout0_21ck156 = 0.95 time = 785
* CHECK dout0_22 vdout0_22ck156 = 0 time = 785
* CHECK dout0_23 vdout0_23ck156 = 0 time = 785
* CHECK dout0_24 vdout0_24ck156 = 0 time = 785
* CHECK dout0_25 vdout0_25ck156 = 0.95 time = 785
* CHECK dout0_26 vdout0_26ck156 = 0 time = 785
* CHECK dout0_27 vdout0_27ck156 = 0 time = 785
* CHECK dout0_28 vdout0_28ck156 = 0 time = 785
* CHECK dout0_29 vdout0_29ck156 = 0 time = 785
* CHECK dout0_30 vdout0_30ck156 = 0.95 time = 785
* CHECK dout0_31 vdout0_31ck156 = 0.95 time = 785
* CHECK dout0_0 vdout0_0ck157 = 0 time = 790
* CHECK dout0_1 vdout0_1ck157 = 0.95 time = 790
* CHECK dout0_2 vdout0_2ck157 = 0.95 time = 790
* CHECK dout0_3 vdout0_3ck157 = 0.95 time = 790
* CHECK dout0_4 vdout0_4ck157 = 0 time = 790
* CHECK dout0_5 vdout0_5ck157 = 0.95 time = 790
* CHECK dout0_6 vdout0_6ck157 = 0.95 time = 790
* CHECK dout0_7 vdout0_7ck157 = 0.95 time = 790
* CHECK dout0_8 vdout0_8ck157 = 0 time = 790
* CHECK dout0_9 vdout0_9ck157 = 0.95 time = 790
* CHECK dout0_10 vdout0_10ck157 = 0.95 time = 790
* CHECK dout0_11 vdout0_11ck157 = 0.95 time = 790
* CHECK dout0_12 vdout0_12ck157 = 0.95 time = 790
* CHECK dout0_13 vdout0_13ck157 = 0.95 time = 790
* CHECK dout0_14 vdout0_14ck157 = 0 time = 790
* CHECK dout0_15 vdout0_15ck157 = 0 time = 790
* CHECK dout0_16 vdout0_16ck157 = 0.95 time = 790
* CHECK dout0_17 vdout0_17ck157 = 0.95 time = 790
* CHECK dout0_18 vdout0_18ck157 = 0.95 time = 790
* CHECK dout0_19 vdout0_19ck157 = 0.95 time = 790
* CHECK dout0_20 vdout0_20ck157 = 0 time = 790
* CHECK dout0_21 vdout0_21ck157 = 0.95 time = 790
* CHECK dout0_22 vdout0_22ck157 = 0.95 time = 790
* CHECK dout0_23 vdout0_23ck157 = 0.95 time = 790
* CHECK dout0_24 vdout0_24ck157 = 0 time = 790
* CHECK dout0_25 vdout0_25ck157 = 0.95 time = 790
* CHECK dout0_26 vdout0_26ck157 = 0.95 time = 790
* CHECK dout0_27 vdout0_27ck157 = 0.95 time = 790
* CHECK dout0_28 vdout0_28ck157 = 0 time = 790
* CHECK dout0_29 vdout0_29ck157 = 0 time = 790
* CHECK dout0_30 vdout0_30ck157 = 0 time = 790
* CHECK dout0_31 vdout0_31ck157 = 0 time = 790
* CHECK dout0_0 vdout0_0ck159 = 0 time = 800
* CHECK dout0_1 vdout0_1ck159 = 0.95 time = 800
* CHECK dout0_2 vdout0_2ck159 = 0 time = 800
* CHECK dout0_3 vdout0_3ck159 = 0 time = 800
* CHECK dout0_4 vdout0_4ck159 = 0 time = 800
* CHECK dout0_5 vdout0_5ck159 = 0 time = 800
* CHECK dout0_6 vdout0_6ck159 = 0.95 time = 800
* CHECK dout0_7 vdout0_7ck159 = 0.95 time = 800
* CHECK dout0_8 vdout0_8ck159 = 0.95 time = 800
* CHECK dout0_9 vdout0_9ck159 = 0.95 time = 800
* CHECK dout0_10 vdout0_10ck159 = 0.95 time = 800
* CHECK dout0_11 vdout0_11ck159 = 0 time = 800
* CHECK dout0_12 vdout0_12ck159 = 0 time = 800
* CHECK dout0_13 vdout0_13ck159 = 0.95 time = 800
* CHECK dout0_14 vdout0_14ck159 = 0.95 time = 800
* CHECK dout0_15 vdout0_15ck159 = 0 time = 800
* CHECK dout0_16 vdout0_16ck159 = 0 time = 800
* CHECK dout0_17 vdout0_17ck159 = 0.95 time = 800
* CHECK dout0_18 vdout0_18ck159 = 0.95 time = 800
* CHECK dout0_19 vdout0_19ck159 = 0 time = 800
* CHECK dout0_20 vdout0_20ck159 = 0.95 time = 800
* CHECK dout0_21 vdout0_21ck159 = 0.95 time = 800
* CHECK dout0_22 vdout0_22ck159 = 0 time = 800
* CHECK dout0_23 vdout0_23ck159 = 0 time = 800
* CHECK dout0_24 vdout0_24ck159 = 0 time = 800
* CHECK dout0_25 vdout0_25ck159 = 0 time = 800
* CHECK dout0_26 vdout0_26ck159 = 0 time = 800
* CHECK dout0_27 vdout0_27ck159 = 0.95 time = 800
* CHECK dout0_28 vdout0_28ck159 = 0 time = 800
* CHECK dout0_29 vdout0_29ck159 = 0.95 time = 800
* CHECK dout0_30 vdout0_30ck159 = 0 time = 800
* CHECK dout0_31 vdout0_31ck159 = 0 time = 800
* CHECK dout0_0 vdout0_0ck160 = 0.95 time = 805
* CHECK dout0_1 vdout0_1ck160 = 0 time = 805
* CHECK dout0_2 vdout0_2ck160 = 0.95 time = 805
* CHECK dout0_3 vdout0_3ck160 = 0 time = 805
* CHECK dout0_4 vdout0_4ck160 = 0.95 time = 805
* CHECK dout0_5 vdout0_5ck160 = 0.95 time = 805
* CHECK dout0_6 vdout0_6ck160 = 0.95 time = 805
* CHECK dout0_7 vdout0_7ck160 = 0.95 time = 805
* CHECK dout0_8 vdout0_8ck160 = 0.95 time = 805
* CHECK dout0_9 vdout0_9ck160 = 0 time = 805
* CHECK dout0_10 vdout0_10ck160 = 0 time = 805
* CHECK dout0_11 vdout0_11ck160 = 0 time = 805
* CHECK dout0_12 vdout0_12ck160 = 0.95 time = 805
* CHECK dout0_13 vdout0_13ck160 = 0 time = 805
* CHECK dout0_14 vdout0_14ck160 = 0 time = 805
* CHECK dout0_15 vdout0_15ck160 = 0.95 time = 805
* CHECK dout0_16 vdout0_16ck160 = 0.95 time = 805
* CHECK dout0_17 vdout0_17ck160 = 0 time = 805
* CHECK dout0_18 vdout0_18ck160 = 0 time = 805
* CHECK dout0_19 vdout0_19ck160 = 0.95 time = 805
* CHECK dout0_20 vdout0_20ck160 = 0.95 time = 805
* CHECK dout0_21 vdout0_21ck160 = 0.95 time = 805
* CHECK dout0_22 vdout0_22ck160 = 0.95 time = 805
* CHECK dout0_23 vdout0_23ck160 = 0.95 time = 805
* CHECK dout0_24 vdout0_24ck160 = 0.95 time = 805
* CHECK dout0_25 vdout0_25ck160 = 0 time = 805
* CHECK dout0_26 vdout0_26ck160 = 0.95 time = 805
* CHECK dout0_27 vdout0_27ck160 = 0.95 time = 805
* CHECK dout0_28 vdout0_28ck160 = 0.95 time = 805
* CHECK dout0_29 vdout0_29ck160 = 0 time = 805
* CHECK dout0_30 vdout0_30ck160 = 0 time = 805
* CHECK dout0_31 vdout0_31ck160 = 0 time = 805
* CHECK dout0_0 vdout0_0ck162 = 0 time = 815
* CHECK dout0_1 vdout0_1ck162 = 0.95 time = 815
* CHECK dout0_2 vdout0_2ck162 = 0.95 time = 815
* CHECK dout0_3 vdout0_3ck162 = 0.95 time = 815
* CHECK dout0_4 vdout0_4ck162 = 0 time = 815
* CHECK dout0_5 vdout0_5ck162 = 0 time = 815
* CHECK dout0_6 vdout0_6ck162 = 0 time = 815
* CHECK dout0_7 vdout0_7ck162 = 0.95 time = 815
* CHECK dout0_8 vdout0_8ck162 = 0 time = 815
* CHECK dout0_9 vdout0_9ck162 = 0.95 time = 815
* CHECK dout0_10 vdout0_10ck162 = 0.95 time = 815
* CHECK dout0_11 vdout0_11ck162 = 0 time = 815
* CHECK dout0_12 vdout0_12ck162 = 0.95 time = 815
* CHECK dout0_13 vdout0_13ck162 = 0.95 time = 815
* CHECK dout0_14 vdout0_14ck162 = 0 time = 815
* CHECK dout0_15 vdout0_15ck162 = 0 time = 815
* CHECK dout0_16 vdout0_16ck162 = 0 time = 815
* CHECK dout0_17 vdout0_17ck162 = 0.95 time = 815
* CHECK dout0_18 vdout0_18ck162 = 0 time = 815
* CHECK dout0_19 vdout0_19ck162 = 0 time = 815
* CHECK dout0_20 vdout0_20ck162 = 0 time = 815
* CHECK dout0_21 vdout0_21ck162 = 0.95 time = 815
* CHECK dout0_22 vdout0_22ck162 = 0 time = 815
* CHECK dout0_23 vdout0_23ck162 = 0.95 time = 815
* CHECK dout0_24 vdout0_24ck162 = 0 time = 815
* CHECK dout0_25 vdout0_25ck162 = 0 time = 815
* CHECK dout0_26 vdout0_26ck162 = 0 time = 815
* CHECK dout0_27 vdout0_27ck162 = 0 time = 815
* CHECK dout0_28 vdout0_28ck162 = 0 time = 815
* CHECK dout0_29 vdout0_29ck162 = 0.95 time = 815
* CHECK dout0_30 vdout0_30ck162 = 0.95 time = 815
* CHECK dout0_31 vdout0_31ck162 = 0.95 time = 815
* CHECK dout0_0 vdout0_0ck163 = 0.95 time = 820
* CHECK dout0_1 vdout0_1ck163 = 0 time = 820
* CHECK dout0_2 vdout0_2ck163 = 0.95 time = 820
* CHECK dout0_3 vdout0_3ck163 = 0 time = 820
* CHECK dout0_4 vdout0_4ck163 = 0.95 time = 820
* CHECK dout0_5 vdout0_5ck163 = 0.95 time = 820
* CHECK dout0_6 vdout0_6ck163 = 0.95 time = 820
* CHECK dout0_7 vdout0_7ck163 = 0 time = 820
* CHECK dout0_8 vdout0_8ck163 = 0.95 time = 820
* CHECK dout0_9 vdout0_9ck163 = 0 time = 820
* CHECK dout0_10 vdout0_10ck163 = 0 time = 820
* CHECK dout0_11 vdout0_11ck163 = 0 time = 820
* CHECK dout0_12 vdout0_12ck163 = 0 time = 820
* CHECK dout0_13 vdout0_13ck163 = 0 time = 820
* CHECK dout0_14 vdout0_14ck163 = 0 time = 820
* CHECK dout0_15 vdout0_15ck163 = 0.95 time = 820
* CHECK dout0_16 vdout0_16ck163 = 0.95 time = 820
* CHECK dout0_17 vdout0_17ck163 = 0 time = 820
* CHECK dout0_18 vdout0_18ck163 = 0 time = 820
* CHECK dout0_19 vdout0_19ck163 = 0 time = 820
* CHECK dout0_20 vdout0_20ck163 = 0.95 time = 820
* CHECK dout0_21 vdout0_21ck163 = 0.95 time = 820
* CHECK dout0_22 vdout0_22ck163 = 0 time = 820
* CHECK dout0_23 vdout0_23ck163 = 0.95 time = 820
* CHECK dout0_24 vdout0_24ck163 = 0 time = 820
* CHECK dout0_25 vdout0_25ck163 = 0.95 time = 820
* CHECK dout0_26 vdout0_26ck163 = 0.95 time = 820
* CHECK dout0_27 vdout0_27ck163 = 0.95 time = 820
* CHECK dout0_28 vdout0_28ck163 = 0 time = 820
* CHECK dout0_29 vdout0_29ck163 = 0 time = 820
* CHECK dout0_30 vdout0_30ck163 = 0 time = 820
* CHECK dout0_31 vdout0_31ck163 = 0 time = 820
* CHECK dout0_0 vdout0_0ck165 = 0.95 time = 830
* CHECK dout0_1 vdout0_1ck165 = 0 time = 830
* CHECK dout0_2 vdout0_2ck165 = 0.95 time = 830
* CHECK dout0_3 vdout0_3ck165 = 0 time = 830
* CHECK dout0_4 vdout0_4ck165 = 0.95 time = 830
* CHECK dout0_5 vdout0_5ck165 = 0.95 time = 830
* CHECK dout0_6 vdout0_6ck165 = 0.95 time = 830
* CHECK dout0_7 vdout0_7ck165 = 0 time = 830
* CHECK dout0_8 vdout0_8ck165 = 0.95 time = 830
* CHECK dout0_9 vdout0_9ck165 = 0 time = 830
* CHECK dout0_10 vdout0_10ck165 = 0 time = 830
* CHECK dout0_11 vdout0_11ck165 = 0 time = 830
* CHECK dout0_12 vdout0_12ck165 = 0 time = 830
* CHECK dout0_13 vdout0_13ck165 = 0 time = 830
* CHECK dout0_14 vdout0_14ck165 = 0 time = 830
* CHECK dout0_15 vdout0_15ck165 = 0.95 time = 830
* CHECK dout0_16 vdout0_16ck165 = 0.95 time = 830
* CHECK dout0_17 vdout0_17ck165 = 0 time = 830
* CHECK dout0_18 vdout0_18ck165 = 0 time = 830
* CHECK dout0_19 vdout0_19ck165 = 0 time = 830
* CHECK dout0_20 vdout0_20ck165 = 0.95 time = 830
* CHECK dout0_21 vdout0_21ck165 = 0.95 time = 830
* CHECK dout0_22 vdout0_22ck165 = 0 time = 830
* CHECK dout0_23 vdout0_23ck165 = 0.95 time = 830
* CHECK dout0_24 vdout0_24ck165 = 0 time = 830
* CHECK dout0_25 vdout0_25ck165 = 0.95 time = 830
* CHECK dout0_26 vdout0_26ck165 = 0.95 time = 830
* CHECK dout0_27 vdout0_27ck165 = 0.95 time = 830
* CHECK dout0_28 vdout0_28ck165 = 0 time = 830
* CHECK dout0_29 vdout0_29ck165 = 0 time = 830
* CHECK dout0_30 vdout0_30ck165 = 0 time = 830
* CHECK dout0_31 vdout0_31ck165 = 0 time = 830
* CHECK dout0_0 vdout0_0ck167 = 0 time = 840
* CHECK dout0_1 vdout0_1ck167 = 0.95 time = 840
* CHECK dout0_2 vdout0_2ck167 = 0.95 time = 840
* CHECK dout0_3 vdout0_3ck167 = 0.95 time = 840
* CHECK dout0_4 vdout0_4ck167 = 0 time = 840
* CHECK dout0_5 vdout0_5ck167 = 0 time = 840
* CHECK dout0_6 vdout0_6ck167 = 0 time = 840
* CHECK dout0_7 vdout0_7ck167 = 0.95 time = 840
* CHECK dout0_8 vdout0_8ck167 = 0 time = 840
* CHECK dout0_9 vdout0_9ck167 = 0.95 time = 840
* CHECK dout0_10 vdout0_10ck167 = 0.95 time = 840
* CHECK dout0_11 vdout0_11ck167 = 0 time = 840
* CHECK dout0_12 vdout0_12ck167 = 0.95 time = 840
* CHECK dout0_13 vdout0_13ck167 = 0.95 time = 840
* CHECK dout0_14 vdout0_14ck167 = 0 time = 840
* CHECK dout0_15 vdout0_15ck167 = 0 time = 840
* CHECK dout0_16 vdout0_16ck167 = 0 time = 840
* CHECK dout0_17 vdout0_17ck167 = 0.95 time = 840
* CHECK dout0_18 vdout0_18ck167 = 0 time = 840
* CHECK dout0_19 vdout0_19ck167 = 0 time = 840
* CHECK dout0_20 vdout0_20ck167 = 0 time = 840
* CHECK dout0_21 vdout0_21ck167 = 0.95 time = 840
* CHECK dout0_22 vdout0_22ck167 = 0 time = 840
* CHECK dout0_23 vdout0_23ck167 = 0.95 time = 840
* CHECK dout0_24 vdout0_24ck167 = 0 time = 840
* CHECK dout0_25 vdout0_25ck167 = 0 time = 840
* CHECK dout0_26 vdout0_26ck167 = 0 time = 840
* CHECK dout0_27 vdout0_27ck167 = 0 time = 840
* CHECK dout0_28 vdout0_28ck167 = 0 time = 840
* CHECK dout0_29 vdout0_29ck167 = 0.95 time = 840
* CHECK dout0_30 vdout0_30ck167 = 0.95 time = 840
* CHECK dout0_31 vdout0_31ck167 = 0.95 time = 840
* CHECK dout0_0 vdout0_0ck168 = 0 time = 845
* CHECK dout0_1 vdout0_1ck168 = 0.95 time = 845
* CHECK dout0_2 vdout0_2ck168 = 0 time = 845
* CHECK dout0_3 vdout0_3ck168 = 0 time = 845
* CHECK dout0_4 vdout0_4ck168 = 0 time = 845
* CHECK dout0_5 vdout0_5ck168 = 0.95 time = 845
* CHECK dout0_6 vdout0_6ck168 = 0 time = 845
* CHECK dout0_7 vdout0_7ck168 = 0.95 time = 845
* CHECK dout0_8 vdout0_8ck168 = 0.95 time = 845
* CHECK dout0_9 vdout0_9ck168 = 0.95 time = 845
* CHECK dout0_10 vdout0_10ck168 = 0.95 time = 845
* CHECK dout0_11 vdout0_11ck168 = 0 time = 845
* CHECK dout0_12 vdout0_12ck168 = 0 time = 845
* CHECK dout0_13 vdout0_13ck168 = 0.95 time = 845
* CHECK dout0_14 vdout0_14ck168 = 0.95 time = 845
* CHECK dout0_15 vdout0_15ck168 = 0 time = 845
* CHECK dout0_16 vdout0_16ck168 = 0.95 time = 845
* CHECK dout0_17 vdout0_17ck168 = 0 time = 845
* CHECK dout0_18 vdout0_18ck168 = 0 time = 845
* CHECK dout0_19 vdout0_19ck168 = 0 time = 845
* CHECK dout0_20 vdout0_20ck168 = 0 time = 845
* CHECK dout0_21 vdout0_21ck168 = 0.95 time = 845
* CHECK dout0_22 vdout0_22ck168 = 0 time = 845
* CHECK dout0_23 vdout0_23ck168 = 0 time = 845
* CHECK dout0_24 vdout0_24ck168 = 0 time = 845
* CHECK dout0_25 vdout0_25ck168 = 0.95 time = 845
* CHECK dout0_26 vdout0_26ck168 = 0 time = 845
* CHECK dout0_27 vdout0_27ck168 = 0 time = 845
* CHECK dout0_28 vdout0_28ck168 = 0 time = 845
* CHECK dout0_29 vdout0_29ck168 = 0 time = 845
* CHECK dout0_30 vdout0_30ck168 = 0.95 time = 845
* CHECK dout0_31 vdout0_31ck168 = 0.95 time = 845
* CHECK dout0_0 vdout0_0ck170 = 0.95 time = 855
* CHECK dout0_1 vdout0_1ck170 = 0.95 time = 855
* CHECK dout0_2 vdout0_2ck170 = 0 time = 855
* CHECK dout0_3 vdout0_3ck170 = 0.95 time = 855
* CHECK dout0_4 vdout0_4ck170 = 0.95 time = 855
* CHECK dout0_5 vdout0_5ck170 = 0.95 time = 855
* CHECK dout0_6 vdout0_6ck170 = 0 time = 855
* CHECK dout0_7 vdout0_7ck170 = 0 time = 855
* CHECK dout0_8 vdout0_8ck170 = 0.95 time = 855
* CHECK dout0_9 vdout0_9ck170 = 0 time = 855
* CHECK dout0_10 vdout0_10ck170 = 0.95 time = 855
* CHECK dout0_11 vdout0_11ck170 = 0.95 time = 855
* CHECK dout0_12 vdout0_12ck170 = 0 time = 855
* CHECK dout0_13 vdout0_13ck170 = 0 time = 855
* CHECK dout0_14 vdout0_14ck170 = 0.95 time = 855
* CHECK dout0_15 vdout0_15ck170 = 0 time = 855
* CHECK dout0_16 vdout0_16ck170 = 0 time = 855
* CHECK dout0_17 vdout0_17ck170 = 0 time = 855
* CHECK dout0_18 vdout0_18ck170 = 0 time = 855
* CHECK dout0_19 vdout0_19ck170 = 0.95 time = 855
* CHECK dout0_20 vdout0_20ck170 = 0.95 time = 855
* CHECK dout0_21 vdout0_21ck170 = 0.95 time = 855
* CHECK dout0_22 vdout0_22ck170 = 0.95 time = 855
* CHECK dout0_23 vdout0_23ck170 = 0.95 time = 855
* CHECK dout0_24 vdout0_24ck170 = 0 time = 855
* CHECK dout0_25 vdout0_25ck170 = 0.95 time = 855
* CHECK dout0_26 vdout0_26ck170 = 0 time = 855
* CHECK dout0_27 vdout0_27ck170 = 0.95 time = 855
* CHECK dout0_28 vdout0_28ck170 = 0.95 time = 855
* CHECK dout0_29 vdout0_29ck170 = 0.95 time = 855
* CHECK dout0_30 vdout0_30ck170 = 0 time = 855
* CHECK dout0_31 vdout0_31ck170 = 0.95 time = 855
* CHECK dout0_0 vdout0_0ck173 = 0.95 time = 870
* CHECK dout0_1 vdout0_1ck173 = 0 time = 870
* CHECK dout0_2 vdout0_2ck173 = 0.95 time = 870
* CHECK dout0_3 vdout0_3ck173 = 0 time = 870
* CHECK dout0_4 vdout0_4ck173 = 0 time = 870
* CHECK dout0_5 vdout0_5ck173 = 0.95 time = 870
* CHECK dout0_6 vdout0_6ck173 = 0 time = 870
* CHECK dout0_7 vdout0_7ck173 = 0 time = 870
* CHECK dout0_8 vdout0_8ck173 = 0.95 time = 870
* CHECK dout0_9 vdout0_9ck173 = 0.95 time = 870
* CHECK dout0_10 vdout0_10ck173 = 0.95 time = 870
* CHECK dout0_11 vdout0_11ck173 = 0 time = 870
* CHECK dout0_12 vdout0_12ck173 = 0.95 time = 870
* CHECK dout0_13 vdout0_13ck173 = 0 time = 870
* CHECK dout0_14 vdout0_14ck173 = 0 time = 870
* CHECK dout0_15 vdout0_15ck173 = 0.95 time = 870
* CHECK dout0_16 vdout0_16ck173 = 0.95 time = 870
* CHECK dout0_17 vdout0_17ck173 = 0.95 time = 870
* CHECK dout0_18 vdout0_18ck173 = 0 time = 870
* CHECK dout0_19 vdout0_19ck173 = 0 time = 870
* CHECK dout0_20 vdout0_20ck173 = 0 time = 870
* CHECK dout0_21 vdout0_21ck173 = 0.95 time = 870
* CHECK dout0_22 vdout0_22ck173 = 0 time = 870
* CHECK dout0_23 vdout0_23ck173 = 0 time = 870
* CHECK dout0_24 vdout0_24ck173 = 0 time = 870
* CHECK dout0_25 vdout0_25ck173 = 0.95 time = 870
* CHECK dout0_26 vdout0_26ck173 = 0 time = 870
* CHECK dout0_27 vdout0_27ck173 = 0.95 time = 870
* CHECK dout0_28 vdout0_28ck173 = 0.95 time = 870
* CHECK dout0_29 vdout0_29ck173 = 0 time = 870
* CHECK dout0_30 vdout0_30ck173 = 0.95 time = 870
* CHECK dout0_31 vdout0_31ck173 = 0.95 time = 870
* CHECK dout0_0 vdout0_0ck176 = 0 time = 885
* CHECK dout0_1 vdout0_1ck176 = 0.95 time = 885
* CHECK dout0_2 vdout0_2ck176 = 0 time = 885
* CHECK dout0_3 vdout0_3ck176 = 0 time = 885
* CHECK dout0_4 vdout0_4ck176 = 0 time = 885
* CHECK dout0_5 vdout0_5ck176 = 0 time = 885
* CHECK dout0_6 vdout0_6ck176 = 0.95 time = 885
* CHECK dout0_7 vdout0_7ck176 = 0.95 time = 885
* CHECK dout0_8 vdout0_8ck176 = 0.95 time = 885
* CHECK dout0_9 vdout0_9ck176 = 0.95 time = 885
* CHECK dout0_10 vdout0_10ck176 = 0.95 time = 885
* CHECK dout0_11 vdout0_11ck176 = 0 time = 885
* CHECK dout0_12 vdout0_12ck176 = 0 time = 885
* CHECK dout0_13 vdout0_13ck176 = 0.95 time = 885
* CHECK dout0_14 vdout0_14ck176 = 0.95 time = 885
* CHECK dout0_15 vdout0_15ck176 = 0 time = 885
* CHECK dout0_16 vdout0_16ck176 = 0 time = 885
* CHECK dout0_17 vdout0_17ck176 = 0.95 time = 885
* CHECK dout0_18 vdout0_18ck176 = 0.95 time = 885
* CHECK dout0_19 vdout0_19ck176 = 0 time = 885
* CHECK dout0_20 vdout0_20ck176 = 0.95 time = 885
* CHECK dout0_21 vdout0_21ck176 = 0.95 time = 885
* CHECK dout0_22 vdout0_22ck176 = 0 time = 885
* CHECK dout0_23 vdout0_23ck176 = 0 time = 885
* CHECK dout0_24 vdout0_24ck176 = 0 time = 885
* CHECK dout0_25 vdout0_25ck176 = 0 time = 885
* CHECK dout0_26 vdout0_26ck176 = 0 time = 885
* CHECK dout0_27 vdout0_27ck176 = 0.95 time = 885
* CHECK dout0_28 vdout0_28ck176 = 0 time = 885
* CHECK dout0_29 vdout0_29ck176 = 0.95 time = 885
* CHECK dout0_30 vdout0_30ck176 = 0 time = 885
* CHECK dout0_31 vdout0_31ck176 = 0 time = 885
* CHECK dout0_0 vdout0_0ck177 = 0 time = 890
* CHECK dout0_1 vdout0_1ck177 = 0.95 time = 890
* CHECK dout0_2 vdout0_2ck177 = 0.95 time = 890
* CHECK dout0_3 vdout0_3ck177 = 0.95 time = 890
* CHECK dout0_4 vdout0_4ck177 = 0 time = 890
* CHECK dout0_5 vdout0_5ck177 = 0 time = 890
* CHECK dout0_6 vdout0_6ck177 = 0 time = 890
* CHECK dout0_7 vdout0_7ck177 = 0.95 time = 890
* CHECK dout0_8 vdout0_8ck177 = 0 time = 890
* CHECK dout0_9 vdout0_9ck177 = 0.95 time = 890
* CHECK dout0_10 vdout0_10ck177 = 0.95 time = 890
* CHECK dout0_11 vdout0_11ck177 = 0 time = 890
* CHECK dout0_12 vdout0_12ck177 = 0.95 time = 890
* CHECK dout0_13 vdout0_13ck177 = 0.95 time = 890
* CHECK dout0_14 vdout0_14ck177 = 0 time = 890
* CHECK dout0_15 vdout0_15ck177 = 0 time = 890
* CHECK dout0_16 vdout0_16ck177 = 0 time = 890
* CHECK dout0_17 vdout0_17ck177 = 0.95 time = 890
* CHECK dout0_18 vdout0_18ck177 = 0 time = 890
* CHECK dout0_19 vdout0_19ck177 = 0 time = 890
* CHECK dout0_20 vdout0_20ck177 = 0 time = 890
* CHECK dout0_21 vdout0_21ck177 = 0.95 time = 890
* CHECK dout0_22 vdout0_22ck177 = 0 time = 890
* CHECK dout0_23 vdout0_23ck177 = 0.95 time = 890
* CHECK dout0_24 vdout0_24ck177 = 0 time = 890
* CHECK dout0_25 vdout0_25ck177 = 0 time = 890
* CHECK dout0_26 vdout0_26ck177 = 0 time = 890
* CHECK dout0_27 vdout0_27ck177 = 0 time = 890
* CHECK dout0_28 vdout0_28ck177 = 0 time = 890
* CHECK dout0_29 vdout0_29ck177 = 0.95 time = 890
* CHECK dout0_30 vdout0_30ck177 = 0.95 time = 890
* CHECK dout0_31 vdout0_31ck177 = 0.95 time = 890
* CHECK dout0_0 vdout0_0ck178 = 0 time = 895
* CHECK dout0_1 vdout0_1ck178 = 0.95 time = 895
* CHECK dout0_2 vdout0_2ck178 = 0 time = 895
* CHECK dout0_3 vdout0_3ck178 = 0 time = 895
* CHECK dout0_4 vdout0_4ck178 = 0 time = 895
* CHECK dout0_5 vdout0_5ck178 = 0.95 time = 895
* CHECK dout0_6 vdout0_6ck178 = 0 time = 895
* CHECK dout0_7 vdout0_7ck178 = 0.95 time = 895
* CHECK dout0_8 vdout0_8ck178 = 0.95 time = 895
* CHECK dout0_9 vdout0_9ck178 = 0.95 time = 895
* CHECK dout0_10 vdout0_10ck178 = 0.95 time = 895
* CHECK dout0_11 vdout0_11ck178 = 0 time = 895
* CHECK dout0_12 vdout0_12ck178 = 0 time = 895
* CHECK dout0_13 vdout0_13ck178 = 0.95 time = 895
* CHECK dout0_14 vdout0_14ck178 = 0.95 time = 895
* CHECK dout0_15 vdout0_15ck178 = 0 time = 895
* CHECK dout0_16 vdout0_16ck178 = 0.95 time = 895
* CHECK dout0_17 vdout0_17ck178 = 0 time = 895
* CHECK dout0_18 vdout0_18ck178 = 0 time = 895
* CHECK dout0_19 vdout0_19ck178 = 0 time = 895
* CHECK dout0_20 vdout0_20ck178 = 0 time = 895
* CHECK dout0_21 vdout0_21ck178 = 0.95 time = 895
* CHECK dout0_22 vdout0_22ck178 = 0 time = 895
* CHECK dout0_23 vdout0_23ck178 = 0 time = 895
* CHECK dout0_24 vdout0_24ck178 = 0 time = 895
* CHECK dout0_25 vdout0_25ck178 = 0.95 time = 895
* CHECK dout0_26 vdout0_26ck178 = 0 time = 895
* CHECK dout0_27 vdout0_27ck178 = 0 time = 895
* CHECK dout0_28 vdout0_28ck178 = 0 time = 895
* CHECK dout0_29 vdout0_29ck178 = 0 time = 895
* CHECK dout0_30 vdout0_30ck178 = 0.95 time = 895
* CHECK dout0_31 vdout0_31ck178 = 0.95 time = 895
* CHECK dout0_0 vdout0_0ck179 = 0.95 time = 900
* CHECK dout0_1 vdout0_1ck179 = 0 time = 900
* CHECK dout0_2 vdout0_2ck179 = 0.95 time = 900
* CHECK dout0_3 vdout0_3ck179 = 0 time = 900
* CHECK dout0_4 vdout0_4ck179 = 0 time = 900
* CHECK dout0_5 vdout0_5ck179 = 0.95 time = 900
* CHECK dout0_6 vdout0_6ck179 = 0 time = 900
* CHECK dout0_7 vdout0_7ck179 = 0 time = 900
* CHECK dout0_8 vdout0_8ck179 = 0.95 time = 900
* CHECK dout0_9 vdout0_9ck179 = 0.95 time = 900
* CHECK dout0_10 vdout0_10ck179 = 0.95 time = 900
* CHECK dout0_11 vdout0_11ck179 = 0 time = 900
* CHECK dout0_12 vdout0_12ck179 = 0.95 time = 900
* CHECK dout0_13 vdout0_13ck179 = 0 time = 900
* CHECK dout0_14 vdout0_14ck179 = 0 time = 900
* CHECK dout0_15 vdout0_15ck179 = 0.95 time = 900
* CHECK dout0_16 vdout0_16ck179 = 0.95 time = 900
* CHECK dout0_17 vdout0_17ck179 = 0.95 time = 900
* CHECK dout0_18 vdout0_18ck179 = 0 time = 900
* CHECK dout0_19 vdout0_19ck179 = 0 time = 900
* CHECK dout0_20 vdout0_20ck179 = 0 time = 900
* CHECK dout0_21 vdout0_21ck179 = 0.95 time = 900
* CHECK dout0_22 vdout0_22ck179 = 0 time = 900
* CHECK dout0_23 vdout0_23ck179 = 0 time = 900
* CHECK dout0_24 vdout0_24ck179 = 0 time = 900
* CHECK dout0_25 vdout0_25ck179 = 0.95 time = 900
* CHECK dout0_26 vdout0_26ck179 = 0 time = 900
* CHECK dout0_27 vdout0_27ck179 = 0.95 time = 900
* CHECK dout0_28 vdout0_28ck179 = 0.95 time = 900
* CHECK dout0_29 vdout0_29ck179 = 0 time = 900
* CHECK dout0_30 vdout0_30ck179 = 0.95 time = 900
* CHECK dout0_31 vdout0_31ck179 = 0.95 time = 900
* CHECK dout0_0 vdout0_0ck182 = 0.95 time = 915
* CHECK dout0_1 vdout0_1ck182 = 0.95 time = 915
* CHECK dout0_2 vdout0_2ck182 = 0 time = 915
* CHECK dout0_3 vdout0_3ck182 = 0.95 time = 915
* CHECK dout0_4 vdout0_4ck182 = 0.95 time = 915
* CHECK dout0_5 vdout0_5ck182 = 0.95 time = 915
* CHECK dout0_6 vdout0_6ck182 = 0 time = 915
* CHECK dout0_7 vdout0_7ck182 = 0 time = 915
* CHECK dout0_8 vdout0_8ck182 = 0.95 time = 915
* CHECK dout0_9 vdout0_9ck182 = 0 time = 915
* CHECK dout0_10 vdout0_10ck182 = 0.95 time = 915
* CHECK dout0_11 vdout0_11ck182 = 0.95 time = 915
* CHECK dout0_12 vdout0_12ck182 = 0 time = 915
* CHECK dout0_13 vdout0_13ck182 = 0 time = 915
* CHECK dout0_14 vdout0_14ck182 = 0.95 time = 915
* CHECK dout0_15 vdout0_15ck182 = 0 time = 915
* CHECK dout0_16 vdout0_16ck182 = 0 time = 915
* CHECK dout0_17 vdout0_17ck182 = 0 time = 915
* CHECK dout0_18 vdout0_18ck182 = 0 time = 915
* CHECK dout0_19 vdout0_19ck182 = 0.95 time = 915
* CHECK dout0_20 vdout0_20ck182 = 0.95 time = 915
* CHECK dout0_21 vdout0_21ck182 = 0.95 time = 915
* CHECK dout0_22 vdout0_22ck182 = 0.95 time = 915
* CHECK dout0_23 vdout0_23ck182 = 0.95 time = 915
* CHECK dout0_24 vdout0_24ck182 = 0 time = 915
* CHECK dout0_25 vdout0_25ck182 = 0.95 time = 915
* CHECK dout0_26 vdout0_26ck182 = 0 time = 915
* CHECK dout0_27 vdout0_27ck182 = 0.95 time = 915
* CHECK dout0_28 vdout0_28ck182 = 0.95 time = 915
* CHECK dout0_29 vdout0_29ck182 = 0.95 time = 915
* CHECK dout0_30 vdout0_30ck182 = 0 time = 915
* CHECK dout0_31 vdout0_31ck182 = 0.95 time = 915
* CHECK dout0_0 vdout0_0ck184 = 0 time = 925
* CHECK dout0_1 vdout0_1ck184 = 0.95 time = 925
* CHECK dout0_2 vdout0_2ck184 = 0.95 time = 925
* CHECK dout0_3 vdout0_3ck184 = 0 time = 925
* CHECK dout0_4 vdout0_4ck184 = 0 time = 925
* CHECK dout0_5 vdout0_5ck184 = 0.95 time = 925
* CHECK dout0_6 vdout0_6ck184 = 0.95 time = 925
* CHECK dout0_7 vdout0_7ck184 = 0.95 time = 925
* CHECK dout0_8 vdout0_8ck184 = 0.95 time = 925
* CHECK dout0_9 vdout0_9ck184 = 0 time = 925
* CHECK dout0_10 vdout0_10ck184 = 0 time = 925
* CHECK dout0_11 vdout0_11ck184 = 0 time = 925
* CHECK dout0_12 vdout0_12ck184 = 0.95 time = 925
* CHECK dout0_13 vdout0_13ck184 = 0.95 time = 925
* CHECK dout0_14 vdout0_14ck184 = 0 time = 925
* CHECK dout0_15 vdout0_15ck184 = 0 time = 925
* CHECK dout0_16 vdout0_16ck184 = 0 time = 925
* CHECK dout0_17 vdout0_17ck184 = 0.95 time = 925
* CHECK dout0_18 vdout0_18ck184 = 0 time = 925
* CHECK dout0_19 vdout0_19ck184 = 0.95 time = 925
* CHECK dout0_20 vdout0_20ck184 = 0 time = 925
* CHECK dout0_21 vdout0_21ck184 = 0 time = 925
* CHECK dout0_22 vdout0_22ck184 = 0 time = 925
* CHECK dout0_23 vdout0_23ck184 = 0 time = 925
* CHECK dout0_24 vdout0_24ck184 = 0.95 time = 925
* CHECK dout0_25 vdout0_25ck184 = 0.95 time = 925
* CHECK dout0_26 vdout0_26ck184 = 0 time = 925
* CHECK dout0_27 vdout0_27ck184 = 0 time = 925
* CHECK dout0_28 vdout0_28ck184 = 0 time = 925
* CHECK dout0_29 vdout0_29ck184 = 0.95 time = 925
* CHECK dout0_30 vdout0_30ck184 = 0 time = 925
* CHECK dout0_31 vdout0_31ck184 = 0 time = 925
* CHECK dout0_0 vdout0_0ck185 = 0 time = 930
* CHECK dout0_1 vdout0_1ck185 = 0.95 time = 930
* CHECK dout0_2 vdout0_2ck185 = 0.95 time = 930
* CHECK dout0_3 vdout0_3ck185 = 0.95 time = 930
* CHECK dout0_4 vdout0_4ck185 = 0 time = 930
* CHECK dout0_5 vdout0_5ck185 = 0.95 time = 930
* CHECK dout0_6 vdout0_6ck185 = 0.95 time = 930
* CHECK dout0_7 vdout0_7ck185 = 0.95 time = 930
* CHECK dout0_8 vdout0_8ck185 = 0 time = 930
* CHECK dout0_9 vdout0_9ck185 = 0.95 time = 930
* CHECK dout0_10 vdout0_10ck185 = 0.95 time = 930
* CHECK dout0_11 vdout0_11ck185 = 0.95 time = 930
* CHECK dout0_12 vdout0_12ck185 = 0.95 time = 930
* CHECK dout0_13 vdout0_13ck185 = 0.95 time = 930
* CHECK dout0_14 vdout0_14ck185 = 0 time = 930
* CHECK dout0_15 vdout0_15ck185 = 0 time = 930
* CHECK dout0_16 vdout0_16ck185 = 0.95 time = 930
* CHECK dout0_17 vdout0_17ck185 = 0.95 time = 930
* CHECK dout0_18 vdout0_18ck185 = 0.95 time = 930
* CHECK dout0_19 vdout0_19ck185 = 0.95 time = 930
* CHECK dout0_20 vdout0_20ck185 = 0 time = 930
* CHECK dout0_21 vdout0_21ck185 = 0.95 time = 930
* CHECK dout0_22 vdout0_22ck185 = 0.95 time = 930
* CHECK dout0_23 vdout0_23ck185 = 0.95 time = 930
* CHECK dout0_24 vdout0_24ck185 = 0 time = 930
* CHECK dout0_25 vdout0_25ck185 = 0.95 time = 930
* CHECK dout0_26 vdout0_26ck185 = 0.95 time = 930
* CHECK dout0_27 vdout0_27ck185 = 0.95 time = 930
* CHECK dout0_28 vdout0_28ck185 = 0 time = 930
* CHECK dout0_29 vdout0_29ck185 = 0 time = 930
* CHECK dout0_30 vdout0_30ck185 = 0 time = 930
* CHECK dout0_31 vdout0_31ck185 = 0 time = 930
* CHECK dout0_0 vdout0_0ck186 = 0.95 time = 935
* CHECK dout0_1 vdout0_1ck186 = 0.95 time = 935
* CHECK dout0_2 vdout0_2ck186 = 0.95 time = 935
* CHECK dout0_3 vdout0_3ck186 = 0.95 time = 935
* CHECK dout0_4 vdout0_4ck186 = 0 time = 935
* CHECK dout0_5 vdout0_5ck186 = 0 time = 935
* CHECK dout0_6 vdout0_6ck186 = 0.95 time = 935
* CHECK dout0_7 vdout0_7ck186 = 0 time = 935
* CHECK dout0_8 vdout0_8ck186 = 0 time = 935
* CHECK dout0_9 vdout0_9ck186 = 0.95 time = 935
* CHECK dout0_10 vdout0_10ck186 = 0.95 time = 935
* CHECK dout0_11 vdout0_11ck186 = 0 time = 935
* CHECK dout0_12 vdout0_12ck186 = 0 time = 935
* CHECK dout0_13 vdout0_13ck186 = 0 time = 935
* CHECK dout0_14 vdout0_14ck186 = 0 time = 935
* CHECK dout0_15 vdout0_15ck186 = 0 time = 935
* CHECK dout0_16 vdout0_16ck186 = 0.95 time = 935
* CHECK dout0_17 vdout0_17ck186 = 0 time = 935
* CHECK dout0_18 vdout0_18ck186 = 0.95 time = 935
* CHECK dout0_19 vdout0_19ck186 = 0 time = 935
* CHECK dout0_20 vdout0_20ck186 = 0 time = 935
* CHECK dout0_21 vdout0_21ck186 = 0.95 time = 935
* CHECK dout0_22 vdout0_22ck186 = 0 time = 935
* CHECK dout0_23 vdout0_23ck186 = 0 time = 935
* CHECK dout0_24 vdout0_24ck186 = 0 time = 935
* CHECK dout0_25 vdout0_25ck186 = 0 time = 935
* CHECK dout0_26 vdout0_26ck186 = 0.95 time = 935
* CHECK dout0_27 vdout0_27ck186 = 0.95 time = 935
* CHECK dout0_28 vdout0_28ck186 = 0.95 time = 935
* CHECK dout0_29 vdout0_29ck186 = 0.95 time = 935
* CHECK dout0_30 vdout0_30ck186 = 0.95 time = 935
* CHECK dout0_31 vdout0_31ck186 = 0.95 time = 935
* CHECK dout0_0 vdout0_0ck189 = 0 time = 950
* CHECK dout0_1 vdout0_1ck189 = 0 time = 950
* CHECK dout0_2 vdout0_2ck189 = 0 time = 950
* CHECK dout0_3 vdout0_3ck189 = 0.95 time = 950
* CHECK dout0_4 vdout0_4ck189 = 0.95 time = 950
* CHECK dout0_5 vdout0_5ck189 = 0.95 time = 950
* CHECK dout0_6 vdout0_6ck189 = 0 time = 950
* CHECK dout0_7 vdout0_7ck189 = 0 time = 950
* CHECK dout0_8 vdout0_8ck189 = 0 time = 950
* CHECK dout0_9 vdout0_9ck189 = 0.95 time = 950
* CHECK dout0_10 vdout0_10ck189 = 0 time = 950
* CHECK dout0_11 vdout0_11ck189 = 0.95 time = 950
* CHECK dout0_12 vdout0_12ck189 = 0.95 time = 950
* CHECK dout0_13 vdout0_13ck189 = 0.95 time = 950
* CHECK dout0_14 vdout0_14ck189 = 0.95 time = 950
* CHECK dout0_15 vdout0_15ck189 = 0 time = 950
* CHECK dout0_16 vdout0_16ck189 = 0 time = 950
* CHECK dout0_17 vdout0_17ck189 = 0 time = 950
* CHECK dout0_18 vdout0_18ck189 = 0.95 time = 950
* CHECK dout0_19 vdout0_19ck189 = 0 time = 950
* CHECK dout0_20 vdout0_20ck189 = 0 time = 950
* CHECK dout0_21 vdout0_21ck189 = 0.95 time = 950
* CHECK dout0_22 vdout0_22ck189 = 0.95 time = 950
* CHECK dout0_23 vdout0_23ck189 = 0.95 time = 950
* CHECK dout0_24 vdout0_24ck189 = 0.95 time = 950
* CHECK dout0_25 vdout0_25ck189 = 0.95 time = 950
* CHECK dout0_26 vdout0_26ck189 = 0.95 time = 950
* CHECK dout0_27 vdout0_27ck189 = 0 time = 950
* CHECK dout0_28 vdout0_28ck189 = 0.95 time = 950
* CHECK dout0_29 vdout0_29ck189 = 0.95 time = 950
* CHECK dout0_30 vdout0_30ck189 = 0 time = 950
* CHECK dout0_31 vdout0_31ck189 = 0.95 time = 950
* CHECK dout0_0 vdout0_0ck190 = 0 time = 955
* CHECK dout0_1 vdout0_1ck190 = 0.95 time = 955
* CHECK dout0_2 vdout0_2ck190 = 0.95 time = 955
* CHECK dout0_3 vdout0_3ck190 = 0.95 time = 955
* CHECK dout0_4 vdout0_4ck190 = 0.95 time = 955
* CHECK dout0_5 vdout0_5ck190 = 0 time = 955
* CHECK dout0_6 vdout0_6ck190 = 0.95 time = 955
* CHECK dout0_7 vdout0_7ck190 = 0 time = 955
* CHECK dout0_8 vdout0_8ck190 = 0 time = 955
* CHECK dout0_9 vdout0_9ck190 = 0 time = 955
* CHECK dout0_10 vdout0_10ck190 = 0.95 time = 955
* CHECK dout0_11 vdout0_11ck190 = 0 time = 955
* CHECK dout0_12 vdout0_12ck190 = 0.95 time = 955
* CHECK dout0_13 vdout0_13ck190 = 0.95 time = 955
* CHECK dout0_14 vdout0_14ck190 = 0.95 time = 955
* CHECK dout0_15 vdout0_15ck190 = 0.95 time = 955
* CHECK dout0_16 vdout0_16ck190 = 0.95 time = 955
* CHECK dout0_17 vdout0_17ck190 = 0.95 time = 955
* CHECK dout0_18 vdout0_18ck190 = 0.95 time = 955
* CHECK dout0_19 vdout0_19ck190 = 0 time = 955
* CHECK dout0_20 vdout0_20ck190 = 0 time = 955
* CHECK dout0_21 vdout0_21ck190 = 0 time = 955
* CHECK dout0_22 vdout0_22ck190 = 0 time = 955
* CHECK dout0_23 vdout0_23ck190 = 0 time = 955
* CHECK dout0_24 vdout0_24ck190 = 0.95 time = 955
* CHECK dout0_25 vdout0_25ck190 = 0 time = 955
* CHECK dout0_26 vdout0_26ck190 = 0 time = 955
* CHECK dout0_27 vdout0_27ck190 = 0.95 time = 955
* CHECK dout0_28 vdout0_28ck190 = 0 time = 955
* CHECK dout0_29 vdout0_29ck190 = 0 time = 955
* CHECK dout0_30 vdout0_30ck190 = 0 time = 955
* CHECK dout0_31 vdout0_31ck190 = 0.95 time = 955
* CHECK dout0_0 vdout0_0ck192 = 0 time = 965
* CHECK dout0_1 vdout0_1ck192 = 0 time = 965
* CHECK dout0_2 vdout0_2ck192 = 0.95 time = 965
* CHECK dout0_3 vdout0_3ck192 = 0.95 time = 965
* CHECK dout0_4 vdout0_4ck192 = 0.95 time = 965
* CHECK dout0_5 vdout0_5ck192 = 0 time = 965
* CHECK dout0_6 vdout0_6ck192 = 0 time = 965
* CHECK dout0_7 vdout0_7ck192 = 0.95 time = 965
* CHECK dout0_8 vdout0_8ck192 = 0.95 time = 965
* CHECK dout0_9 vdout0_9ck192 = 0 time = 965
* CHECK dout0_10 vdout0_10ck192 = 0.95 time = 965
* CHECK dout0_11 vdout0_11ck192 = 0.95 time = 965
* CHECK dout0_12 vdout0_12ck192 = 0.95 time = 965
* CHECK dout0_13 vdout0_13ck192 = 0 time = 965
* CHECK dout0_14 vdout0_14ck192 = 0.95 time = 965
* CHECK dout0_15 vdout0_15ck192 = 0.95 time = 965
* CHECK dout0_16 vdout0_16ck192 = 0.95 time = 965
* CHECK dout0_17 vdout0_17ck192 = 0.95 time = 965
* CHECK dout0_18 vdout0_18ck192 = 0.95 time = 965
* CHECK dout0_19 vdout0_19ck192 = 0 time = 965
* CHECK dout0_20 vdout0_20ck192 = 0 time = 965
* CHECK dout0_21 vdout0_21ck192 = 0.95 time = 965
* CHECK dout0_22 vdout0_22ck192 = 0 time = 965
* CHECK dout0_23 vdout0_23ck192 = 0.95 time = 965
* CHECK dout0_24 vdout0_24ck192 = 0 time = 965
* CHECK dout0_25 vdout0_25ck192 = 0.95 time = 965
* CHECK dout0_26 vdout0_26ck192 = 0 time = 965
* CHECK dout0_27 vdout0_27ck192 = 0 time = 965
* CHECK dout0_28 vdout0_28ck192 = 0 time = 965
* CHECK dout0_29 vdout0_29ck192 = 0.95 time = 965
* CHECK dout0_30 vdout0_30ck192 = 0 time = 965
* CHECK dout0_31 vdout0_31ck192 = 0.95 time = 965
* CHECK dout0_0 vdout0_0ck193 = 0 time = 970
* CHECK dout0_1 vdout0_1ck193 = 0.95 time = 970
* CHECK dout0_2 vdout0_2ck193 = 0.95 time = 970
* CHECK dout0_3 vdout0_3ck193 = 0 time = 970
* CHECK dout0_4 vdout0_4ck193 = 0 time = 970
* CHECK dout0_5 vdout0_5ck193 = 0.95 time = 970
* CHECK dout0_6 vdout0_6ck193 = 0.95 time = 970
* CHECK dout0_7 vdout0_7ck193 = 0.95 time = 970
* CHECK dout0_8 vdout0_8ck193 = 0.95 time = 970
* CHECK dout0_9 vdout0_9ck193 = 0 time = 970
* CHECK dout0_10 vdout0_10ck193 = 0 time = 970
* CHECK dout0_11 vdout0_11ck193 = 0 time = 970
* CHECK dout0_12 vdout0_12ck193 = 0.95 time = 970
* CHECK dout0_13 vdout0_13ck193 = 0.95 time = 970
* CHECK dout0_14 vdout0_14ck193 = 0 time = 970
* CHECK dout0_15 vdout0_15ck193 = 0 time = 970
* CHECK dout0_16 vdout0_16ck193 = 0 time = 970
* CHECK dout0_17 vdout0_17ck193 = 0.95 time = 970
* CHECK dout0_18 vdout0_18ck193 = 0 time = 970
* CHECK dout0_19 vdout0_19ck193 = 0.95 time = 970
* CHECK dout0_20 vdout0_20ck193 = 0 time = 970
* CHECK dout0_21 vdout0_21ck193 = 0 time = 970
* CHECK dout0_22 vdout0_22ck193 = 0 time = 970
* CHECK dout0_23 vdout0_23ck193 = 0 time = 970
* CHECK dout0_24 vdout0_24ck193 = 0.95 time = 970
* CHECK dout0_25 vdout0_25ck193 = 0.95 time = 970
* CHECK dout0_26 vdout0_26ck193 = 0 time = 970
* CHECK dout0_27 vdout0_27ck193 = 0 time = 970
* CHECK dout0_28 vdout0_28ck193 = 0 time = 970
* CHECK dout0_29 vdout0_29ck193 = 0.95 time = 970
* CHECK dout0_30 vdout0_30ck193 = 0 time = 970
* CHECK dout0_31 vdout0_31ck193 = 0 time = 970
* CHECK dout0_0 vdout0_0ck195 = 0.95 time = 980
* CHECK dout0_1 vdout0_1ck195 = 0 time = 980
* CHECK dout0_2 vdout0_2ck195 = 0.95 time = 980
* CHECK dout0_3 vdout0_3ck195 = 0 time = 980
* CHECK dout0_4 vdout0_4ck195 = 0.95 time = 980
* CHECK dout0_5 vdout0_5ck195 = 0.95 time = 980
* CHECK dout0_6 vdout0_6ck195 = 0.95 time = 980
* CHECK dout0_7 vdout0_7ck195 = 0 time = 980
* CHECK dout0_8 vdout0_8ck195 = 0.95 time = 980
* CHECK dout0_9 vdout0_9ck195 = 0 time = 980
* CHECK dout0_10 vdout0_10ck195 = 0 time = 980
* CHECK dout0_11 vdout0_11ck195 = 0 time = 980
* CHECK dout0_12 vdout0_12ck195 = 0 time = 980
* CHECK dout0_13 vdout0_13ck195 = 0 time = 980
* CHECK dout0_14 vdout0_14ck195 = 0 time = 980
* CHECK dout0_15 vdout0_15ck195 = 0.95 time = 980
* CHECK dout0_16 vdout0_16ck195 = 0.95 time = 980
* CHECK dout0_17 vdout0_17ck195 = 0 time = 980
* CHECK dout0_18 vdout0_18ck195 = 0 time = 980
* CHECK dout0_19 vdout0_19ck195 = 0 time = 980
* CHECK dout0_20 vdout0_20ck195 = 0.95 time = 980
* CHECK dout0_21 vdout0_21ck195 = 0.95 time = 980
* CHECK dout0_22 vdout0_22ck195 = 0 time = 980
* CHECK dout0_23 vdout0_23ck195 = 0.95 time = 980
* CHECK dout0_24 vdout0_24ck195 = 0 time = 980
* CHECK dout0_25 vdout0_25ck195 = 0.95 time = 980
* CHECK dout0_26 vdout0_26ck195 = 0.95 time = 980
* CHECK dout0_27 vdout0_27ck195 = 0.95 time = 980
* CHECK dout0_28 vdout0_28ck195 = 0 time = 980
* CHECK dout0_29 vdout0_29ck195 = 0 time = 980
* CHECK dout0_30 vdout0_30ck195 = 0 time = 980
* CHECK dout0_31 vdout0_31ck195 = 0 time = 980
* CHECK dout0_0 vdout0_0ck196 = 0 time = 985
* CHECK dout0_1 vdout0_1ck196 = 0 time = 985
* CHECK dout0_2 vdout0_2ck196 = 0 time = 985
* CHECK dout0_3 vdout0_3ck196 = 0.95 time = 985
* CHECK dout0_4 vdout0_4ck196 = 0 time = 985
* CHECK dout0_5 vdout0_5ck196 = 0 time = 985
* CHECK dout0_6 vdout0_6ck196 = 0.95 time = 985
* CHECK dout0_7 vdout0_7ck196 = 0 time = 985
* CHECK dout0_8 vdout0_8ck196 = 0.95 time = 985
* CHECK dout0_9 vdout0_9ck196 = 0.95 time = 985
* CHECK dout0_10 vdout0_10ck196 = 0.95 time = 985
* CHECK dout0_11 vdout0_11ck196 = 0.95 time = 985
* CHECK dout0_12 vdout0_12ck196 = 0.95 time = 985
* CHECK dout0_13 vdout0_13ck196 = 0 time = 985
* CHECK dout0_14 vdout0_14ck196 = 0 time = 985
* CHECK dout0_15 vdout0_15ck196 = 0 time = 985
* CHECK dout0_16 vdout0_16ck196 = 0.95 time = 985
* CHECK dout0_17 vdout0_17ck196 = 0 time = 985
* CHECK dout0_18 vdout0_18ck196 = 0 time = 985
* CHECK dout0_19 vdout0_19ck196 = 0.95 time = 985
* CHECK dout0_20 vdout0_20ck196 = 0 time = 985
* CHECK dout0_21 vdout0_21ck196 = 0.95 time = 985
* CHECK dout0_22 vdout0_22ck196 = 0.95 time = 985
* CHECK dout0_23 vdout0_23ck196 = 0.95 time = 985
* CHECK dout0_24 vdout0_24ck196 = 0.95 time = 985
* CHECK dout0_25 vdout0_25ck196 = 0 time = 985
* CHECK dout0_26 vdout0_26ck196 = 0 time = 985
* CHECK dout0_27 vdout0_27ck196 = 0 time = 985
* CHECK dout0_28 vdout0_28ck196 = 0 time = 985
* CHECK dout0_29 vdout0_29ck196 = 0 time = 985
* CHECK dout0_30 vdout0_30ck196 = 0 time = 985
* CHECK dout0_31 vdout0_31ck196 = 0 time = 985
* CHECK dout0_0 vdout0_0ck197 = 0.95 time = 990
* CHECK dout0_1 vdout0_1ck197 = 0 time = 990
* CHECK dout0_2 vdout0_2ck197 = 0.95 time = 990
* CHECK dout0_3 vdout0_3ck197 = 0.95 time = 990
* CHECK dout0_4 vdout0_4ck197 = 0 time = 990
* CHECK dout0_5 vdout0_5ck197 = 0.95 time = 990
* CHECK dout0_6 vdout0_6ck197 = 0 time = 990
* CHECK dout0_7 vdout0_7ck197 = 0.95 time = 990
* CHECK dout0_8 vdout0_8ck197 = 0.95 time = 990
* CHECK dout0_9 vdout0_9ck197 = 0 time = 990
* CHECK dout0_10 vdout0_10ck197 = 0 time = 990
* CHECK dout0_11 vdout0_11ck197 = 0 time = 990
* CHECK dout0_12 vdout0_12ck197 = 0.95 time = 990
* CHECK dout0_13 vdout0_13ck197 = 0.95 time = 990
* CHECK dout0_14 vdout0_14ck197 = 0 time = 990
* CHECK dout0_15 vdout0_15ck197 = 0.95 time = 990
* CHECK dout0_16 vdout0_16ck197 = 0.95 time = 990
* CHECK dout0_17 vdout0_17ck197 = 0 time = 990
* CHECK dout0_18 vdout0_18ck197 = 0.95 time = 990
* CHECK dout0_19 vdout0_19ck197 = 0 time = 990
* CHECK dout0_20 vdout0_20ck197 = 0 time = 990
* CHECK dout0_21 vdout0_21ck197 = 0 time = 990
* CHECK dout0_22 vdout0_22ck197 = 0.95 time = 990
* CHECK dout0_23 vdout0_23ck197 = 0.95 time = 990
* CHECK dout0_24 vdout0_24ck197 = 0 time = 990
* CHECK dout0_25 vdout0_25ck197 = 0.95 time = 990
* CHECK dout0_26 vdout0_26ck197 = 0.95 time = 990
* CHECK dout0_27 vdout0_27ck197 = 0 time = 990
* CHECK dout0_28 vdout0_28ck197 = 0 time = 990
* CHECK dout0_29 vdout0_29ck197 = 0 time = 990
* CHECK dout0_30 vdout0_30ck197 = 0.95 time = 990
* CHECK dout0_31 vdout0_31ck197 = 0 time = 990
* CHECK dout0_0 vdout0_0ck198 = 0.95 time = 995
* CHECK dout0_1 vdout0_1ck198 = 0 time = 995
* CHECK dout0_2 vdout0_2ck198 = 0.95 time = 995
* CHECK dout0_3 vdout0_3ck198 = 0.95 time = 995
* CHECK dout0_4 vdout0_4ck198 = 0 time = 995
* CHECK dout0_5 vdout0_5ck198 = 0.95 time = 995
* CHECK dout0_6 vdout0_6ck198 = 0 time = 995
* CHECK dout0_7 vdout0_7ck198 = 0.95 time = 995
* CHECK dout0_8 vdout0_8ck198 = 0.95 time = 995
* CHECK dout0_9 vdout0_9ck198 = 0 time = 995
* CHECK dout0_10 vdout0_10ck198 = 0 time = 995
* CHECK dout0_11 vdout0_11ck198 = 0 time = 995
* CHECK dout0_12 vdout0_12ck198 = 0.95 time = 995
* CHECK dout0_13 vdout0_13ck198 = 0.95 time = 995
* CHECK dout0_14 vdout0_14ck198 = 0 time = 995
* CHECK dout0_15 vdout0_15ck198 = 0.95 time = 995
* CHECK dout0_16 vdout0_16ck198 = 0.95 time = 995
* CHECK dout0_17 vdout0_17ck198 = 0 time = 995
* CHECK dout0_18 vdout0_18ck198 = 0.95 time = 995
* CHECK dout0_19 vdout0_19ck198 = 0 time = 995
* CHECK dout0_20 vdout0_20ck198 = 0 time = 995
* CHECK dout0_21 vdout0_21ck198 = 0 time = 995
* CHECK dout0_22 vdout0_22ck198 = 0.95 time = 995
* CHECK dout0_23 vdout0_23ck198 = 0.95 time = 995
* CHECK dout0_24 vdout0_24ck198 = 0 time = 995
* CHECK dout0_25 vdout0_25ck198 = 0.95 time = 995
* CHECK dout0_26 vdout0_26ck198 = 0.95 time = 995
* CHECK dout0_27 vdout0_27ck198 = 0 time = 995
* CHECK dout0_28 vdout0_28ck198 = 0 time = 995
* CHECK dout0_29 vdout0_29ck198 = 0 time = 995
* CHECK dout0_30 vdout0_30ck198 = 0.95 time = 995
* CHECK dout0_31 vdout0_31ck198 = 0 time = 995
* CHECK dout0_0 vdout0_0ck199 = 0 time = 1000
* CHECK dout0_1 vdout0_1ck199 = 0.95 time = 1000
* CHECK dout0_2 vdout0_2ck199 = 0.95 time = 1000
* CHECK dout0_3 vdout0_3ck199 = 0.95 time = 1000
* CHECK dout0_4 vdout0_4ck199 = 0.95 time = 1000
* CHECK dout0_5 vdout0_5ck199 = 0 time = 1000
* CHECK dout0_6 vdout0_6ck199 = 0.95 time = 1000
* CHECK dout0_7 vdout0_7ck199 = 0 time = 1000
* CHECK dout0_8 vdout0_8ck199 = 0 time = 1000
* CHECK dout0_9 vdout0_9ck199 = 0 time = 1000
* CHECK dout0_10 vdout0_10ck199 = 0.95 time = 1000
* CHECK dout0_11 vdout0_11ck199 = 0 time = 1000
* CHECK dout0_12 vdout0_12ck199 = 0.95 time = 1000
* CHECK dout0_13 vdout0_13ck199 = 0.95 time = 1000
* CHECK dout0_14 vdout0_14ck199 = 0.95 time = 1000
* CHECK dout0_15 vdout0_15ck199 = 0.95 time = 1000
* CHECK dout0_16 vdout0_16ck199 = 0.95 time = 1000
* CHECK dout0_17 vdout0_17ck199 = 0.95 time = 1000
* CHECK dout0_18 vdout0_18ck199 = 0.95 time = 1000
* CHECK dout0_19 vdout0_19ck199 = 0 time = 1000
* CHECK dout0_20 vdout0_20ck199 = 0 time = 1000
* CHECK dout0_21 vdout0_21ck199 = 0 time = 1000
* CHECK dout0_22 vdout0_22ck199 = 0 time = 1000
* CHECK dout0_23 vdout0_23ck199 = 0 time = 1000
* CHECK dout0_24 vdout0_24ck199 = 0.95 time = 1000
* CHECK dout0_25 vdout0_25ck199 = 0 time = 1000
* CHECK dout0_26 vdout0_26ck199 = 0 time = 1000
* CHECK dout0_27 vdout0_27ck199 = 0.95 time = 1000
* CHECK dout0_28 vdout0_28ck199 = 0 time = 1000
* CHECK dout0_29 vdout0_29ck199 = 0 time = 1000
* CHECK dout0_30 vdout0_30ck199 = 0 time = 1000
* CHECK dout0_31 vdout0_31ck199 = 0.95 time = 1000
* CHECK dout0_0 vdout0_0ck203 = 0 time = 1020
* CHECK dout0_1 vdout0_1ck203 = 0 time = 1020
* CHECK dout0_2 vdout0_2ck203 = 0 time = 1020
* CHECK dout0_3 vdout0_3ck203 = 0 time = 1020
* CHECK dout0_4 vdout0_4ck203 = 0.95 time = 1020
* CHECK dout0_5 vdout0_5ck203 = 0 time = 1020
* CHECK dout0_6 vdout0_6ck203 = 0 time = 1020
* CHECK dout0_7 vdout0_7ck203 = 0.95 time = 1020
* CHECK dout0_8 vdout0_8ck203 = 0.95 time = 1020
* CHECK dout0_9 vdout0_9ck203 = 0 time = 1020
* CHECK dout0_10 vdout0_10ck203 = 0 time = 1020
* CHECK dout0_11 vdout0_11ck203 = 0 time = 1020
* CHECK dout0_12 vdout0_12ck203 = 0.95 time = 1020
* CHECK dout0_13 vdout0_13ck203 = 0 time = 1020
* CHECK dout0_14 vdout0_14ck203 = 0.95 time = 1020
* CHECK dout0_15 vdout0_15ck203 = 0 time = 1020
* CHECK dout0_16 vdout0_16ck203 = 0 time = 1020
* CHECK dout0_17 vdout0_17ck203 = 0 time = 1020
* CHECK dout0_18 vdout0_18ck203 = 0 time = 1020
* CHECK dout0_19 vdout0_19ck203 = 0.95 time = 1020
* CHECK dout0_20 vdout0_20ck203 = 0 time = 1020
* CHECK dout0_21 vdout0_21ck203 = 0 time = 1020
* CHECK dout0_22 vdout0_22ck203 = 0 time = 1020
* CHECK dout0_23 vdout0_23ck203 = 0.95 time = 1020
* CHECK dout0_24 vdout0_24ck203 = 0.95 time = 1020
* CHECK dout0_25 vdout0_25ck203 = 0.95 time = 1020
* CHECK dout0_26 vdout0_26ck203 = 0 time = 1020
* CHECK dout0_27 vdout0_27ck203 = 0.95 time = 1020
* CHECK dout0_28 vdout0_28ck203 = 0 time = 1020
* CHECK dout0_29 vdout0_29ck203 = 0.95 time = 1020
* CHECK dout0_30 vdout0_30ck203 = 0 time = 1020
* CHECK dout0_31 vdout0_31ck203 = 0 time = 1020
* CHECK dout0_0 vdout0_0ck204 = 0.95 time = 1025
* CHECK dout0_1 vdout0_1ck204 = 0 time = 1025
* CHECK dout0_2 vdout0_2ck204 = 0.95 time = 1025
* CHECK dout0_3 vdout0_3ck204 = 0 time = 1025
* CHECK dout0_4 vdout0_4ck204 = 0.95 time = 1025
* CHECK dout0_5 vdout0_5ck204 = 0.95 time = 1025
* CHECK dout0_6 vdout0_6ck204 = 0.95 time = 1025
* CHECK dout0_7 vdout0_7ck204 = 0.95 time = 1025
* CHECK dout0_8 vdout0_8ck204 = 0.95 time = 1025
* CHECK dout0_9 vdout0_9ck204 = 0 time = 1025
* CHECK dout0_10 vdout0_10ck204 = 0 time = 1025
* CHECK dout0_11 vdout0_11ck204 = 0 time = 1025
* CHECK dout0_12 vdout0_12ck204 = 0.95 time = 1025
* CHECK dout0_13 vdout0_13ck204 = 0 time = 1025
* CHECK dout0_14 vdout0_14ck204 = 0 time = 1025
* CHECK dout0_15 vdout0_15ck204 = 0.95 time = 1025
* CHECK dout0_16 vdout0_16ck204 = 0.95 time = 1025
* CHECK dout0_17 vdout0_17ck204 = 0 time = 1025
* CHECK dout0_18 vdout0_18ck204 = 0 time = 1025
* CHECK dout0_19 vdout0_19ck204 = 0.95 time = 1025
* CHECK dout0_20 vdout0_20ck204 = 0.95 time = 1025
* CHECK dout0_21 vdout0_21ck204 = 0.95 time = 1025
* CHECK dout0_22 vdout0_22ck204 = 0.95 time = 1025
* CHECK dout0_23 vdout0_23ck204 = 0.95 time = 1025
* CHECK dout0_24 vdout0_24ck204 = 0.95 time = 1025
* CHECK dout0_25 vdout0_25ck204 = 0 time = 1025
* CHECK dout0_26 vdout0_26ck204 = 0.95 time = 1025
* CHECK dout0_27 vdout0_27ck204 = 0.95 time = 1025
* CHECK dout0_28 vdout0_28ck204 = 0.95 time = 1025
* CHECK dout0_29 vdout0_29ck204 = 0 time = 1025
* CHECK dout0_30 vdout0_30ck204 = 0 time = 1025
* CHECK dout0_31 vdout0_31ck204 = 0 time = 1025
.include /home/Nischal/Projects/OpenRAM/../orion-rv/sram/icache_data_sram_1rw0r0w_32_1024_freepdk45/functional_meas.sp
.OPTIONS DEVICE TEMP=125
.OPTIONS MEASURE MEASFAIL=1
.OPTIONS LINSOL type=klu
.OPTIONS TIMEINT RELTOL=1e-3 ABSTOL=1e-6 method=gear minorder=2
.TRAN 10p 1030n 0n 10p
* probe is used for hspice/xa, while plot is used in ngspice
.end
